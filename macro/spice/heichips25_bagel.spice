* NGSPICE file created from heichips25_bagel.ext - technology: ihp-sg13g2

* Black-box entry subcircuit for sg13g2_fill_2 abstract view
.subckt sg13g2_fill_2 VDD VSS
.ends

* Black-box entry subcircuit for sg13g2_nor3_1 abstract view
.subckt sg13g2_nor3_1 A B C Y VDD VSS
.ends

* Black-box entry subcircuit for sg13g2_nand2_1 abstract view
.subckt sg13g2_nand2_1 Y A B VDD VSS
.ends

* Black-box entry subcircuit for sg13g2_fill_1 abstract view
.subckt sg13g2_fill_1 VDD VSS
.ends

* Black-box entry subcircuit for sg13g2_decap_4 abstract view
.subckt sg13g2_decap_4 VDD VSS
.ends

* Black-box entry subcircuit for sg13g2_a21oi_2 abstract view
.subckt sg13g2_a21oi_2 VSS VDD B1 Y A2 A1
.ends

* Black-box entry subcircuit for sg13g2_mux2_1 abstract view
.subckt sg13g2_mux2_1 A0 A1 S X VDD VSS
.ends

* Black-box entry subcircuit for sg13g2_inv_1 abstract view
.subckt sg13g2_inv_1 VDD Y A VSS
.ends

* Black-box entry subcircuit for sg13g2_buf_8 abstract view
.subckt sg13g2_buf_8 A X VDD VSS
.ends

* Black-box entry subcircuit for sg13g2_decap_8 abstract view
.subckt sg13g2_decap_8 VDD VSS
.ends

* Black-box entry subcircuit for sg13g2_tiehi abstract view
.subckt sg13g2_tiehi VDD VSS L_HI
.ends

* Black-box entry subcircuit for sg13g2_dfrbpq_1 abstract view
.subckt sg13g2_dfrbpq_1 RESET_B VSS VDD D Q CLK
.ends

* Black-box entry subcircuit for sg13g2_nor2_1 abstract view
.subckt sg13g2_nor2_1 A B Y VDD VSS
.ends

* Black-box entry subcircuit for sg13g2_nand2_2 abstract view
.subckt sg13g2_nand2_2 Y A B VDD VSS
.ends

* Black-box entry subcircuit for sg13g2_nand2b_2 abstract view
.subckt sg13g2_nand2b_2 Y B VDD VSS A_N
.ends

* Black-box entry subcircuit for sg13g2_o21ai_1 abstract view
.subckt sg13g2_o21ai_1 B1 VDD Y VSS A1 A2
.ends

* Black-box entry subcircuit for sg13g2_and2_1 abstract view
.subckt sg13g2_and2_1 A B X VDD VSS
.ends

* Black-box entry subcircuit for sg13g2_nand2b_1 abstract view
.subckt sg13g2_nand2b_1 Y B A_N VDD VSS
.ends

* Black-box entry subcircuit for sg13g2_or3_1 abstract view
.subckt sg13g2_or3_1 A B C X VDD VSS
.ends

* Black-box entry subcircuit for sg13g2_dfrbpq_2 abstract view
.subckt sg13g2_dfrbpq_2 RESET_B VSS VDD D Q CLK
.ends

* Black-box entry subcircuit for sg13g2_xor2_1 abstract view
.subckt sg13g2_xor2_1 B A X VDD VSS
.ends

* Black-box entry subcircuit for sg13g2_a21oi_1 abstract view
.subckt sg13g2_a21oi_1 VSS VDD A1 A2 Y B1
.ends

* Black-box entry subcircuit for sg13g2_tielo abstract view
.subckt sg13g2_tielo VDD VSS L_LO
.ends

* Black-box entry subcircuit for sg13g2_a22oi_1 abstract view
.subckt sg13g2_a22oi_1 Y B1 B2 A2 A1 VDD VSS
.ends

* Black-box entry subcircuit for sg13g2_dlygate4sd3_1 abstract view
.subckt sg13g2_dlygate4sd3_1 A VDD VSS X
.ends

* Black-box entry subcircuit for sg13g2_nor2_2 abstract view
.subckt sg13g2_nor2_2 A B Y VDD VSS
.ends

* Black-box entry subcircuit for sg13g2_xnor2_1 abstract view
.subckt sg13g2_xnor2_1 Y A B VDD VSS
.ends

* Black-box entry subcircuit for sg13g2_buf_1 abstract view
.subckt sg13g2_buf_1 A X VDD VSS
.ends

* Black-box entry subcircuit for sg13g2_nand3_1 abstract view
.subckt sg13g2_nand3_1 B C A Y VDD VSS
.ends

* Black-box entry subcircuit for sg13g2_nor2b_1 abstract view
.subckt sg13g2_nor2b_1 A B_N Y VDD VSS
.ends

* Black-box entry subcircuit for sg13g2_buf_2 abstract view
.subckt sg13g2_buf_2 A X VDD VSS
.ends

* Black-box entry subcircuit for sg13g2_or4_1 abstract view
.subckt sg13g2_or4_1 A B C D X VDD VSS
.ends

* Black-box entry subcircuit for sg13g2_a21o_1 abstract view
.subckt sg13g2_a21o_1 A2 A1 B1 X VDD VSS
.ends

* Black-box entry subcircuit for sg13g2_nand4_1 abstract view
.subckt sg13g2_nand4_1 B C A Y VDD VSS D
.ends

* Black-box entry subcircuit for sg13g2_and3_1 abstract view
.subckt sg13g2_and3_1 X A B C VDD VSS
.ends

* Black-box entry subcircuit for sg13g2_nor4_1 abstract view
.subckt sg13g2_nor4_1 A B C D Y VDD VSS
.ends

* Black-box entry subcircuit for sg13g2_nor2b_2 abstract view
.subckt sg13g2_nor2b_2 A B_N Y VDD VSS
.ends

* Black-box entry subcircuit for sg13g2_nand3b_1 abstract view
.subckt sg13g2_nand3b_1 B C Y VDD VSS A_N
.ends

* Black-box entry subcircuit for sg13g2_a21o_2 abstract view
.subckt sg13g2_a21o_2 A2 A1 B1 X VDD VSS
.ends

* Black-box entry subcircuit for sg13g2_and4_1 abstract view
.subckt sg13g2_and4_1 A B C D X VDD VSS
.ends

* Black-box entry subcircuit for sg13g2_or2_1 abstract view
.subckt sg13g2_or2_1 VSS VDD X B A
.ends

* Black-box entry subcircuit for sg13g2_a221oi_1 abstract view
.subckt sg13g2_a221oi_1 VDD VSS B2 C1 B1 A1 Y A2
.ends

* Black-box entry subcircuit for sg13g2_and3_2 abstract view
.subckt sg13g2_and3_2 X A B C VDD VSS
.ends

* Black-box entry subcircuit for sg13g2_nor3_2 abstract view
.subckt sg13g2_nor3_2 A B C Y VDD VSS
.ends

* Black-box entry subcircuit for sg13g2_inv_4 abstract view
.subckt sg13g2_inv_4 A Y VDD VSS
.ends

* Black-box entry subcircuit for sg13g2_inv_2 abstract view
.subckt sg13g2_inv_2 Y A VDD VSS
.ends

* Black-box entry subcircuit for sg13g2_nor4_2 abstract view
.subckt sg13g2_nor4_2 A B C Y VSS VDD D
.ends

.subckt heichips25_bagel VGND VPWR clk ena rst_n tmds_b tmds_clk tmds_g tmds_r ui_in[0]
+ ui_in[1] ui_in[2] ui_in[3] ui_in[4] ui_in[5] ui_in[6] ui_in[7] uio_in[0] uio_in[1]
+ uio_in[2] uio_in[3] uio_in[4] uio_in[5] uio_in[6] uio_in[7] uio_oe[0] uio_oe[1]
+ uio_oe[2] uio_oe[3] uio_oe[4] uio_oe[5] uio_oe[6] uio_oe[7] uio_out[0] uio_out[1]
+ uio_out[2] uio_out[3] uio_out[4] uio_out[5] uio_out[6] uio_out[7] uo_out[0] uo_out[1]
+ uo_out[2] uo_out[3] uo_out[4] uo_out[5] uo_out[6] uo_out[7]
XFILLER_39_255 VPWR VGND sg13g2_fill_2
X_3155_ net769 _0827_ _0874_ _0290_ VPWR VGND sg13g2_nor3_1
X_3086_ net9 _0705_ _0842_ VPWR VGND sg13g2_nand2_1
XFILLER_22_100 VPWR VGND sg13g2_fill_2
XFILLER_23_623 VPWR VGND sg13g2_fill_1
XFILLER_35_461 VPWR VGND sg13g2_decap_4
XFILLER_35_483 VPWR VGND sg13g2_decap_4
XFILLER_35_494 VPWR VGND sg13g2_fill_1
X_3988_ VGND VPWR _1647_ _1648_ _1093_ _1092_ sg13g2_a21oi_2
XFILLER_23_678 VPWR VGND sg13g2_decap_4
X_2939_ videogen.test_lut_thingy.pixel_feeder_inst.row\[5\]\[3\] net783 _0792_ _0459_
+ VPWR VGND sg13g2_mux2_1
X_4609_ VPWR _0644_ net468 VGND sg13g2_inv_1
Xfanout820 net821 net820 VPWR VGND sg13g2_buf_8
XFILLER_19_907 VPWR VGND sg13g2_decap_8
XFILLER_46_715 VPWR VGND sg13g2_decap_8
XFILLER_18_417 VPWR VGND sg13g2_decap_8
X_5197__340 VPWR VGND net340 sg13g2_tiehi
XFILLER_13_144 VPWR VGND sg13g2_fill_1
XFILLER_13_199 VPWR VGND sg13g2_fill_1
XFILLER_9_159 VPWR VGND sg13g2_fill_2
X_5054__355 VPWR VGND net355 sg13g2_tiehi
XFILLER_6_855 VPWR VGND sg13g2_decap_8
X_4917__160 VPWR VGND net160 sg13g2_tiehi
XFILLER_5_387 VPWR VGND sg13g2_decap_4
XFILLER_3_45 VPWR VGND sg13g2_fill_1
XFILLER_1_560 VPWR VGND sg13g2_decap_8
X_5280__210 VPWR VGND net210 sg13g2_tiehi
XFILLER_3_1007 VPWR VGND sg13g2_decap_8
XFILLER_49_586 VPWR VGND sg13g2_decap_8
X_5061__348 VPWR VGND net348 sg13g2_tiehi
XFILLER_36_214 VPWR VGND sg13g2_decap_4
XFILLER_18_951 VPWR VGND sg13g2_fill_1
XFILLER_45_792 VPWR VGND sg13g2_fill_2
X_4960_ net90 VGND VPWR _0314_ videogen.test_lut_thingy.pixel_feeder_inst.v_counter\[3\]
+ net654 sg13g2_dfrbpq_1
XFILLER_17_461 VPWR VGND sg13g2_decap_8
XFILLER_17_472 VPWR VGND sg13g2_fill_2
XFILLER_18_995 VPWR VGND sg13g2_decap_4
X_4891_ net681 net725 _0246_ VPWR VGND sg13g2_nor2_1
X_3911_ _0676_ _1562_ _1573_ _1574_ VPWR VGND sg13g2_nor3_1
XFILLER_17_494 VPWR VGND sg13g2_decap_8
X_3842_ videogen.test_lut_thingy.pixel_feeder_inst.row\[44\]\[1\] net596 _1506_ VPWR
+ VGND sg13g2_nor2_1
X_3773_ videogen.test_lut_thingy.pixel_feeder_inst.row\[1\]\[1\] net568 _1437_ VPWR
+ VGND sg13g2_nor2_1
X_2724_ _0730_ net611 net562 VPWR VGND sg13g2_nand2_2
XFILLER_8_192 VPWR VGND sg13g2_decap_4
X_2655_ VPWR _0674_ videogen.test_lut_thingy.pixel_feeder_inst.v_counter\[3\] VGND
+ sg13g2_inv_1
X_4325_ _1977_ _1973_ VPWR VGND _1955_ sg13g2_nand2b_2
X_4256_ _1743_ VPWR _1913_ VGND _0994_ _1169_ sg13g2_o21ai_1
X_3207_ net646 _0908_ _0910_ VPWR VGND sg13g2_and2_1
X_4187_ VPWR _1844_ _1843_ VGND sg13g2_inv_1
X_3138_ serialize.tmds_parallel_b\[9\] net675 _0268_ VPWR VGND sg13g2_and2_1
XFILLER_43_718 VPWR VGND sg13g2_fill_2
XFILLER_43_707 VPWR VGND sg13g2_decap_8
XFILLER_42_206 VPWR VGND sg13g2_decap_8
X_3069_ videogen.fancy_shader.video_x\[5\] _0830_ _0831_ VPWR VGND sg13g2_and2_1
XFILLER_11_637 VPWR VGND sg13g2_fill_1
XFILLER_3_825 VPWR VGND sg13g2_decap_8
Xfanout650 net651 net650 VPWR VGND sg13g2_buf_8
XFILLER_46_501 VPWR VGND sg13g2_fill_2
Xfanout672 net674 net672 VPWR VGND sg13g2_buf_8
Xfanout661 net669 net661 VPWR VGND sg13g2_buf_8
Xfanout683 net684 net683 VPWR VGND sg13g2_buf_8
Xfanout694 net698 net694 VPWR VGND sg13g2_buf_8
XFILLER_46_589 VPWR VGND sg13g2_decap_8
XFILLER_18_269 VPWR VGND sg13g2_decap_8
XFILLER_42_740 VPWR VGND sg13g2_fill_1
XFILLER_42_762 VPWR VGND sg13g2_fill_1
XFILLER_18_1026 VPWR VGND sg13g2_fill_2
XFILLER_41_283 VPWR VGND sg13g2_fill_2
XFILLER_14_475 VPWR VGND sg13g2_fill_1
X_4954__102 VPWR VGND net102 sg13g2_tiehi
XFILLER_6_663 VPWR VGND sg13g2_fill_1
X_4110_ _1767_ _1764_ _1766_ VPWR VGND sg13g2_nand2b_1
X_5090_ net291 VGND VPWR _0440_ videogen.test_lut_thingy.pixel_feeder_inst.row\[61\]\[0\]
+ _0077_ sg13g2_dfrbpq_1
X_4041_ _1686_ _1691_ _1695_ _1701_ VPWR VGND sg13g2_or3_1
XFILLER_37_523 VPWR VGND sg13g2_decap_4
X_4943_ net122 VGND VPWR _0297_ videogen.fancy_shader.video_x\[9\] net658 sg13g2_dfrbpq_2
XFILLER_24_228 VPWR VGND sg13g2_decap_8
XFILLER_24_239 VPWR VGND sg13g2_fill_1
X_4874_ net695 net739 _0231_ VPWR VGND sg13g2_nor2_1
X_3825_ videogen.test_lut_thingy.pixel_feeder_inst.row\[57\]\[1\] net570 _1489_ VPWR
+ VGND sg13g2_nor2_1
X_3756_ videogen.test_lut_thingy.pixel_feeder_inst.row\[0\]\[2\] net589 _1420_ VPWR
+ VGND sg13g2_nor2_1
X_2707_ videogen.test_lut_thingy.pixel_feeder_inst.row\[21\]\[1\] net804 _0722_ _0664_
+ VPWR VGND sg13g2_mux2_1
X_3687_ videogen.test_lut_thingy.pixel_feeder_inst.row\[37\]\[2\] net574 _1351_ VPWR
+ VGND sg13g2_nor2_1
XFILLER_0_828 VPWR VGND sg13g2_decap_8
X_5288_ net71 VGND VPWR _0638_ serialize.shift_reg_b\[0\] clknet_3_1_0_clk_regs sg13g2_dfrbpq_1
X_4308_ net556 red\[4\] _1960_ VPWR VGND sg13g2_xor2_1
X_4239_ _1891_ _1892_ _1895_ _1896_ VPWR VGND sg13g2_nor3_1
X_5120__231 VPWR VGND net231 sg13g2_tiehi
X_4907__170 VPWR VGND net170 sg13g2_tiehi
XFILLER_24_784 VPWR VGND sg13g2_fill_1
XFILLER_11_434 VPWR VGND sg13g2_decap_8
XFILLER_23_53 VPWR VGND sg13g2_decap_4
X_5231__204 VPWR VGND net204 sg13g2_tiehi
XFILLER_23_97 VPWR VGND sg13g2_fill_1
X_4914__163 VPWR VGND net163 sg13g2_tiehi
XFILLER_2_110 VPWR VGND sg13g2_fill_2
XFILLER_3_699 VPWR VGND sg13g2_decap_8
XFILLER_47_865 VPWR VGND sg13g2_decap_8
XFILLER_0_35 VPWR VGND sg13g2_decap_8
X_5023__405 VPWR VGND net405 sg13g2_tiehi
XFILLER_46_353 VPWR VGND sg13g2_decap_8
XFILLER_34_526 VPWR VGND sg13g2_decap_8
XFILLER_15_773 VPWR VGND sg13g2_decap_8
XFILLER_9_33 VPWR VGND sg13g2_fill_1
X_4590_ VGND VPWR net625 net626 _0619_ _2202_ sg13g2_a21oi_1
X_3610_ videogen.test_lut_thingy.pixel_feeder_inst.row\[39\]\[3\] net586 _1274_ VPWR
+ VGND sg13g2_nor2_1
XFILLER_30_787 VPWR VGND sg13g2_fill_1
XFILLER_31_1023 VPWR VGND sg13g2_fill_2
X_3541_ _1203_ _1204_ _1205_ VPWR VGND sg13g2_and2_1
XFILLER_7_994 VPWR VGND sg13g2_decap_8
X_3472_ _1136_ _1134_ _1135_ VPWR VGND sg13g2_nand2_2
X_5211_ net284 VGND VPWR _0561_ videogen.test_lut_thingy.pixel_feeder_inst.row\[45\]\[1\]
+ _0190_ sg13g2_dfrbpq_1
X_5142_ net187 VGND VPWR _0492_ videogen.test_lut_thingy.pixel_feeder_inst.row\[54\]\[0\]
+ _0129_ sg13g2_dfrbpq_1
X_5073_ net325 VGND VPWR _0423_ videogen.test_lut_thingy.pixel_feeder_inst.row\[9\]\[3\]
+ _0060_ sg13g2_dfrbpq_1
XFILLER_37_320 VPWR VGND sg13g2_decap_4
X_4024_ _1010_ _1630_ _1684_ VPWR VGND sg13g2_nor2_1
XFILLER_25_526 VPWR VGND sg13g2_decap_8
XFILLER_25_559 VPWR VGND sg13g2_decap_8
XFILLER_40_507 VPWR VGND sg13g2_fill_1
X_4926_ net145 VGND VPWR _0280_ videogen.test_lut_thingy.pixel_feeder_inst.row\[1\]\[2\]
+ _0011_ sg13g2_dfrbpq_1
XFILLER_33_570 VPWR VGND sg13g2_decap_4
X_4857_ net715 net759 _0214_ VPWR VGND sg13g2_nor2_1
X_3808_ videogen.test_lut_thingy.pixel_feeder_inst.row\[30\]\[1\] net604 _1472_ VPWR
+ VGND sg13g2_nor2_1
X_4788_ net722 net763 _0145_ VPWR VGND sg13g2_nor2_1
Xheichips25_bagel_24 VPWR VGND uio_oe[3] sg13g2_tielo
X_3739_ net610 VPWR _1403_ VGND videogen.test_lut_thingy.pixel_feeder_inst.row\[8\]\[2\]
+ net589 sg13g2_o21ai_1
XFILLER_0_625 VPWR VGND sg13g2_decap_8
XFILLER_29_810 VPWR VGND sg13g2_fill_2
XFILLER_47_139 VPWR VGND sg13g2_decap_8
XFILLER_43_301 VPWR VGND sg13g2_decap_4
XFILLER_29_887 VPWR VGND sg13g2_decap_8
XFILLER_43_323 VPWR VGND sg13g2_decap_8
XFILLER_34_52 VPWR VGND sg13g2_fill_1
XFILLER_11_220 VPWR VGND sg13g2_fill_1
XFILLER_12_765 VPWR VGND sg13g2_fill_1
XFILLER_4_953 VPWR VGND sg13g2_decap_8
XFILLER_3_441 VPWR VGND sg13g2_fill_1
XFILLER_47_662 VPWR VGND sg13g2_decap_8
XFILLER_46_150 VPWR VGND sg13g2_decap_8
XFILLER_15_581 VPWR VGND sg13g2_fill_1
X_2972_ videogen.test_lut_thingy.pixel_feeder_inst.row\[6\]\[2\] net794 _0800_ _0434_
+ VPWR VGND sg13g2_mux2_1
XFILLER_34_378 VPWR VGND sg13g2_decap_8
X_4711_ net706 net750 _0068_ VPWR VGND sg13g2_nor2_1
XFILLER_15_592 VPWR VGND sg13g2_decap_8
X_4642_ _2236_ net670 net454 net676 red_tmds_par\[7\] VPWR VGND sg13g2_a22oi_1
X_4573_ VGND VPWR _2196_ _2197_ _0612_ net774 sg13g2_a21oi_1
X_5034__386 VPWR VGND net386 sg13g2_tiehi
X_3524_ _1178_ _1179_ _1188_ VPWR VGND sg13g2_nor2_1
X_3455_ VGND VPWR _1095_ _1100_ _1119_ net557 sg13g2_a21oi_1
X_3386_ _1049_ VPWR _1050_ VGND _1027_ _1048_ sg13g2_o21ai_1
X_5125_ net221 VGND VPWR _0475_ videogen.test_lut_thingy.pixel_feeder_inst.row\[57\]\[3\]
+ _0112_ sg13g2_dfrbpq_1
XFILLER_29_117 VPWR VGND sg13g2_decap_4
X_5056_ net353 VGND VPWR _0406_ red_tmds_par\[8\] net664 sg13g2_dfrbpq_1
X_4007_ _1659_ _1666_ _1667_ VPWR VGND sg13g2_and2_1
XFILLER_38_684 VPWR VGND sg13g2_decap_8
XFILLER_34_890 VPWR VGND sg13g2_decap_8
X_4909_ net168 VGND VPWR _0263_ serialize.shift_reg_r\[8\] clknet_3_5_0_clk_regs sg13g2_dfrbpq_1
XFILLER_21_595 VPWR VGND sg13g2_decap_4
XFILLER_0_400 VPWR VGND sg13g2_decap_8
XFILLER_1_945 VPWR VGND sg13g2_decap_8
X_4911__166 VPWR VGND net166 sg13g2_tiehi
Xhold41 serialize.bit_cnt\[2\] VPWR VGND net486 sg13g2_dlygate4sd3_1
XFILLER_0_466 VPWR VGND sg13g2_fill_1
Xhold30 serialize.shift_reg_r\[2\] VPWR VGND net475 sg13g2_dlygate4sd3_1
XFILLER_29_30 VPWR VGND sg13g2_decap_8
XFILLER_0_499 VPWR VGND sg13g2_decap_8
XFILLER_29_662 VPWR VGND sg13g2_decap_8
XFILLER_45_73 VPWR VGND sg13g2_fill_1
XFILLER_44_643 VPWR VGND sg13g2_decap_8
XFILLER_43_142 VPWR VGND sg13g2_decap_4
XFILLER_43_186 VPWR VGND sg13g2_fill_1
XFILLER_40_860 VPWR VGND sg13g2_fill_2
XFILLER_8_533 VPWR VGND sg13g2_decap_4
XFILLER_4_750 VPWR VGND sg13g2_decap_8
X_3240_ VGND VPWR videogen.test_lut_thingy.pixel_feeder_inst.h_counter\[2\] _0929_
+ _0932_ videogen.test_lut_thingy.pixel_feeder_inst.h_counter\[3\] sg13g2_a21oi_1
XFILLER_6_1016 VPWR VGND sg13g2_decap_8
X_3171_ _0882_ videogen.fancy_shader.video_x\[9\] _0884_ VPWR VGND sg13g2_xor2_1
XFILLER_48_960 VPWR VGND sg13g2_decap_8
XFILLER_34_186 VPWR VGND sg13g2_fill_1
X_2955_ videogen.test_lut_thingy.pixel_feeder_inst.row\[11\]\[2\] net787 _0795_ _0446_
+ VPWR VGND sg13g2_mux2_1
X_2886_ _0708_ _0745_ _0780_ VPWR VGND sg13g2_nor2_2
X_4625_ VPWR _0652_ _2227_ VGND sg13g2_inv_1
X_4556_ _2183_ _2180_ _2182_ _2179_ _2127_ VPWR VGND sg13g2_a22oi_1
X_3507_ _1171_ net629 videogen.fancy_shader.video_x\[0\] VPWR VGND sg13g2_xnor2_1
X_4487_ _2121_ _2109_ _2120_ VPWR VGND sg13g2_nand2_1
X_5262__314 VPWR VGND net314 sg13g2_tiehi
X_3438_ _1101_ _1081_ _1102_ VPWR VGND sg13g2_xor2_1
X_3369_ videogen.fancy_shader.video_x\[6\] videogen.fancy_shader.shader_counter_reg\[6\]
+ _1033_ VPWR VGND sg13g2_and2_1
X_5108_ net255 VGND VPWR _0458_ videogen.test_lut_thingy.pixel_feeder_inst.row\[5\]\[2\]
+ _0095_ sg13g2_dfrbpq_1
X_5039_ net376 VGND VPWR _0393_ videogen.test_lut_thingy.pixel_feeder_inst.row\[16\]\[2\]
+ _0039_ sg13g2_dfrbpq_1
XFILLER_14_816 VPWR VGND sg13g2_decap_8
XFILLER_14_827 VPWR VGND sg13g2_fill_2
XFILLER_15_21 VPWR VGND sg13g2_decap_8
XFILLER_25_164 VPWR VGND sg13g2_decap_4
XFILLER_41_668 VPWR VGND sg13g2_decap_8
XFILLER_5_547 VPWR VGND sg13g2_decap_8
XFILLER_31_97 VPWR VGND sg13g2_fill_1
Xoutput20 net20 uo_out[7] VPWR VGND sg13g2_buf_1
Xoutput7 net7 uio_out[0] VPWR VGND sg13g2_buf_1
XFILLER_1_742 VPWR VGND sg13g2_decap_8
XFILLER_49_768 VPWR VGND sg13g2_decap_8
XFILLER_36_407 VPWR VGND sg13g2_fill_1
XFILLER_17_610 VPWR VGND sg13g2_decap_8
XFILLER_17_632 VPWR VGND sg13g2_decap_8
XFILLER_36_429 VPWR VGND sg13g2_fill_2
XFILLER_44_462 VPWR VGND sg13g2_decap_8
XFILLER_32_613 VPWR VGND sg13g2_fill_1
XFILLER_16_186 VPWR VGND sg13g2_fill_1
XFILLER_16_197 VPWR VGND sg13g2_fill_2
X_2740_ videogen.test_lut_thingy.pixel_feeder_inst.row\[29\]\[3\] net782 _0737_ _0611_
+ VPWR VGND sg13g2_mux2_1
XFILLER_9_831 VPWR VGND sg13g2_fill_1
XFILLER_9_853 VPWR VGND sg13g2_fill_2
X_2671_ VPWR _0690_ tmds_red.dc_balancing_reg\[2\] VGND sg13g2_inv_1
XFILLER_8_374 VPWR VGND sg13g2_decap_8
X_4410_ _2053_ net623 _0685_ VPWR VGND sg13g2_nand2_1
X_4341_ _1992_ _1988_ _1990_ VPWR VGND sg13g2_xnor2_1
X_4272_ _1628_ _1734_ _1329_ _1929_ VPWR VGND sg13g2_nand3_1
X_3223_ videogen.test_lut_thingy.pixel_feeder_inst.v_counter\[1\] _0891_ _0921_ VPWR
+ VGND sg13g2_nor2b_1
XFILLER_39_245 VPWR VGND sg13g2_decap_4
X_3154_ videogen.fancy_shader.video_x\[2\] _0826_ _0874_ VPWR VGND sg13g2_nor2_1
X_3085_ net600 net567 net620 _0842_ VPWR VGND sg13g2_nand3_1
XFILLER_23_613 VPWR VGND sg13g2_fill_2
X_3987_ VPWR _1647_ _1646_ VGND sg13g2_inv_1
XFILLER_23_668 VPWR VGND sg13g2_fill_2
X_2938_ _0708_ _0755_ _0792_ VPWR VGND sg13g2_nor2_2
X_2869_ net799 videogen.test_lut_thingy.pixel_feeder_inst.row\[2\]\[1\] _0776_ _0521_
+ VPWR VGND sg13g2_mux2_1
X_4608_ _2219_ net674 net467 net675 serialize.tmds_parallel_b\[6\] VPWR VGND sg13g2_a22oi_1
X_4539_ _2143_ VPWR _2166_ VGND blue\[1\] _2142_ sg13g2_o21ai_1
XFILLER_2_539 VPWR VGND sg13g2_decap_8
X_5227__220 VPWR VGND net220 sg13g2_tiehi
Xfanout821 rst_n net821 VPWR VGND sg13g2_buf_8
Xfanout810 net812 net810 VPWR VGND sg13g2_buf_8
XFILLER_45_226 VPWR VGND sg13g2_decap_8
XFILLER_45_259 VPWR VGND sg13g2_decap_8
XFILLER_26_20 VPWR VGND sg13g2_fill_1
XFILLER_27_941 VPWR VGND sg13g2_fill_1
XFILLER_27_974 VPWR VGND sg13g2_decap_8
XFILLER_13_112 VPWR VGND sg13g2_decap_4
XFILLER_13_123 VPWR VGND sg13g2_decap_4
XFILLER_14_624 VPWR VGND sg13g2_fill_1
XFILLER_42_52 VPWR VGND sg13g2_decap_4
XFILLER_42_41 VPWR VGND sg13g2_fill_1
XFILLER_9_127 VPWR VGND sg13g2_fill_2
X_5019__410 VPWR VGND net410 sg13g2_tiehi
XFILLER_42_96 VPWR VGND sg13g2_fill_1
XFILLER_6_834 VPWR VGND sg13g2_decap_8
XFILLER_5_322 VPWR VGND sg13g2_decap_8
X_5130__211 VPWR VGND net211 sg13g2_tiehi
XFILLER_5_333 VPWR VGND sg13g2_fill_2
X_5206__304 VPWR VGND net304 sg13g2_tiehi
XFILLER_49_565 VPWR VGND sg13g2_decap_8
XFILLER_37_727 VPWR VGND sg13g2_decap_8
XFILLER_17_451 VPWR VGND sg13g2_fill_2
X_3910_ net616 _1567_ _1572_ _1573_ VPWR VGND sg13g2_nor3_1
X_4890_ net682 net726 _0245_ VPWR VGND sg13g2_nor2_1
X_3841_ net647 VPWR _1505_ VGND videogen.test_lut_thingy.pixel_feeder_inst.row\[46\]\[1\]
+ net607 sg13g2_o21ai_1
XFILLER_33_999 VPWR VGND sg13g2_fill_1
X_3772_ videogen.test_lut_thingy.pixel_feeder_inst.row\[0\]\[1\] net589 _1436_ VPWR
+ VGND sg13g2_nor2_1
X_2723_ _0729_ videogen.test_lut_thingy.pixel_feeder_inst.h_pix\[0\] VPWR VGND videogen.test_lut_thingy.pixel_feeder_inst.h_pix\[1\]
+ sg13g2_nand2b_2
XFILLER_9_683 VPWR VGND sg13g2_decap_4
X_2654_ VPWR _0673_ net820 VGND sg13g2_inv_1
X_4324_ _1976_ _1964_ _1975_ VPWR VGND sg13g2_nand2_2
X_4255_ _1912_ _1905_ _1911_ _1902_ _1897_ VPWR VGND sg13g2_a22oi_1
XFILLER_41_1014 VPWR VGND sg13g2_decap_8
X_3206_ _0908_ _0909_ _0306_ VPWR VGND sg13g2_nor2_1
X_4186_ _1843_ net557 _1842_ VPWR VGND sg13g2_xnor2_1
XFILLER_28_716 VPWR VGND sg13g2_decap_8
X_3137_ serialize.tmds_parallel_b\[8\] net675 _0267_ VPWR VGND sg13g2_and2_1
X_5107__257 VPWR VGND net257 sg13g2_tiehi
XFILLER_27_248 VPWR VGND sg13g2_fill_2
X_3068_ videogen.fancy_shader.video_x\[4\] _0828_ _0830_ VPWR VGND sg13g2_and2_1
XFILLER_10_104 VPWR VGND sg13g2_fill_2
XFILLER_11_649 VPWR VGND sg13g2_decap_8
XFILLER_23_487 VPWR VGND sg13g2_fill_2
XFILLER_3_804 VPWR VGND sg13g2_decap_8
XFILLER_2_325 VPWR VGND sg13g2_decap_8
XFILLER_2_369 VPWR VGND sg13g2_decap_8
Xfanout651 net652 net651 VPWR VGND sg13g2_buf_2
Xfanout640 net641 net640 VPWR VGND sg13g2_buf_8
Xfanout673 net674 net673 VPWR VGND sg13g2_buf_1
Xfanout662 net669 net662 VPWR VGND sg13g2_buf_2
Xfanout684 net685 net684 VPWR VGND sg13g2_buf_8
XFILLER_46_524 VPWR VGND sg13g2_decap_8
Xfanout695 net697 net695 VPWR VGND sg13g2_buf_8
XFILLER_46_568 VPWR VGND sg13g2_decap_8
XFILLER_37_85 VPWR VGND sg13g2_decap_8
XFILLER_15_900 VPWR VGND sg13g2_decap_4
XFILLER_33_218 VPWR VGND sg13g2_fill_2
XFILLER_42_796 VPWR VGND sg13g2_fill_1
XFILLER_42_785 VPWR VGND sg13g2_decap_8
XFILLER_6_686 VPWR VGND sg13g2_fill_2
XFILLER_6_675 VPWR VGND sg13g2_decap_8
XFILLER_5_141 VPWR VGND sg13g2_decap_8
XFILLER_2_881 VPWR VGND sg13g2_decap_8
X_4040_ _1700_ _1682_ _1699_ VPWR VGND sg13g2_xnor2_1
XFILLER_49_362 VPWR VGND sg13g2_fill_1
X_4942_ net123 VGND VPWR _0296_ videogen.fancy_shader.video_x\[8\] net654 sg13g2_dfrbpq_2
XFILLER_21_903 VPWR VGND sg13g2_fill_1
X_4873_ net696 net740 _0230_ VPWR VGND sg13g2_nor2_1
XFILLER_33_796 VPWR VGND sg13g2_fill_2
X_3824_ net611 VPWR _1488_ VGND videogen.test_lut_thingy.pixel_feeder_inst.row\[59\]\[1\]
+ net579 sg13g2_o21ai_1
X_3755_ net612 VPWR _1419_ VGND videogen.test_lut_thingy.pixel_feeder_inst.row\[2\]\[2\]
+ net605 sg13g2_o21ai_1
X_2706_ videogen.test_lut_thingy.pixel_feeder_inst.row\[21\]\[2\] net793 _0722_ _0665_
+ VPWR VGND sg13g2_mux2_1
X_3686_ videogen.test_lut_thingy.pixel_feeder_inst.row\[39\]\[2\] net587 _1350_ VPWR
+ VGND sg13g2_nor2_1
XFILLER_0_807 VPWR VGND sg13g2_decap_8
X_5287_ net87 VGND VPWR _0637_ videogen.test_lut_thingy.pixel_feeder_inst.row\[22\]\[3\]
+ _0256_ sg13g2_dfrbpq_1
X_4307_ _1959_ _1939_ net556 VPWR VGND sg13g2_xnor2_1
X_5009__420 VPWR VGND net420 sg13g2_tiehi
X_4238_ _1633_ _1870_ _1875_ _1890_ _1895_ VPWR VGND sg13g2_or4_1
XFILLER_28_502 VPWR VGND sg13g2_fill_1
X_5044__366 VPWR VGND net366 sg13g2_tiehi
XFILLER_28_557 VPWR VGND sg13g2_fill_2
X_4169_ VGND VPWR _1822_ _1825_ _1826_ _1814_ sg13g2_a21oi_1
XFILLER_28_579 VPWR VGND sg13g2_decap_4
XFILLER_12_925 VPWR VGND sg13g2_decap_8
X_5016__413 VPWR VGND net413 sg13g2_tiehi
XFILLER_48_1009 VPWR VGND sg13g2_decap_8
XFILLER_3_634 VPWR VGND sg13g2_fill_2
XFILLER_3_678 VPWR VGND sg13g2_decap_8
XFILLER_47_844 VPWR VGND sg13g2_decap_8
XFILLER_46_332 VPWR VGND sg13g2_fill_2
XFILLER_46_321 VPWR VGND sg13g2_decap_8
XFILLER_0_14 VPWR VGND sg13g2_decap_8
XFILLER_34_505 VPWR VGND sg13g2_fill_1
XFILLER_30_722 VPWR VGND sg13g2_decap_4
XFILLER_14_295 VPWR VGND sg13g2_fill_1
XFILLER_11_980 VPWR VGND sg13g2_decap_8
X_3540_ _1202_ _1192_ _1182_ _1204_ VPWR VGND sg13g2_a21o_1
XFILLER_7_973 VPWR VGND sg13g2_decap_8
X_5210_ net288 VGND VPWR _0560_ videogen.test_lut_thingy.pixel_feeder_inst.row\[45\]\[0\]
+ _0189_ sg13g2_dfrbpq_1
XFILLER_6_494 VPWR VGND sg13g2_decap_8
X_3471_ _1135_ _1032_ _1130_ VPWR VGND sg13g2_nand2_1
XFILLER_9_1014 VPWR VGND sg13g2_decap_8
X_5141_ net189 VGND VPWR _0491_ videogen.test_lut_thingy.pixel_feeder_inst.row\[10\]\[3\]
+ _0128_ sg13g2_dfrbpq_1
X_5072_ net327 VGND VPWR _0422_ videogen.test_lut_thingy.pixel_feeder_inst.row\[9\]\[2\]
+ _0059_ sg13g2_dfrbpq_1
X_4023_ _1683_ _1635_ _1681_ VPWR VGND sg13g2_xnor2_1
XFILLER_38_844 VPWR VGND sg13g2_decap_8
X_4925_ net147 VGND VPWR _0279_ videogen.test_lut_thingy.pixel_feeder_inst.row\[1\]\[1\]
+ _0010_ sg13g2_dfrbpq_1
X_4856_ net717 net759 _0213_ VPWR VGND sg13g2_nor2_1
XFILLER_21_744 VPWR VGND sg13g2_decap_4
X_3807_ videogen.test_lut_thingy.pixel_feeder_inst.row\[28\]\[1\] net594 _1471_ VPWR
+ VGND sg13g2_nor2_1
XFILLER_21_777 VPWR VGND sg13g2_decap_4
X_4787_ net701 net745 _0144_ VPWR VGND sg13g2_nor2_1
XFILLER_20_298 VPWR VGND sg13g2_fill_2
X_3738_ _1389_ _1401_ _1402_ VPWR VGND sg13g2_nor2_1
Xheichips25_bagel_25 VPWR VGND uio_oe[4] sg13g2_tielo
X_3669_ videogen.test_lut_thingy.pixel_feeder_inst.row\[43\]\[2\] net585 _1333_ VPWR
+ VGND sg13g2_nor2_1
XFILLER_0_604 VPWR VGND sg13g2_decap_8
X_5171__69 VPWR VGND net69 sg13g2_tiehi
XFILLER_47_107 VPWR VGND sg13g2_fill_1
XFILLER_29_800 VPWR VGND sg13g2_fill_1
XFILLER_18_21 VPWR VGND sg13g2_decap_4
XFILLER_28_310 VPWR VGND sg13g2_fill_2
XFILLER_18_65 VPWR VGND sg13g2_decap_8
XFILLER_18_76 VPWR VGND sg13g2_fill_1
XFILLER_28_343 VPWR VGND sg13g2_decap_8
XFILLER_28_387 VPWR VGND sg13g2_decap_4
XFILLER_44_869 VPWR VGND sg13g2_decap_8
XFILLER_34_64 VPWR VGND sg13g2_fill_1
XFILLER_34_75 VPWR VGND sg13g2_fill_2
XFILLER_34_86 VPWR VGND sg13g2_decap_4
XFILLER_8_726 VPWR VGND sg13g2_fill_2
XFILLER_7_247 VPWR VGND sg13g2_decap_4
XFILLER_11_287 VPWR VGND sg13g2_decap_8
XFILLER_4_932 VPWR VGND sg13g2_decap_8
XFILLER_3_420 VPWR VGND sg13g2_decap_8
XFILLER_47_641 VPWR VGND sg13g2_decap_8
XFILLER_43_880 VPWR VGND sg13g2_fill_1
X_2971_ videogen.test_lut_thingy.pixel_feeder_inst.row\[6\]\[3\] net783 _0800_ _0435_
+ VPWR VGND sg13g2_mux2_1
X_4710_ net687 net731 _0067_ VPWR VGND sg13g2_nor2_1
X_4976__58 VPWR VGND net58 sg13g2_tiehi
X_4641_ VPWR _0660_ _2235_ VGND sg13g2_inv_1
XFILLER_30_563 VPWR VGND sg13g2_fill_1
X_4572_ _2128_ _2130_ net626 _2197_ VPWR VGND sg13g2_nand3_1
X_3523_ _1184_ _1183_ _1181_ _1187_ VPWR VGND sg13g2_a21o_1
X_3454_ _1116_ _1114_ _1118_ VPWR VGND sg13g2_xor2_1
XFILLER_41_0 VPWR VGND sg13g2_decap_8
X_3385_ _1049_ videogen.fancy_shader.video_y\[5\] net630 VPWR VGND sg13g2_nand2_1
X_5124_ net223 VGND VPWR _0474_ videogen.test_lut_thingy.pixel_feeder_inst.row\[57\]\[2\]
+ _0111_ sg13g2_dfrbpq_1
X_5055_ net354 VGND VPWR _0405_ red_tmds_par\[6\] net665 sg13g2_dfrbpq_1
XFILLER_38_663 VPWR VGND sg13g2_decap_8
X_4006_ _1665_ VPWR _1666_ VGND _1660_ _1662_ sg13g2_o21ai_1
X_5006__423 VPWR VGND net423 sg13g2_tiehi
XFILLER_13_519 VPWR VGND sg13g2_fill_1
X_4908_ net169 VGND VPWR net760 clockdiv.q2temp net445 sg13g2_dfrbpq_1
X_4991__442 VPWR VGND net442 sg13g2_tiehi
X_4839_ net714 net758 _0196_ VPWR VGND sg13g2_nor2_1
X_5013__416 VPWR VGND net416 sg13g2_tiehi
Xclkbuf_3_7_0_clk_regs clknet_0_clk_regs clknet_3_7_0_clk_regs VPWR VGND sg13g2_buf_8
XFILLER_1_924 VPWR VGND sg13g2_decap_8
XFILLER_29_20 VPWR VGND sg13g2_decap_4
Xhold31 serialize.shift_reg_g\[4\] VPWR VGND net476 sg13g2_dlygate4sd3_1
XFILLER_0_478 VPWR VGND sg13g2_decap_8
Xhold20 serialize.shift_reg_g\[2\] VPWR VGND net465 sg13g2_dlygate4sd3_1
XFILLER_29_75 VPWR VGND sg13g2_fill_2
XFILLER_44_622 VPWR VGND sg13g2_decap_8
XFILLER_17_869 VPWR VGND sg13g2_decap_8
X_5020__409 VPWR VGND net409 sg13g2_tiehi
XFILLER_28_195 VPWR VGND sg13g2_decap_8
XFILLER_24_390 VPWR VGND sg13g2_decap_8
X_3170_ _0873_ _0883_ _0296_ VPWR VGND sg13g2_nor2_1
XFILLER_13_4 VPWR VGND sg13g2_decap_4
XFILLER_35_644 VPWR VGND sg13g2_decap_4
XFILLER_34_198 VPWR VGND sg13g2_decap_8
X_2954_ videogen.test_lut_thingy.pixel_feeder_inst.row\[11\]\[3\] net776 _0795_ _0447_
+ VPWR VGND sg13g2_mux2_1
X_2885_ videogen.test_lut_thingy.pixel_feeder_inst.row\[51\]\[0\] net810 _0779_ _0500_
+ VPWR VGND sg13g2_mux2_1
X_5071__329 VPWR VGND net329 sg13g2_tiehi
X_4624_ _2227_ net670 net456 net676 green_tmds_par\[6\] VPWR VGND sg13g2_a22oi_1
X_4555_ _2127_ _2181_ _2182_ VPWR VGND sg13g2_nor2_1
X_3506_ videogen.fancy_shader.shader_counter_reg\[0\] net629 _1170_ VPWR VGND sg13g2_xor2_1
X_4486_ _2120_ _2117_ _2119_ VPWR VGND sg13g2_xnor2_1
X_3437_ VGND VPWR _1046_ _1055_ _1101_ _1045_ sg13g2_a21oi_1
X_3368_ _1030_ _1031_ _1032_ VPWR VGND sg13g2_and2_1
X_5107_ net257 VGND VPWR _0457_ videogen.test_lut_thingy.pixel_feeder_inst.row\[5\]\[1\]
+ _0094_ sg13g2_dfrbpq_1
XFILLER_39_961 VPWR VGND sg13g2_fill_2
X_3299_ _0844_ _0845_ videogen.fancy_shader.video_y\[4\] _0974_ VPWR VGND _0872_ sg13g2_nand4_1
X_5038_ net378 VGND VPWR _0392_ videogen.test_lut_thingy.pixel_feeder_inst.row\[16\]\[1\]
+ _0038_ sg13g2_dfrbpq_1
XFILLER_26_622 VPWR VGND sg13g2_decap_4
XFILLER_26_655 VPWR VGND sg13g2_fill_2
XFILLER_41_647 VPWR VGND sg13g2_decap_8
XFILLER_25_198 VPWR VGND sg13g2_decap_8
X_5117__237 VPWR VGND net237 sg13g2_tiehi
XFILLER_21_393 VPWR VGND sg13g2_fill_1
XFILLER_5_526 VPWR VGND sg13g2_decap_8
XFILLER_31_76 VPWR VGND sg13g2_fill_2
Xoutput8 net8 uio_out[2] VPWR VGND sg13g2_buf_1
Xoutput10 net10 uio_out[4] VPWR VGND sg13g2_buf_1
XFILLER_1_721 VPWR VGND sg13g2_decap_8
XFILLER_49_747 VPWR VGND sg13g2_decap_8
XFILLER_1_798 VPWR VGND sg13g2_decap_8
XFILLER_48_268 VPWR VGND sg13g2_fill_1
XFILLER_45_975 VPWR VGND sg13g2_decap_8
XFILLER_32_636 VPWR VGND sg13g2_decap_8
XFILLER_9_810 VPWR VGND sg13g2_decap_8
XFILLER_31_179 VPWR VGND sg13g2_decap_8
X_2670_ VPWR _0689_ videogen.fancy_shader.shader_counter_reg\[6\] VGND sg13g2_inv_1
X_4340_ _1988_ _1990_ _1991_ VPWR VGND sg13g2_nor2b_1
XFILLER_4_592 VPWR VGND sg13g2_decap_8
X_4271_ _1428_ _1525_ _1928_ VPWR VGND sg13g2_nor2_1
X_3222_ _0920_ _0674_ _0889_ _0919_ VPWR VGND sg13g2_and3_1
X_3153_ _0699_ _0826_ _0873_ _0289_ VPWR VGND sg13g2_nor3_1
XFILLER_39_257 VPWR VGND sg13g2_fill_1
XFILLER_27_408 VPWR VGND sg13g2_decap_4
X_3084_ VGND VPWR _0681_ net8 _0701_ net648 sg13g2_a21oi_2
XFILLER_36_942 VPWR VGND sg13g2_decap_8
X_5003__426 VPWR VGND net426 sg13g2_tiehi
XFILLER_22_102 VPWR VGND sg13g2_fill_1
XFILLER_23_647 VPWR VGND sg13g2_decap_8
XFILLER_11_809 VPWR VGND sg13g2_decap_8
X_3986_ _1082_ _1098_ _1053_ _1646_ VPWR VGND _1634_ sg13g2_nand4_1
XFILLER_22_135 VPWR VGND sg13g2_decap_8
XFILLER_10_319 VPWR VGND sg13g2_decap_4
X_2937_ net808 videogen.test_lut_thingy.pixel_feeder_inst.row\[8\]\[0\] _0791_ _0460_
+ VPWR VGND sg13g2_mux2_1
X_4607_ VPWR _0643_ net478 VGND sg13g2_inv_1
XFILLER_11_1022 VPWR VGND sg13g2_decap_8
X_2868_ net793 videogen.test_lut_thingy.pixel_feeder_inst.row\[2\]\[2\] _0776_ _0522_
+ VPWR VGND sg13g2_mux2_1
X_2799_ videogen.test_lut_thingy.pixel_feeder_inst.row\[42\]\[0\] net816 _0761_ _0576_
+ VPWR VGND sg13g2_mux2_1
X_4538_ _2165_ tmds_blue.dc_balancing_reg\[3\] _2142_ VPWR VGND sg13g2_xnor2_1
XFILLER_2_518 VPWR VGND sg13g2_decap_8
X_5010__419 VPWR VGND net419 sg13g2_tiehi
Xfanout800 net801 net800 VPWR VGND sg13g2_buf_8
X_4469_ _2102_ _2090_ _2104_ VPWR VGND sg13g2_nor2b_1
Xfanout811 net812 net811 VPWR VGND sg13g2_buf_8
XFILLER_45_238 VPWR VGND sg13g2_decap_8
XFILLER_38_290 VPWR VGND sg13g2_decap_8
XFILLER_27_953 VPWR VGND sg13g2_fill_2
XFILLER_26_474 VPWR VGND sg13g2_decap_8
XFILLER_41_466 VPWR VGND sg13g2_fill_2
XFILLER_41_488 VPWR VGND sg13g2_fill_1
XFILLER_9_117 VPWR VGND sg13g2_fill_2
XFILLER_13_179 VPWR VGND sg13g2_decap_8
XFILLER_6_813 VPWR VGND sg13g2_decap_8
XFILLER_3_58 VPWR VGND sg13g2_decap_8
XFILLER_1_595 VPWR VGND sg13g2_decap_8
XFILLER_49_544 VPWR VGND sg13g2_decap_8
XFILLER_45_794 VPWR VGND sg13g2_fill_1
X_3840_ _1500_ _1501_ _1502_ _1503_ _1504_ VPWR VGND sg13g2_nor4_1
XFILLER_32_444 VPWR VGND sg13g2_fill_1
X_3771_ net615 VPWR _1435_ VGND videogen.test_lut_thingy.pixel_feeder_inst.row\[3\]\[1\]
+ net582 sg13g2_o21ai_1
XFILLER_12_190 VPWR VGND sg13g2_decap_8
X_2722_ videogen.test_lut_thingy.pixel_feeder_inst.h_pix\[1\] net648 _0728_ VPWR VGND
+ sg13g2_nor2b_2
X_2653_ VPWR _0672_ videogen.fancy_shader.video_y\[8\] VGND sg13g2_inv_1
X_4931__137 VPWR VGND net137 sg13g2_tiehi
X_4323_ _1975_ _1959_ _1972_ VPWR VGND sg13g2_xnor2_1
X_4254_ _1894_ _1900_ _1911_ VPWR VGND _1909_ sg13g2_nand3b_1
X_3205_ _0837_ VPWR _0909_ VGND videogen.test_lut_thingy.pixel_feeder_inst.h_pix\[1\]
+ _0906_ sg13g2_o21ai_1
X_4185_ _1842_ _1748_ _1833_ VPWR VGND sg13g2_xnor2_1
X_3136_ green_tmds_par\[9\] net677 _0266_ VPWR VGND sg13g2_and2_1
X_3067_ _0829_ videogen.fancy_shader.video_x\[3\] _0827_ VPWR VGND sg13g2_nand2_1
X_5300__359 VPWR VGND net359 sg13g2_tiehi
XFILLER_24_912 VPWR VGND sg13g2_decap_8
X_3969_ VGND VPWR _1233_ _1629_ _0358_ net775 sg13g2_a21oi_1
XFILLER_12_34 VPWR VGND sg13g2_decap_8
XFILLER_12_56 VPWR VGND sg13g2_fill_2
Xfanout630 videogen.fancy_shader.shader_counter_reg\[5\] net630 VPWR VGND sg13g2_buf_2
Xfanout641 net642 net641 VPWR VGND sg13g2_buf_8
Xfanout663 net668 net663 VPWR VGND sg13g2_buf_8
Xfanout652 net653 net652 VPWR VGND sg13g2_buf_1
Xfanout685 net691 net685 VPWR VGND sg13g2_buf_8
Xfanout674 _0868_ net674 VPWR VGND sg13g2_buf_8
Xfanout696 net697 net696 VPWR VGND sg13g2_buf_2
XFILLER_46_503 VPWR VGND sg13g2_fill_1
XFILLER_18_216 VPWR VGND sg13g2_fill_2
XFILLER_46_547 VPWR VGND sg13g2_decap_8
XFILLER_37_64 VPWR VGND sg13g2_fill_1
XFILLER_27_772 VPWR VGND sg13g2_decap_8
XFILLER_18_1028 VPWR VGND sg13g2_fill_1
XFILLER_41_252 VPWR VGND sg13g2_fill_1
XFILLER_14_499 VPWR VGND sg13g2_decap_8
XFILLER_41_285 VPWR VGND sg13g2_fill_1
XFILLER_10_672 VPWR VGND sg13g2_decap_8
XFILLER_5_153 VPWR VGND sg13g2_decap_4
XFILLER_45_7 VPWR VGND sg13g2_fill_1
XFILLER_2_860 VPWR VGND sg13g2_decap_8
XFILLER_49_341 VPWR VGND sg13g2_decap_8
XFILLER_49_374 VPWR VGND sg13g2_decap_8
XFILLER_37_558 VPWR VGND sg13g2_decap_8
X_4941_ net124 VGND VPWR _0295_ videogen.fancy_shader.video_x\[7\] net654 sg13g2_dfrbpq_1
XFILLER_17_282 VPWR VGND sg13g2_fill_1
XFILLER_18_783 VPWR VGND sg13g2_decap_4
X_4872_ net695 net739 _0229_ VPWR VGND sg13g2_nor2_1
X_5000__429 VPWR VGND net429 sg13g2_tiehi
X_3823_ net639 _1481_ _1486_ _1487_ VPWR VGND sg13g2_nor3_1
XFILLER_21_926 VPWR VGND sg13g2_decap_8
XFILLER_32_285 VPWR VGND sg13g2_decap_8
XFILLER_32_296 VPWR VGND sg13g2_fill_2
XFILLER_9_470 VPWR VGND sg13g2_decap_8
X_3754_ _1414_ _1415_ _1416_ _1417_ _1418_ VPWR VGND sg13g2_nor4_1
X_2705_ videogen.test_lut_thingy.pixel_feeder_inst.row\[21\]\[3\] net783 _0722_ _0666_
+ VPWR VGND sg13g2_mux2_1
X_3685_ videogen.test_lut_thingy.pixel_feeder_inst.row\[36\]\[2\] net597 _1349_ VPWR
+ VGND sg13g2_nor2_1
X_5286_ net119 VGND VPWR _0636_ videogen.test_lut_thingy.pixel_feeder_inst.row\[22\]\[2\]
+ _0255_ sg13g2_dfrbpq_1
X_4306_ _1954_ _1957_ _1958_ VPWR VGND sg13g2_and2_1
X_4237_ VPWR _1894_ _1893_ VGND sg13g2_inv_1
X_4168_ _1825_ _1808_ _1812_ VPWR VGND sg13g2_xnor2_1
XFILLER_43_517 VPWR VGND sg13g2_fill_2
X_3119_ _0852_ _0865_ net7 VPWR VGND sg13g2_nor2_1
X_4099_ _1756_ _1749_ _1755_ VPWR VGND sg13g2_nand2_1
XFILLER_12_904 VPWR VGND sg13g2_fill_1
XFILLER_23_230 VPWR VGND sg13g2_fill_1
XFILLER_23_285 VPWR VGND sg13g2_decap_4
XFILLER_2_123 VPWR VGND sg13g2_decap_8
XFILLER_2_145 VPWR VGND sg13g2_fill_2
XFILLER_47_823 VPWR VGND sg13g2_decap_8
XFILLER_19_558 VPWR VGND sg13g2_decap_4
XFILLER_34_517 VPWR VGND sg13g2_fill_1
X_4988__34 VPWR VGND net34 sg13g2_tiehi
XFILLER_7_952 VPWR VGND sg13g2_decap_8
XFILLER_10_480 VPWR VGND sg13g2_decap_8
X_3470_ _1133_ _1130_ _1032_ _1134_ VPWR VGND sg13g2_a21o_2
X_5140_ net191 VGND VPWR _0490_ videogen.test_lut_thingy.pixel_feeder_inst.row\[10\]\[2\]
+ _0127_ sg13g2_dfrbpq_1
X_5071_ net329 VGND VPWR _0421_ videogen.test_lut_thingy.pixel_feeder_inst.row\[9\]\[1\]
+ _0058_ sg13g2_dfrbpq_1
X_4022_ _1681_ _1635_ _1682_ VPWR VGND sg13g2_xor2_1
XFILLER_18_580 VPWR VGND sg13g2_decap_8
XFILLER_18_591 VPWR VGND sg13g2_fill_2
X_4924_ net149 VGND VPWR _0278_ videogen.test_lut_thingy.pixel_feeder_inst.row\[1\]\[0\]
+ _0009_ sg13g2_dfrbpq_1
XFILLER_33_550 VPWR VGND sg13g2_fill_2
X_4855_ net715 net761 _0212_ VPWR VGND sg13g2_nor2_1
XFILLER_20_211 VPWR VGND sg13g2_decap_4
X_4786_ net702 net746 _0143_ VPWR VGND sg13g2_nor2_1
X_3806_ videogen.test_lut_thingy.pixel_feeder_inst.row\[31\]\[1\] net583 _1470_ VPWR
+ VGND sg13g2_nor2_1
X_3737_ net636 VPWR _1401_ VGND _1394_ _1400_ sg13g2_o21ai_1
X_3668_ net642 VPWR _1332_ VGND videogen.test_lut_thingy.pixel_feeder_inst.row\[40\]\[2\]
+ net596 sg13g2_o21ai_1
Xheichips25_bagel_26 VPWR VGND uio_oe[5] sg13g2_tielo
X_3599_ videogen.test_lut_thingy.pixel_feeder_inst.row\[42\]\[3\] net607 _1263_ VPWR
+ VGND sg13g2_nor2_1
X_5265__302 VPWR VGND net302 sg13g2_tiehi
X_5269_ net286 VGND VPWR _0619_ serialize.tmds_parallel_b\[8\] net668 sg13g2_dfrbpq_1
X_5081__309 VPWR VGND net309 sg13g2_tiehi
XFILLER_18_44 VPWR VGND sg13g2_decap_8
XFILLER_44_848 VPWR VGND sg13g2_decap_8
XFILLER_11_211 VPWR VGND sg13g2_decap_8
XFILLER_12_745 VPWR VGND sg13g2_decap_4
XFILLER_12_756 VPWR VGND sg13g2_decap_8
XFILLER_24_583 VPWR VGND sg13g2_fill_1
XFILLER_4_911 VPWR VGND sg13g2_decap_8
XFILLER_4_988 VPWR VGND sg13g2_decap_8
XFILLER_1_0 VPWR VGND sg13g2_decap_8
X_5127__217 VPWR VGND net217 sg13g2_tiehi
XFILLER_47_620 VPWR VGND sg13g2_decap_8
XFILLER_15_8 VPWR VGND sg13g2_decap_8
XFILLER_47_697 VPWR VGND sg13g2_decap_8
XFILLER_46_174 VPWR VGND sg13g2_decap_8
XFILLER_19_388 VPWR VGND sg13g2_decap_8
XFILLER_34_314 VPWR VGND sg13g2_decap_8
XFILLER_35_848 VPWR VGND sg13g2_fill_1
XFILLER_46_196 VPWR VGND sg13g2_fill_2
X_2970_ _0724_ _0755_ _0800_ VPWR VGND sg13g2_nor2_2
X_4640_ _2235_ net670 net463 net676 red_tmds_par\[6\] VPWR VGND sg13g2_a22oi_1
X_4571_ _2196_ hsync net626 VPWR VGND sg13g2_nand2b_1
XFILLER_7_782 VPWR VGND sg13g2_decap_8
X_3522_ VGND VPWR _1183_ _1184_ _1186_ _1181_ sg13g2_a21oi_1
X_3453_ _1117_ _1114_ _1116_ VPWR VGND sg13g2_xnor2_1
X_3384_ videogen.fancy_shader.video_y\[5\] net630 _1048_ VPWR VGND sg13g2_nor2_1
X_5123_ net225 VGND VPWR _0473_ videogen.test_lut_thingy.pixel_feeder_inst.row\[57\]\[1\]
+ _0110_ sg13g2_dfrbpq_1
XFILLER_34_0 VPWR VGND sg13g2_fill_2
X_5054_ net355 VGND VPWR _0404_ red_tmds_par\[4\] net662 sg13g2_dfrbpq_1
XFILLER_38_642 VPWR VGND sg13g2_decap_8
X_4005_ _1665_ _1652_ _1641_ VPWR VGND sg13g2_nand2b_1
XFILLER_41_829 VPWR VGND sg13g2_fill_2
XFILLER_41_818 VPWR VGND sg13g2_decap_8
X_4907_ net170 VGND VPWR _0262_ clockdiv.q2 clknet_3_4_0_clk_regs sg13g2_dfrbpq_1
X_4838_ net723 net767 _0195_ VPWR VGND sg13g2_nor2_1
XFILLER_5_719 VPWR VGND sg13g2_decap_8
X_4769_ net683 net727 _0126_ VPWR VGND sg13g2_nor2_1
XFILLER_1_903 VPWR VGND sg13g2_decap_8
XFILLER_20_67 VPWR VGND sg13g2_decap_8
XFILLER_49_929 VPWR VGND sg13g2_decap_8
Xhold21 serialize.shift_reg_b\[5\] VPWR VGND net466 sg13g2_dlygate4sd3_1
Xhold32 serialize.shift_reg_b\[7\] VPWR VGND net477 sg13g2_dlygate4sd3_1
XFILLER_0_457 VPWR VGND sg13g2_decap_8
Xhold10 serialize.shift_reg_r\[6\] VPWR VGND net455 sg13g2_dlygate4sd3_1
XFILLER_21_1002 VPWR VGND sg13g2_decap_8
XFILLER_21_1013 VPWR VGND sg13g2_decap_8
XFILLER_29_98 VPWR VGND sg13g2_fill_1
XFILLER_45_31 VPWR VGND sg13g2_decap_8
XFILLER_44_601 VPWR VGND sg13g2_decap_8
XFILLER_17_848 VPWR VGND sg13g2_decap_8
XFILLER_44_678 VPWR VGND sg13g2_decap_8
XFILLER_43_155 VPWR VGND sg13g2_fill_2
XFILLER_25_881 VPWR VGND sg13g2_decap_8
XFILLER_8_568 VPWR VGND sg13g2_fill_2
XFILLER_4_785 VPWR VGND sg13g2_decap_8
XFILLER_3_295 VPWR VGND sg13g2_decap_8
X_5289__63 VPWR VGND net63 sg13g2_tiehi
XFILLER_48_995 VPWR VGND sg13g2_decap_8
XFILLER_47_494 VPWR VGND sg13g2_decap_8
XFILLER_23_807 VPWR VGND sg13g2_decap_8
XFILLER_23_818 VPWR VGND sg13g2_fill_1
XFILLER_35_689 VPWR VGND sg13g2_decap_8
X_2953_ _0747_ _0783_ _0795_ VPWR VGND sg13g2_nor2_2
X_2884_ videogen.test_lut_thingy.pixel_feeder_inst.row\[51\]\[1\] net801 _0779_ _0501_
+ VPWR VGND sg13g2_mux2_1
XFILLER_30_383 VPWR VGND sg13g2_decap_4
X_4623_ VPWR _0651_ _2226_ VGND sg13g2_inv_1
X_4554_ _2157_ _2174_ _2181_ VPWR VGND sg13g2_nor2_1
X_3505_ videogen.fancy_shader.video_x\[0\] net633 _1169_ VPWR VGND sg13g2_xor2_1
X_4485_ _2119_ tmds_green.dc_balancing_reg\[4\] _2118_ VPWR VGND sg13g2_xnor2_1
X_3436_ VPWR _1100_ _1099_ VGND sg13g2_inv_1
X_3367_ _1031_ _1029_ _1021_ VPWR VGND sg13g2_nand2b_1
X_5106_ net259 VGND VPWR _0456_ videogen.test_lut_thingy.pixel_feeder_inst.row\[5\]\[0\]
+ _0093_ sg13g2_dfrbpq_1
X_3298_ videogen.fancy_shader.video_y\[4\] _0972_ _0973_ VPWR VGND sg13g2_nor2_1
X_5037_ net380 VGND VPWR _0391_ videogen.test_lut_thingy.pixel_feeder_inst.row\[16\]\[0\]
+ _0037_ sg13g2_dfrbpq_1
XFILLER_39_984 VPWR VGND sg13g2_fill_1
XFILLER_38_483 VPWR VGND sg13g2_decap_8
XFILLER_41_626 VPWR VGND sg13g2_decap_8
XFILLER_22_873 VPWR VGND sg13g2_decap_4
X_4963__84 VPWR VGND net84 sg13g2_tiehi
XFILLER_1_700 VPWR VGND sg13g2_decap_8
Xoutput9 net9 uio_out[3] VPWR VGND sg13g2_buf_1
Xoutput11 net11 uio_out[6] VPWR VGND sg13g2_buf_1
XFILLER_1_777 VPWR VGND sg13g2_decap_8
X_5308__246 VPWR VGND net246 sg13g2_tiehi
XFILLER_49_726 VPWR VGND sg13g2_decap_8
XFILLER_48_258 VPWR VGND sg13g2_fill_2
XFILLER_45_921 VPWR VGND sg13g2_decap_8
XFILLER_45_954 VPWR VGND sg13g2_decap_8
XFILLER_17_645 VPWR VGND sg13g2_decap_8
XFILLER_16_177 VPWR VGND sg13g2_fill_1
XFILLER_16_199 VPWR VGND sg13g2_fill_1
XFILLER_12_350 VPWR VGND sg13g2_decap_8
XFILLER_12_394 VPWR VGND sg13g2_fill_2
X_4270_ _1824_ _1918_ _1921_ _1926_ _1927_ VPWR VGND sg13g2_and4_1
X_3221_ _0919_ videogen.test_lut_thingy.pixel_feeder_inst.v_counter\[1\] videogen.test_lut_thingy.pixel_feeder_inst.v_counter\[0\]
+ VPWR VGND sg13g2_nand2_1
X_3152_ videogen.fancy_shader.video_x\[0\] _0873_ _0288_ VPWR VGND sg13g2_nor2_1
X_3083_ _0823_ _0820_ net621 videogen.mem_row VPWR VGND sg13g2_a21o_2
XFILLER_48_792 VPWR VGND sg13g2_decap_8
XFILLER_47_280 VPWR VGND sg13g2_fill_1
XFILLER_36_987 VPWR VGND sg13g2_decap_4
XFILLER_23_604 VPWR VGND sg13g2_fill_2
XFILLER_22_114 VPWR VGND sg13g2_decap_8
X_3985_ _1091_ _1098_ _1090_ _1645_ VPWR VGND _1639_ sg13g2_nand4_1
X_2936_ net798 videogen.test_lut_thingy.pixel_feeder_inst.row\[8\]\[1\] _0791_ _0461_
+ VPWR VGND sg13g2_mux2_1
X_2867_ net777 videogen.test_lut_thingy.pixel_feeder_inst.row\[2\]\[3\] _0776_ _0523_
+ VPWR VGND sg13g2_mux2_1
X_4606_ _2218_ net674 net477 net675 serialize.tmds_parallel_b\[5\] VPWR VGND sg13g2_a22oi_1
XFILLER_11_1001 VPWR VGND sg13g2_decap_8
X_2798_ videogen.test_lut_thingy.pixel_feeder_inst.row\[42\]\[1\] net806 _0761_ _0577_
+ VPWR VGND sg13g2_mux2_1
X_4537_ VGND VPWR _2164_ _2142_ tmds_blue.dc_balancing_reg\[3\] sg13g2_or2_1
X_4468_ _2103_ _2102_ _2090_ VPWR VGND sg13g2_nand2b_1
X_3419_ VPWR VGND _1050_ _1079_ _1082_ _1045_ _1083_ _1080_ sg13g2_a221oi_1
Xfanout801 net802 net801 VPWR VGND sg13g2_buf_8
Xfanout812 ui_in[4] net812 VPWR VGND sg13g2_buf_8
X_4399_ _1982_ _2030_ _2047_ VPWR VGND sg13g2_nor2_2
XFILLER_46_729 VPWR VGND sg13g2_decap_8
XFILLER_39_781 VPWR VGND sg13g2_fill_1
XFILLER_39_770 VPWR VGND sg13g2_decap_8
XFILLER_26_11 VPWR VGND sg13g2_decap_8
XFILLER_26_33 VPWR VGND sg13g2_decap_8
XFILLER_26_66 VPWR VGND sg13g2_decap_8
XFILLER_26_442 VPWR VGND sg13g2_fill_2
XFILLER_41_423 VPWR VGND sg13g2_fill_1
XFILLER_41_412 VPWR VGND sg13g2_fill_2
XFILLER_41_401 VPWR VGND sg13g2_decap_8
XFILLER_14_648 VPWR VGND sg13g2_fill_1
XFILLER_13_158 VPWR VGND sg13g2_decap_4
XFILLER_5_302 VPWR VGND sg13g2_fill_2
XFILLER_6_869 VPWR VGND sg13g2_decap_8
XFILLER_3_15 VPWR VGND sg13g2_fill_2
X_5030__391 VPWR VGND net391 sg13g2_tiehi
XFILLER_49_523 VPWR VGND sg13g2_decap_8
XFILLER_1_574 VPWR VGND sg13g2_decap_8
XFILLER_17_431 VPWR VGND sg13g2_fill_2
XFILLER_45_751 VPWR VGND sg13g2_decap_8
XFILLER_17_442 VPWR VGND sg13g2_decap_4
XFILLER_44_283 VPWR VGND sg13g2_decap_8
XFILLER_33_946 VPWR VGND sg13g2_decap_8
X_3770_ _1430_ _1431_ _1432_ _1433_ _1434_ VPWR VGND sg13g2_nor4_1
XFILLER_20_629 VPWR VGND sg13g2_fill_1
X_2721_ videogen.test_lut_thingy.pixel_feeder_inst.row\[23\]\[0\] net814 _0727_ _0630_
+ VPWR VGND sg13g2_mux2_1
XFILLER_9_674 VPWR VGND sg13g2_fill_1
X_2652_ VPWR _0671_ videogen.test_lut_thingy.pixel_feeder_inst.row\[62\]\[3\] VGND
+ sg13g2_inv_1
XFILLER_5_880 VPWR VGND sg13g2_decap_8
X_4322_ VPWR VGND _1971_ _1973_ _1967_ red\[0\] _1974_ _1943_ sg13g2_a221oi_1
X_4253_ _1899_ _1909_ _1910_ VPWR VGND sg13g2_nor2_1
X_3204_ net584 _0903_ _0904_ _0908_ VPWR VGND sg13g2_nor3_1
X_4184_ _1841_ _1059_ _1840_ VPWR VGND sg13g2_xnor2_1
X_3135_ green_tmds_par\[8\] net676 _0265_ VPWR VGND sg13g2_and2_1
X_3066_ videogen.fancy_shader.video_x\[3\] _0827_ _0828_ VPWR VGND sg13g2_and2_1
XFILLER_27_228 VPWR VGND sg13g2_fill_2
XFILLER_24_924 VPWR VGND sg13g2_decap_4
XFILLER_24_979 VPWR VGND sg13g2_decap_8
X_3968_ _1629_ _1331_ _1628_ VPWR VGND sg13g2_nand2_1
XFILLER_10_117 VPWR VGND sg13g2_fill_2
X_2919_ net779 videogen.test_lut_thingy.pixel_feeder_inst.row\[57\]\[3\] _0788_ _0475_
+ VPWR VGND sg13g2_mux2_1
XFILLER_32_990 VPWR VGND sg13g2_decap_4
X_3899_ net640 _1556_ _1561_ _1562_ VPWR VGND sg13g2_nor3_1
XFILLER_3_839 VPWR VGND sg13g2_decap_8
Xfanout631 videogen.fancy_shader.shader_counter_reg\[4\] net631 VPWR VGND sg13g2_buf_8
Xfanout620 net621 net620 VPWR VGND sg13g2_buf_8
Xfanout642 videogen.test_lut_thingy.pixel_feeder_inst.h_pix\[3\] net642 VPWR VGND
+ sg13g2_buf_8
Xfanout675 net680 net675 VPWR VGND sg13g2_buf_8
Xfanout653 clk_video net653 VPWR VGND sg13g2_buf_8
Xfanout664 net668 net664 VPWR VGND sg13g2_buf_8
Xfanout686 net688 net686 VPWR VGND sg13g2_buf_8
Xfanout697 net698 net697 VPWR VGND sg13g2_buf_8
XFILLER_2_1021 VPWR VGND sg13g2_decap_8
XFILLER_14_423 VPWR VGND sg13g2_decap_8
XFILLER_15_946 VPWR VGND sg13g2_decap_8
XFILLER_26_294 VPWR VGND sg13g2_decap_4
XFILLER_6_600 VPWR VGND sg13g2_fill_2
XFILLER_5_198 VPWR VGND sg13g2_decap_4
XFILLER_18_740 VPWR VGND sg13g2_decap_4
X_4940_ net125 VGND VPWR _0294_ videogen.fancy_shader.video_x\[6\] net654 sg13g2_dfrbpq_2
XFILLER_17_261 VPWR VGND sg13g2_fill_2
X_4871_ net694 net738 _0228_ VPWR VGND sg13g2_nor2_1
XFILLER_32_231 VPWR VGND sg13g2_fill_1
X_3822_ _1482_ _1483_ _1484_ _1485_ _1486_ VPWR VGND sg13g2_nor4_1
XFILLER_33_798 VPWR VGND sg13g2_fill_1
X_3753_ videogen.test_lut_thingy.pixel_feeder_inst.row\[7\]\[2\] net585 _1417_ VPWR
+ VGND sg13g2_nor2_1
X_2704_ _0708_ _0721_ _0722_ VPWR VGND sg13g2_nor2_2
X_3684_ net617 VPWR _1348_ VGND videogen.test_lut_thingy.pixel_feeder_inst.row\[38\]\[2\]
+ net606 sg13g2_o21ai_1
X_4305_ _1948_ _1950_ _1946_ _1957_ VPWR VGND _1956_ sg13g2_nand4_1
X_5285_ net148 VGND VPWR _0635_ videogen.test_lut_thingy.pixel_feeder_inst.row\[22\]\[1\]
+ _0254_ sg13g2_dfrbpq_1
X_4236_ VGND VPWR _1893_ _1892_ _1891_ sg13g2_or2_1
X_4167_ _1824_ _1821_ _1823_ VPWR VGND sg13g2_nand2b_1
X_3118_ VGND VPWR videogen.test_lut_thingy.pixel_feeder_inst.v_pix\[5\] _0861_ _0865_
+ _0864_ sg13g2_a21oi_1
X_4098_ _1751_ _1640_ _1755_ VPWR VGND sg13g2_xor2_1
X_3049_ net809 videogen.test_lut_thingy.pixel_feeder_inst.row\[1\]\[0\] _0815_ _0278_
+ VPWR VGND sg13g2_mux2_1
XFILLER_24_732 VPWR VGND sg13g2_decap_8
XFILLER_24_743 VPWR VGND sg13g2_fill_1
XFILLER_36_592 VPWR VGND sg13g2_decap_4
XFILLER_23_34 VPWR VGND sg13g2_fill_2
XFILLER_20_960 VPWR VGND sg13g2_decap_4
X_5174__57 VPWR VGND net57 sg13g2_tiehi
XFILLER_2_157 VPWR VGND sg13g2_fill_2
X_5088__295 VPWR VGND net295 sg13g2_tiehi
XFILLER_24_1011 VPWR VGND sg13g2_decap_8
XFILLER_47_802 VPWR VGND sg13g2_decap_8
XFILLER_46_334 VPWR VGND sg13g2_fill_1
XFILLER_19_526 VPWR VGND sg13g2_decap_8
XFILLER_47_879 VPWR VGND sg13g2_decap_8
XFILLER_46_367 VPWR VGND sg13g2_decap_8
XFILLER_0_49 VPWR VGND sg13g2_decap_8
XFILLER_46_378 VPWR VGND sg13g2_fill_1
XFILLER_7_931 VPWR VGND sg13g2_decap_8
XFILLER_6_474 VPWR VGND sg13g2_decap_8
X_5070_ net331 VGND VPWR _0420_ videogen.test_lut_thingy.pixel_feeder_inst.row\[9\]\[0\]
+ _0057_ sg13g2_dfrbpq_1
X_4021_ VGND VPWR _1680_ _1681_ _1677_ _1673_ sg13g2_a21oi_2
XFILLER_49_183 VPWR VGND sg13g2_decap_8
XFILLER_49_161 VPWR VGND sg13g2_decap_8
XFILLER_37_367 VPWR VGND sg13g2_decap_8
XFILLER_37_378 VPWR VGND sg13g2_fill_2
XFILLER_46_890 VPWR VGND sg13g2_decap_8
X_4923_ net151 VGND VPWR _0277_ videogen.test_lut_thingy.pixel_feeder_inst.row\[20\]\[3\]
+ _0008_ sg13g2_dfrbpq_1
X_4854_ net717 net760 _0211_ VPWR VGND sg13g2_nor2_1
X_4785_ net697 net741 _0142_ VPWR VGND sg13g2_nor2_1
X_3805_ net640 VPWR _1469_ VGND videogen.test_lut_thingy.pixel_feeder_inst.row\[29\]\[1\]
+ net572 sg13g2_o21ai_1
X_3736_ net640 VPWR _1400_ VGND _1395_ _1399_ sg13g2_o21ai_1
XFILLER_20_289 VPWR VGND sg13g2_decap_4
Xheichips25_bagel_27 VPWR VGND uio_oe[6] sg13g2_tielo
X_3667_ net1 _1329_ _1331_ VPWR VGND sg13g2_nor2_1
X_3598_ videogen.test_lut_thingy.pixel_feeder_inst.row\[41\]\[3\] net575 _1262_ VPWR
+ VGND sg13g2_nor2_1
X_5268_ net290 VGND VPWR _0618_ serialize.tmds_parallel_b\[7\] net668 sg13g2_dfrbpq_1
XFILLER_0_639 VPWR VGND sg13g2_decap_8
X_4219_ _1876_ _1793_ _1827_ VPWR VGND sg13g2_xnor2_1
X_5199_ net332 VGND VPWR _0549_ videogen.test_lut_thingy.pixel_feeder_inst.row\[48\]\[1\]
+ _0178_ sg13g2_dfrbpq_1
X_5202__320 VPWR VGND net320 sg13g2_tiehi
XFILLER_44_827 VPWR VGND sg13g2_decap_8
XFILLER_34_77 VPWR VGND sg13g2_fill_1
XFILLER_8_728 VPWR VGND sg13g2_fill_1
XFILLER_11_234 VPWR VGND sg13g2_fill_2
XFILLER_7_238 VPWR VGND sg13g2_decap_4
X_4951__108 VPWR VGND net108 sg13g2_tiehi
XFILLER_4_967 VPWR VGND sg13g2_decap_8
XFILLER_3_466 VPWR VGND sg13g2_fill_2
XFILLER_19_345 VPWR VGND sg13g2_fill_1
XFILLER_47_676 VPWR VGND sg13g2_decap_8
XFILLER_34_348 VPWR VGND sg13g2_fill_2
XFILLER_30_554 VPWR VGND sg13g2_decap_8
X_4570_ net566 _2195_ _0515_ VPWR VGND sg13g2_nor2_1
X_3521_ _1178_ _1180_ net557 _1185_ VPWR VGND sg13g2_mux2_1
XFILLER_6_271 VPWR VGND sg13g2_decap_4
XFILLER_6_260 VPWR VGND sg13g2_fill_1
X_3452_ _1116_ _1041_ _1115_ VPWR VGND sg13g2_xnor2_1
X_3383_ _1047_ videogen.fancy_shader.video_y\[6\] videogen.fancy_shader.shader_counter_reg\[6\]
+ VPWR VGND sg13g2_xnor2_1
X_5122_ net227 VGND VPWR _0472_ videogen.test_lut_thingy.pixel_feeder_inst.row\[57\]\[0\]
+ _0109_ sg13g2_dfrbpq_1
XFILLER_27_0 VPWR VGND sg13g2_decap_4
XFILLER_38_621 VPWR VGND sg13g2_decap_8
X_5053_ net356 VGND VPWR _0403_ red_tmds_par\[2\] net665 sg13g2_dfrbpq_1
X_4004_ _1660_ _1662_ _1664_ VPWR VGND sg13g2_nor2_1
XFILLER_26_805 VPWR VGND sg13g2_decap_4
XFILLER_38_698 VPWR VGND sg13g2_decap_8
XFILLER_1_70 VPWR VGND sg13g2_decap_8
XFILLER_26_838 VPWR VGND sg13g2_decap_4
X_4906_ net174 VGND VPWR _0261_ clockdiv.q1 clknet_3_4_0_clk_regs sg13g2_dfrbpq_1
X_4837_ net714 net758 _0194_ VPWR VGND sg13g2_nor2_1
X_4975__60 VPWR VGND net60 sg13g2_tiehi
X_4768_ net683 net727 _0125_ VPWR VGND sg13g2_nor2_1
X_4699_ net721 net764 _0056_ VPWR VGND sg13g2_nor2_1
X_3719_ _1379_ _1380_ _1381_ _1382_ _1383_ VPWR VGND sg13g2_nor4_1
XFILLER_20_79 VPWR VGND sg13g2_fill_2
XFILLER_49_908 VPWR VGND sg13g2_decap_8
XFILLER_0_414 VPWR VGND sg13g2_decap_8
XFILLER_0_436 VPWR VGND sg13g2_decap_8
XFILLER_1_959 VPWR VGND sg13g2_decap_8
Xhold22 serialize.shift_reg_b\[8\] VPWR VGND net467 sg13g2_dlygate4sd3_1
Xhold11 serialize.shift_reg_g\[8\] VPWR VGND net456 sg13g2_dlygate4sd3_1
Xhold33 _2218_ VPWR VGND net478 sg13g2_dlygate4sd3_1
XFILLER_29_77 VPWR VGND sg13g2_fill_1
XFILLER_17_816 VPWR VGND sg13g2_decap_4
XFILLER_28_153 VPWR VGND sg13g2_fill_1
XFILLER_44_657 VPWR VGND sg13g2_decap_8
XFILLER_16_337 VPWR VGND sg13g2_fill_2
XFILLER_31_307 VPWR VGND sg13g2_decap_8
XFILLER_12_510 VPWR VGND sg13g2_fill_2
XFILLER_6_26 VPWR VGND sg13g2_decap_8
XFILLER_4_764 VPWR VGND sg13g2_decap_8
XFILLER_3_285 VPWR VGND sg13g2_decap_4
XFILLER_39_407 VPWR VGND sg13g2_fill_2
X_4927__143 VPWR VGND net143 sg13g2_tiehi
XFILLER_48_974 VPWR VGND sg13g2_decap_8
XFILLER_34_101 VPWR VGND sg13g2_decap_8
XFILLER_34_112 VPWR VGND sg13g2_fill_1
XFILLER_22_307 VPWR VGND sg13g2_fill_2
XFILLER_34_145 VPWR VGND sg13g2_fill_2
XFILLER_35_668 VPWR VGND sg13g2_decap_8
X_2952_ net811 videogen.test_lut_thingy.pixel_feeder_inst.row\[63\]\[0\] _0794_ _0448_
+ VPWR VGND sg13g2_mux2_1
X_5255__379 VPWR VGND net379 sg13g2_tiehi
XFILLER_15_392 VPWR VGND sg13g2_decap_8
XFILLER_30_340 VPWR VGND sg13g2_decap_4
XFILLER_31_852 VPWR VGND sg13g2_decap_8
XFILLER_31_863 VPWR VGND sg13g2_fill_1
X_2883_ videogen.test_lut_thingy.pixel_feeder_inst.row\[51\]\[2\] net789 _0779_ _0502_
+ VPWR VGND sg13g2_mux2_1
X_4622_ _2226_ net672 net473 net677 green_tmds_par\[1\] VPWR VGND sg13g2_a22oi_1
X_4553_ _2180_ _2157_ _2175_ VPWR VGND sg13g2_nand2_1
XFILLER_7_580 VPWR VGND sg13g2_fill_2
X_4484_ _2069_ VPWR _2118_ VGND tmds_green.dc_balancing_reg\[3\] _2071_ sg13g2_o21ai_1
X_3504_ _1167_ VPWR _1168_ VGND _1158_ _1165_ sg13g2_o21ai_1
X_3435_ _1098_ _1097_ _1099_ VPWR VGND sg13g2_xor2_1
X_3366_ _1030_ _1021_ _1029_ VPWR VGND sg13g2_nand2b_1
X_3297_ net769 _0971_ _0972_ _0342_ VPWR VGND sg13g2_nor3_1
X_5105_ net261 VGND VPWR _0455_ videogen.test_lut_thingy.pixel_feeder_inst.row\[60\]\[3\]
+ _0092_ sg13g2_dfrbpq_1
X_5036_ net382 VGND VPWR _0390_ videogen.test_lut_thingy.pixel_feeder_inst.row\[17\]\[3\]
+ _0036_ sg13g2_dfrbpq_1
XFILLER_38_462 VPWR VGND sg13g2_decap_8
XFILLER_41_605 VPWR VGND sg13g2_decap_8
XFILLER_25_145 VPWR VGND sg13g2_decap_8
XFILLER_25_156 VPWR VGND sg13g2_fill_2
XFILLER_26_668 VPWR VGND sg13g2_fill_1
XFILLER_15_35 VPWR VGND sg13g2_decap_8
XFILLER_15_46 VPWR VGND sg13g2_fill_1
XFILLER_22_852 VPWR VGND sg13g2_decap_4
XFILLER_21_362 VPWR VGND sg13g2_fill_1
XFILLER_31_89 VPWR VGND sg13g2_decap_4
Xoutput12 net12 uio_out[7] VPWR VGND sg13g2_buf_1
XFILLER_49_705 VPWR VGND sg13g2_decap_8
XFILLER_0_255 VPWR VGND sg13g2_decap_8
XFILLER_0_222 VPWR VGND sg13g2_decap_4
XFILLER_1_756 VPWR VGND sg13g2_decap_8
XFILLER_29_473 VPWR VGND sg13g2_fill_2
XFILLER_29_495 VPWR VGND sg13g2_decap_8
XFILLER_16_156 VPWR VGND sg13g2_fill_2
XFILLER_40_693 VPWR VGND sg13g2_fill_2
XFILLER_9_867 VPWR VGND sg13g2_decap_8
XFILLER_9_878 VPWR VGND sg13g2_fill_2
XFILLER_12_373 VPWR VGND sg13g2_decap_8
X_5070__331 VPWR VGND net331 sg13g2_tiehi
XFILLER_4_572 VPWR VGND sg13g2_decap_8
X_3220_ _0917_ _0918_ _0311_ VPWR VGND sg13g2_nor2_1
X_3151_ _0873_ net819 VPWR VGND _0872_ sg13g2_nand2b_2
XFILLER_48_771 VPWR VGND sg13g2_decap_8
X_3082_ VGND VPWR _0837_ _0841_ _0002_ _0354_ sg13g2_a21oi_1
XFILLER_36_955 VPWR VGND sg13g2_fill_2
XFILLER_35_465 VPWR VGND sg13g2_fill_1
XFILLER_35_487 VPWR VGND sg13g2_fill_1
X_3984_ _1093_ _1643_ _1092_ _1644_ VPWR VGND sg13g2_nand3_1
X_2935_ net787 videogen.test_lut_thingy.pixel_feeder_inst.row\[8\]\[2\] _0791_ _0462_
+ VPWR VGND sg13g2_mux2_1
X_2866_ _0776_ _0754_ _0760_ VPWR VGND sg13g2_nand2_2
XFILLER_31_682 VPWR VGND sg13g2_decap_8
X_4605_ VPWR _0642_ net480 VGND sg13g2_inv_1
X_2797_ videogen.test_lut_thingy.pixel_feeder_inst.row\[42\]\[2\] net796 _0761_ _0578_
+ VPWR VGND sg13g2_mux2_1
X_4536_ VGND VPWR _2145_ _2146_ _2163_ _2148_ sg13g2_a21oi_1
X_4467_ _2056_ _2073_ _2101_ _2102_ VPWR VGND sg13g2_nor3_1
Xfanout813 net814 net813 VPWR VGND sg13g2_buf_8
X_3418_ _1047_ _1081_ _1082_ VPWR VGND sg13g2_nor2_1
X_4398_ VGND VPWR _2046_ _2030_ _1982_ sg13g2_or2_1
Xfanout802 ui_in[5] net802 VPWR VGND sg13g2_buf_8
X_3349_ _1013_ videogen.fancy_shader.video_x\[3\] videogen.fancy_shader.shader_counter_reg\[3\]
+ VPWR VGND sg13g2_xnor2_1
XFILLER_46_708 VPWR VGND sg13g2_decap_8
X_5019_ net410 VGND VPWR _0373_ red_tmds_par\[3\] net666 sg13g2_dfrbpq_1
XFILLER_27_955 VPWR VGND sg13g2_fill_1
XFILLER_14_605 VPWR VGND sg13g2_decap_4
XFILLER_26_56 VPWR VGND sg13g2_fill_1
XFILLER_26_454 VPWR VGND sg13g2_fill_2
XFILLER_27_999 VPWR VGND sg13g2_fill_2
XFILLER_21_170 VPWR VGND sg13g2_fill_1
XFILLER_6_848 VPWR VGND sg13g2_decap_8
XFILLER_1_553 VPWR VGND sg13g2_decap_8
XFILLER_49_502 VPWR VGND sg13g2_decap_8
XFILLER_49_579 VPWR VGND sg13g2_decap_8
XFILLER_37_719 VPWR VGND sg13g2_fill_2
XFILLER_45_730 VPWR VGND sg13g2_fill_1
XFILLER_18_944 VPWR VGND sg13g2_decap_8
XFILLER_36_218 VPWR VGND sg13g2_fill_1
XFILLER_18_988 VPWR VGND sg13g2_decap_8
XFILLER_17_487 VPWR VGND sg13g2_decap_8
XFILLER_32_402 VPWR VGND sg13g2_fill_2
XFILLER_32_413 VPWR VGND sg13g2_decap_4
X_5098__275 VPWR VGND net275 sg13g2_tiehi
X_2720_ videogen.test_lut_thingy.pixel_feeder_inst.row\[23\]\[1\] net804 _0727_ _0631_
+ VPWR VGND sg13g2_mux2_1
XFILLER_9_653 VPWR VGND sg13g2_fill_2
X_2651_ VPWR _0670_ videogen.test_lut_thingy.pixel_feeder_inst.row\[61\]\[2\] VGND
+ sg13g2_inv_1
XFILLER_8_196 VPWR VGND sg13g2_fill_1
XFILLER_8_174 VPWR VGND sg13g2_fill_2
XFILLER_9_697 VPWR VGND sg13g2_decap_8
X_4321_ _1959_ _1972_ _1973_ VPWR VGND sg13g2_nor2_1
X_4252_ VPWR VGND _1908_ _1896_ _1903_ _1886_ _1909_ _1889_ sg13g2_a221oi_1
X_3203_ _0906_ _0907_ _0305_ VPWR VGND sg13g2_nor2_1
XFILLER_41_1028 VPWR VGND sg13g2_fill_1
X_4183_ _1840_ _1747_ _1832_ VPWR VGND sg13g2_xnor2_1
X_3134_ red_tmds_par\[9\] net676 _0264_ VPWR VGND sg13g2_and2_1
X_3065_ videogen.fancy_shader.video_x\[2\] _0826_ _0827_ VPWR VGND sg13g2_and2_1
XFILLER_24_969 VPWR VGND sg13g2_decap_4
XFILLER_35_284 VPWR VGND sg13g2_decap_4
X_3967_ _1525_ _1624_ _1428_ _1628_ VPWR VGND sg13g2_nand3_1
X_2918_ _0742_ _0748_ _0735_ _0788_ VPWR VGND sg13g2_nand3_1
X_3898_ _1557_ _1558_ _1559_ _1560_ _1561_ VPWR VGND sg13g2_nor4_1
X_2849_ net798 videogen.test_lut_thingy.pixel_feeder_inst.row\[26\]\[1\] _0772_ _0537_
+ VPWR VGND sg13g2_mux2_1
XFILLER_3_818 VPWR VGND sg13g2_decap_8
X_4519_ _2146_ _2144_ _2147_ VPWR VGND sg13g2_xor2_1
Xfanout610 net614 net610 VPWR VGND sg13g2_buf_8
Xfanout621 videogen.mem_read net621 VPWR VGND sg13g2_buf_8
Xfanout632 videogen.fancy_shader.shader_counter_reg\[1\] net632 VPWR VGND sg13g2_buf_8
Xfanout654 net655 net654 VPWR VGND sg13g2_buf_8
Xfanout643 net645 net643 VPWR VGND sg13g2_buf_8
Xfanout665 net667 net665 VPWR VGND sg13g2_buf_8
Xfanout676 net680 net676 VPWR VGND sg13g2_buf_8
Xfanout687 net688 net687 VPWR VGND sg13g2_buf_8
XFILLER_19_708 VPWR VGND sg13g2_fill_2
Xfanout698 net704 net698 VPWR VGND sg13g2_buf_8
XFILLER_46_538 VPWR VGND sg13g2_decap_4
XFILLER_2_1000 VPWR VGND sg13g2_decap_8
XFILLER_37_99 VPWR VGND sg13g2_fill_2
XFILLER_18_1019 VPWR VGND sg13g2_decap_8
XFILLER_41_276 VPWR VGND sg13g2_decap_8
XFILLER_10_641 VPWR VGND sg13g2_fill_1
XFILLER_6_634 VPWR VGND sg13g2_fill_1
XFILLER_6_656 VPWR VGND sg13g2_decap_8
XFILLER_2_895 VPWR VGND sg13g2_decap_8
XFILLER_37_527 VPWR VGND sg13g2_fill_1
X_5247__59 VPWR VGND net59 sg13g2_tiehi
XFILLER_17_240 VPWR VGND sg13g2_fill_2
XFILLER_18_796 VPWR VGND sg13g2_fill_2
XFILLER_45_593 VPWR VGND sg13g2_decap_8
X_4870_ net698 net742 _0227_ VPWR VGND sg13g2_nor2_1
X_3821_ videogen.test_lut_thingy.pixel_feeder_inst.row\[52\]\[1\] net593 _1485_ VPWR
+ VGND sg13g2_nor2_1
XFILLER_32_243 VPWR VGND sg13g2_decap_4
XFILLER_20_416 VPWR VGND sg13g2_fill_2
X_3752_ videogen.test_lut_thingy.pixel_feeder_inst.row\[6\]\[2\] net605 _1416_ VPWR
+ VGND sg13g2_nor2_1
X_2703_ _0721_ net560 _0720_ VPWR VGND sg13g2_nand2_2
X_3683_ _1343_ _1344_ _1345_ _1346_ _1347_ VPWR VGND sg13g2_nor4_1
X_4304_ red\[0\] _1942_ _1956_ VPWR VGND sg13g2_and2_1
X_5284_ net178 VGND VPWR _0634_ videogen.test_lut_thingy.pixel_feeder_inst.row\[22\]\[0\]
+ _0253_ sg13g2_dfrbpq_1
XFILLER_4_70 VPWR VGND sg13g2_fill_2
X_4235_ _1892_ _1879_ _1885_ _1888_ VPWR VGND sg13g2_and3_1
X_4166_ _1822_ VPWR _1823_ VGND _1813_ _1820_ sg13g2_o21ai_1
X_3117_ _0850_ VPWR _0864_ VGND videogen.test_lut_thingy.pixel_feeder_inst.v_pix\[5\]
+ _0861_ sg13g2_o21ai_1
XFILLER_43_508 VPWR VGND sg13g2_fill_1
X_4097_ _1754_ _1640_ _1751_ VPWR VGND sg13g2_xnor2_1
X_3048_ net799 videogen.test_lut_thingy.pixel_feeder_inst.row\[1\]\[1\] _0815_ _0279_
+ VPWR VGND sg13g2_mux2_1
XFILLER_24_777 VPWR VGND sg13g2_decap_8
XFILLER_12_939 VPWR VGND sg13g2_decap_4
XFILLER_23_46 VPWR VGND sg13g2_decap_8
X_4999_ net430 VGND VPWR _0353_ hsync net664 sg13g2_dfrbpq_2
XFILLER_23_57 VPWR VGND sg13g2_fill_2
XFILLER_20_994 VPWR VGND sg13g2_fill_1
XFILLER_3_604 VPWR VGND sg13g2_fill_2
XFILLER_48_21 VPWR VGND sg13g2_decap_8
XFILLER_46_302 VPWR VGND sg13g2_decap_4
XFILLER_47_858 VPWR VGND sg13g2_decap_8
XFILLER_0_28 VPWR VGND sg13g2_decap_8
XFILLER_14_221 VPWR VGND sg13g2_decap_8
XFILLER_14_254 VPWR VGND sg13g2_fill_1
XFILLER_15_788 VPWR VGND sg13g2_fill_1
XFILLER_7_910 VPWR VGND sg13g2_decap_8
XFILLER_11_994 VPWR VGND sg13g2_decap_8
XFILLER_31_1016 VPWR VGND sg13g2_decap_8
XFILLER_6_442 VPWR VGND sg13g2_fill_1
XFILLER_6_431 VPWR VGND sg13g2_decap_8
XFILLER_7_987 VPWR VGND sg13g2_decap_8
XFILLER_9_1028 VPWR VGND sg13g2_fill_1
XFILLER_2_692 VPWR VGND sg13g2_decap_8
XFILLER_49_140 VPWR VGND sg13g2_decap_8
X_4020_ VGND VPWR _1660_ _1679_ _1680_ _1664_ sg13g2_a21oi_1
XFILLER_37_324 VPWR VGND sg13g2_fill_1
XFILLER_25_519 VPWR VGND sg13g2_decap_8
X_4922_ net153 VGND VPWR _0276_ videogen.test_lut_thingy.pixel_feeder_inst.row\[20\]\[2\]
+ _0007_ sg13g2_dfrbpq_1
XFILLER_33_530 VPWR VGND sg13g2_fill_2
XFILLER_21_714 VPWR VGND sg13g2_fill_2
X_4853_ net716 net761 _0210_ VPWR VGND sg13g2_nor2_1
XFILLER_33_574 VPWR VGND sg13g2_fill_1
X_4784_ net703 net747 _0141_ VPWR VGND sg13g2_nor2_1
X_3804_ _1464_ _1465_ _1466_ _1467_ _1468_ VPWR VGND sg13g2_nor4_1
X_3735_ _1398_ VPWR _1399_ VGND videogen.test_lut_thingy.pixel_feeder_inst.row\[30\]\[2\]
+ net604 sg13g2_o21ai_1
Xheichips25_bagel_28 VPWR VGND uio_oe[7] sg13g2_tielo
X_3666_ VPWR _1330_ _1329_ VGND sg13g2_inv_1
XFILLER_47_1012 VPWR VGND sg13g2_decap_8
X_3597_ net612 VPWR _1261_ VGND videogen.test_lut_thingy.pixel_feeder_inst.row\[40\]\[3\]
+ net592 sg13g2_o21ai_1
XFILLER_0_618 VPWR VGND sg13g2_decap_8
X_5267_ net294 VGND VPWR _0617_ serialize.tmds_parallel_b\[6\] net663 sg13g2_dfrbpq_1
X_4218_ VPWR _1875_ _1874_ VGND sg13g2_inv_1
X_5198_ net336 VGND VPWR _0548_ videogen.test_lut_thingy.pixel_feeder_inst.row\[48\]\[0\]
+ _0177_ sg13g2_dfrbpq_1
X_4149_ VGND VPWR _1803_ _1804_ _1806_ _1805_ sg13g2_a21oi_1
XFILLER_43_316 VPWR VGND sg13g2_decap_8
XFILLER_12_703 VPWR VGND sg13g2_decap_4
X_5155__117 VPWR VGND net117 sg13g2_tiehi
Xclkload0 VPWR clkload0/Y clknet_1_1__leaf_clk VGND sg13g2_inv_1
XFILLER_4_946 VPWR VGND sg13g2_decap_8
XFILLER_3_434 VPWR VGND sg13g2_decap_8
XFILLER_3_489 VPWR VGND sg13g2_fill_2
XFILLER_47_655 VPWR VGND sg13g2_decap_8
XFILLER_46_143 VPWR VGND sg13g2_decap_8
X_5027__397 VPWR VGND net397 sg13g2_tiehi
XFILLER_15_552 VPWR VGND sg13g2_decap_8
X_3520_ _1184_ _1106_ _1178_ VPWR VGND sg13g2_nand2_1
X_3451_ _1018_ VPWR _1115_ VGND _1017_ _1019_ sg13g2_o21ai_1
X_3382_ VGND VPWR _1046_ videogen.fancy_shader.shader_counter_reg\[6\] videogen.fancy_shader.video_y\[6\]
+ sg13g2_or2_1
X_5121_ net229 VGND VPWR _0471_ videogen.test_lut_thingy.pixel_feeder_inst.row\[58\]\[3\]
+ _0108_ sg13g2_dfrbpq_1
XFILLER_34_2 VPWR VGND sg13g2_fill_1
X_5080__311 VPWR VGND net311 sg13g2_tiehi
X_5052_ net358 VGND VPWR _0001_ videogen.test_lut_thingy.pixel_feeder_inst.state\[3\]
+ net650 sg13g2_dfrbpq_1
XFILLER_37_121 VPWR VGND sg13g2_decap_8
X_4003_ _1654_ _1656_ _1638_ _1663_ VPWR VGND _1659_ sg13g2_nand4_1
XFILLER_38_677 VPWR VGND sg13g2_decap_8
XFILLER_40_319 VPWR VGND sg13g2_fill_1
X_4905_ net710 net754 _0260_ VPWR VGND sg13g2_nor2_1
XFILLER_21_533 VPWR VGND sg13g2_fill_1
X_4836_ net713 net757 _0193_ VPWR VGND sg13g2_nor2_1
XFILLER_33_393 VPWR VGND sg13g2_fill_2
X_4767_ net689 net733 _0124_ VPWR VGND sg13g2_nor2_1
XFILLER_21_599 VPWR VGND sg13g2_fill_2
X_4698_ net716 net760 _0055_ VPWR VGND sg13g2_nor2_1
X_3718_ videogen.test_lut_thingy.pixel_feeder_inst.row\[21\]\[2\] net573 _1382_ VPWR
+ VGND sg13g2_nor2_1
X_3649_ _1309_ _1310_ _1311_ _1312_ _1313_ VPWR VGND sg13g2_nor4_1
XFILLER_20_36 VPWR VGND sg13g2_fill_1
X_5319_ net138 VGND VPWR net675 serialize.shift_reg_c\[8\] clknet_3_2_0_clk_regs sg13g2_dfrbpq_1
XFILLER_1_938 VPWR VGND sg13g2_decap_8
Xhold23 _2219_ VPWR VGND net468 sg13g2_dlygate4sd3_1
Xhold12 serialize.shift_reg_r\[4\] VPWR VGND net457 sg13g2_dlygate4sd3_1
Xhold34 serialize.shift_reg_b\[6\] VPWR VGND net479 sg13g2_dlygate4sd3_1
XFILLER_29_655 VPWR VGND sg13g2_decap_8
XFILLER_29_688 VPWR VGND sg13g2_decap_4
XFILLER_44_636 VPWR VGND sg13g2_decap_8
XFILLER_43_113 VPWR VGND sg13g2_fill_2
XFILLER_28_176 VPWR VGND sg13g2_fill_2
XFILLER_45_99 VPWR VGND sg13g2_fill_2
XFILLER_40_897 VPWR VGND sg13g2_fill_2
XFILLER_8_537 VPWR VGND sg13g2_fill_1
XFILLER_8_526 VPWR VGND sg13g2_decap_8
XFILLER_4_743 VPWR VGND sg13g2_decap_8
XFILLER_3_253 VPWR VGND sg13g2_decap_8
XFILLER_6_1009 VPWR VGND sg13g2_decap_8
XFILLER_0_982 VPWR VGND sg13g2_decap_8
XFILLER_48_953 VPWR VGND sg13g2_decap_8
XFILLER_47_441 VPWR VGND sg13g2_fill_2
XFILLER_47_430 VPWR VGND sg13g2_decap_8
XFILLER_19_143 VPWR VGND sg13g2_fill_1
XFILLER_19_165 VPWR VGND sg13g2_decap_4
XFILLER_16_850 VPWR VGND sg13g2_fill_2
XFILLER_15_371 VPWR VGND sg13g2_decap_8
X_2951_ net800 videogen.test_lut_thingy.pixel_feeder_inst.row\[63\]\[1\] _0794_ _0449_
+ VPWR VGND sg13g2_mux2_1
XFILLER_31_820 VPWR VGND sg13g2_fill_1
XFILLER_34_168 VPWR VGND sg13g2_fill_1
XFILLER_34_179 VPWR VGND sg13g2_decap_8
XFILLER_43_691 VPWR VGND sg13g2_decap_8
X_2882_ videogen.test_lut_thingy.pixel_feeder_inst.row\[51\]\[3\] net779 _0779_ _0503_
+ VPWR VGND sg13g2_mux2_1
X_4621_ VPWR _0650_ _2225_ VGND sg13g2_inv_1
X_4552_ _2179_ _2169_ _2178_ VPWR VGND sg13g2_xnor2_1
X_4483_ _2103_ VPWR _2117_ VGND _2104_ _2106_ sg13g2_o21ai_1
X_3503_ _1167_ _1153_ _1156_ VPWR VGND sg13g2_xnor2_1
X_3434_ _1085_ _1078_ _1098_ VPWR VGND sg13g2_xor2_1
X_3365_ _1028_ _1026_ _1029_ VPWR VGND sg13g2_xor2_1
X_5104_ net263 VGND VPWR _0454_ videogen.test_lut_thingy.pixel_feeder_inst.row\[60\]\[2\]
+ _0091_ sg13g2_dfrbpq_1
X_3296_ _0972_ _0844_ _0845_ _0872_ VPWR VGND sg13g2_and3_1
X_5035_ net384 VGND VPWR _0389_ videogen.test_lut_thingy.pixel_feeder_inst.row\[17\]\[2\]
+ _0035_ sg13g2_dfrbpq_1
X_5303__326 VPWR VGND net326 sg13g2_tiehi
XFILLER_38_441 VPWR VGND sg13g2_fill_2
XFILLER_14_809 VPWR VGND sg13g2_decap_8
XFILLER_25_179 VPWR VGND sg13g2_fill_1
XFILLER_33_190 VPWR VGND sg13g2_fill_1
X_4819_ net718 net762 _0176_ VPWR VGND sg13g2_nor2_1
Xoutput13 net13 uo_out[0] VPWR VGND sg13g2_buf_1
XFILLER_1_735 VPWR VGND sg13g2_decap_8
XFILLER_48_249 VPWR VGND sg13g2_decap_4
XFILLER_5_1020 VPWR VGND sg13g2_decap_8
XFILLER_44_422 VPWR VGND sg13g2_decap_8
XFILLER_44_411 VPWR VGND sg13g2_decap_4
XFILLER_16_113 VPWR VGND sg13g2_decap_8
XFILLER_44_455 VPWR VGND sg13g2_decap_8
XFILLER_44_433 VPWR VGND sg13g2_fill_1
XFILLER_16_146 VPWR VGND sg13g2_decap_4
XFILLER_40_672 VPWR VGND sg13g2_decap_8
XFILLER_8_301 VPWR VGND sg13g2_fill_2
XFILLER_9_824 VPWR VGND sg13g2_decap_8
XFILLER_4_551 VPWR VGND sg13g2_decap_8
XFILLER_39_205 VPWR VGND sg13g2_decap_4
X_3150_ _0872_ _0819_ _0830_ _0871_ VPWR VGND sg13g2_and3_2
XFILLER_39_249 VPWR VGND sg13g2_fill_2
XFILLER_39_238 VPWR VGND sg13g2_decap_8
X_3081_ _0841_ _0834_ _0840_ VPWR VGND sg13g2_nand2_1
XFILLER_48_750 VPWR VGND sg13g2_decap_8
XFILLER_11_4 VPWR VGND sg13g2_fill_1
XFILLER_36_934 VPWR VGND sg13g2_decap_4
Xclkbuf_3_6_0_clk_regs clknet_0_clk_regs clknet_3_6_0_clk_regs VPWR VGND sg13g2_buf_8
XFILLER_36_978 VPWR VGND sg13g2_decap_4
X_3983_ _1643_ _1098_ _1639_ VPWR VGND sg13g2_nand2_1
XFILLER_16_680 VPWR VGND sg13g2_decap_8
XFILLER_22_149 VPWR VGND sg13g2_decap_4
X_2934_ net776 videogen.test_lut_thingy.pixel_feeder_inst.row\[8\]\[3\] _0791_ _0463_
+ VPWR VGND sg13g2_mux2_1
X_2865_ videogen.test_lut_thingy.pixel_feeder_inst.row\[28\]\[0\] net813 _0775_ _0524_
+ VPWR VGND sg13g2_mux2_1
X_4604_ _2217_ net674 net479 net675 blue_tmds_par\[2\] VPWR VGND sg13g2_a22oi_1
X_2796_ videogen.test_lut_thingy.pixel_feeder_inst.row\[42\]\[3\] net785 _0761_ _0579_
+ VPWR VGND sg13g2_mux2_1
X_4535_ net566 _2162_ _0513_ VPWR VGND sg13g2_nor2_1
X_4466_ _0683_ green\[6\] _2101_ VPWR VGND sg13g2_nor2_1
X_3417_ _1081_ videogen.fancy_shader.video_y\[7\] videogen.fancy_shader.shader_counter_reg\[7\]
+ VPWR VGND sg13g2_xnor2_1
X_4397_ VGND VPWR _2044_ _2045_ _0370_ net565 sg13g2_a21oi_1
Xfanout814 net817 net814 VPWR VGND sg13g2_buf_8
Xfanout803 net804 net803 VPWR VGND sg13g2_buf_8
X_3348_ _1012_ _1006_ _1010_ VPWR VGND sg13g2_xnor2_1
X_3279_ net820 net627 _0960_ VPWR VGND sg13g2_and2_1
XFILLER_45_219 VPWR VGND sg13g2_fill_2
X_5018_ net411 VGND VPWR _0372_ red_tmds_par\[1\] net666 sg13g2_dfrbpq_1
XFILLER_41_414 VPWR VGND sg13g2_fill_1
XFILLER_13_105 VPWR VGND sg13g2_decap_8
XFILLER_13_116 VPWR VGND sg13g2_fill_2
XFILLER_13_127 VPWR VGND sg13g2_fill_2
XFILLER_42_34 VPWR VGND sg13g2_decap_8
XFILLER_10_812 VPWR VGND sg13g2_decap_8
X_5273__266 VPWR VGND net266 sg13g2_tiehi
XFILLER_42_67 VPWR VGND sg13g2_fill_1
XFILLER_42_56 VPWR VGND sg13g2_fill_1
XFILLER_6_827 VPWR VGND sg13g2_decap_8
XFILLER_5_304 VPWR VGND sg13g2_fill_1
XFILLER_10_878 VPWR VGND sg13g2_fill_2
XFILLER_5_315 VPWR VGND sg13g2_decap_8
XFILLER_3_17 VPWR VGND sg13g2_fill_1
XFILLER_1_532 VPWR VGND sg13g2_decap_8
XFILLER_49_558 VPWR VGND sg13g2_decap_8
XFILLER_37_709 VPWR VGND sg13g2_decap_4
XFILLER_33_937 VPWR VGND sg13g2_fill_2
XFILLER_13_650 VPWR VGND sg13g2_fill_2
XFILLER_12_171 VPWR VGND sg13g2_fill_2
XFILLER_13_694 VPWR VGND sg13g2_fill_1
XFILLER_9_687 VPWR VGND sg13g2_fill_2
X_5285__148 VPWR VGND net148 sg13g2_tiehi
X_4320_ _1970_ _1967_ _1972_ VPWR VGND sg13g2_xor2_1
X_4251_ _1908_ _1904_ _1907_ VPWR VGND sg13g2_xnor2_1
X_3202_ _0837_ VPWR _0907_ VGND net648 _0905_ sg13g2_o21ai_1
XFILLER_41_1007 VPWR VGND sg13g2_decap_8
X_4182_ _1839_ _1095_ _1836_ VPWR VGND sg13g2_xnor2_1
X_3133_ red_tmds_par\[8\] net676 _0263_ VPWR VGND sg13g2_and2_1
X_3064_ videogen.fancy_shader.video_x\[1\] videogen.fancy_shader.video_x\[0\] _0826_
+ VPWR VGND sg13g2_and2_1
XFILLER_24_904 VPWR VGND sg13g2_decap_4
XFILLER_36_764 VPWR VGND sg13g2_decap_4
X_3966_ _1627_ _1525_ _1624_ VPWR VGND sg13g2_nand2_1
XFILLER_10_119 VPWR VGND sg13g2_fill_1
X_2917_ net810 videogen.test_lut_thingy.pixel_feeder_inst.row\[56\]\[0\] _0787_ _0476_
+ VPWR VGND sg13g2_mux2_1
X_3897_ videogen.test_lut_thingy.pixel_feeder_inst.row\[20\]\[0\] net595 _1560_ VPWR
+ VGND sg13g2_nor2_1
X_2848_ net787 videogen.test_lut_thingy.pixel_feeder_inst.row\[26\]\[2\] _0772_ _0538_
+ VPWR VGND sg13g2_mux2_1
X_2779_ videogen.test_lut_thingy.pixel_feeder_inst.row\[3\]\[3\] net778 _0756_ _0591_
+ VPWR VGND sg13g2_mux2_1
X_4518_ tmds_blue.dc_balancing_reg\[1\] _2141_ _2132_ _2146_ VPWR VGND sg13g2_mux2_1
X_4449_ VGND VPWR _2085_ _2084_ _2083_ sg13g2_or2_1
Xfanout611 net614 net611 VPWR VGND sg13g2_buf_8
Xfanout600 net601 net600 VPWR VGND sg13g2_buf_8
Xfanout622 net623 net622 VPWR VGND sg13g2_buf_8
Xfanout633 videogen.fancy_shader.shader_counter_reg\[0\] net633 VPWR VGND sg13g2_buf_8
Xfanout655 net657 net655 VPWR VGND sg13g2_buf_8
Xfanout644 net645 net644 VPWR VGND sg13g2_buf_8
Xfanout666 net667 net666 VPWR VGND sg13g2_buf_2
Xfanout688 net691 net688 VPWR VGND sg13g2_buf_8
Xfanout677 net679 net677 VPWR VGND sg13g2_buf_8
Xfanout699 net704 net699 VPWR VGND sg13g2_buf_8
XFILLER_39_580 VPWR VGND sg13g2_fill_2
XFILLER_15_904 VPWR VGND sg13g2_fill_1
XFILLER_42_723 VPWR VGND sg13g2_fill_2
X_5238__172 VPWR VGND net172 sg13g2_tiehi
X_5177__45 VPWR VGND net45 sg13g2_tiehi
XFILLER_6_602 VPWR VGND sg13g2_fill_1
XFILLER_6_668 VPWR VGND sg13g2_decap_8
XFILLER_6_646 VPWR VGND sg13g2_decap_4
XFILLER_10_697 VPWR VGND sg13g2_fill_2
XFILLER_2_874 VPWR VGND sg13g2_decap_8
XFILLER_1_362 VPWR VGND sg13g2_fill_1
XFILLER_49_311 VPWR VGND sg13g2_decap_8
XFILLER_49_300 VPWR VGND sg13g2_decap_8
XFILLER_49_355 VPWR VGND sg13g2_decap_8
XFILLER_49_399 VPWR VGND sg13g2_decap_8
XFILLER_49_388 VPWR VGND sg13g2_decap_8
XFILLER_37_539 VPWR VGND sg13g2_decap_4
XFILLER_45_572 VPWR VGND sg13g2_decap_8
XFILLER_17_263 VPWR VGND sg13g2_fill_1
X_3820_ videogen.test_lut_thingy.pixel_feeder_inst.row\[53\]\[1\] net571 _1484_ VPWR
+ VGND sg13g2_nor2_1
XFILLER_33_789 VPWR VGND sg13g2_decap_8
X_3751_ videogen.test_lut_thingy.pixel_feeder_inst.row\[5\]\[2\] net572 _1415_ VPWR
+ VGND sg13g2_nor2_1
X_2702_ _0717_ _0719_ _0720_ VPWR VGND sg13g2_nor2_2
XFILLER_9_484 VPWR VGND sg13g2_decap_4
X_3682_ videogen.test_lut_thingy.pixel_feeder_inst.row\[47\]\[2\] net585 _1346_ VPWR
+ VGND sg13g2_nor2_1
X_4303_ _1955_ red\[0\] _1943_ VPWR VGND sg13g2_nand2_1
X_5283_ net186 VGND VPWR _0633_ videogen.test_lut_thingy.pixel_feeder_inst.row\[23\]\[3\]
+ _0252_ sg13g2_dfrbpq_1
XFILLER_4_93 VPWR VGND sg13g2_decap_8
X_4234_ VGND VPWR _1879_ _1891_ _1888_ _1886_ sg13g2_a21oi_2
X_4165_ _1813_ _1818_ _1742_ _1822_ VPWR VGND sg13g2_nand3_1
X_3116_ VGND VPWR _0850_ _0863_ net20 _0852_ sg13g2_a21oi_1
X_4096_ VGND VPWR _1753_ _1751_ _1097_ sg13g2_or2_1
X_3047_ net793 videogen.test_lut_thingy.pixel_feeder_inst.row\[1\]\[2\] _0815_ _0280_
+ VPWR VGND sg13g2_mux2_1
XFILLER_12_918 VPWR VGND sg13g2_decap_8
X_4998_ net431 VGND VPWR _0352_ videogen.test_lut_thingy.gol_counter_reg\[3\] net652
+ sg13g2_dfrbpq_1
X_3949_ videogen.test_lut_thingy.pixel_feeder_inst.row\[42\]\[0\] net607 _1612_ VPWR
+ VGND sg13g2_nor2_1
XFILLER_20_940 VPWR VGND sg13g2_decap_4
XFILLER_23_69 VPWR VGND sg13g2_fill_1
X_5311__222 VPWR VGND net222 sg13g2_tiehi
XFILLER_47_837 VPWR VGND sg13g2_decap_8
XFILLER_48_99 VPWR VGND sg13g2_decap_8
XFILLER_46_314 VPWR VGND sg13g2_decap_8
XFILLER_15_712 VPWR VGND sg13g2_decap_4
X_5316__111 VPWR VGND net111 sg13g2_tiehi
XFILLER_15_767 VPWR VGND sg13g2_fill_1
XFILLER_42_597 VPWR VGND sg13g2_decap_8
XFILLER_14_277 VPWR VGND sg13g2_fill_2
XFILLER_14_288 VPWR VGND sg13g2_decap_8
XFILLER_30_726 VPWR VGND sg13g2_fill_2
XFILLER_11_940 VPWR VGND sg13g2_decap_8
XFILLER_31_1006 VPWR VGND sg13g2_fill_1
XFILLER_11_973 VPWR VGND sg13g2_decap_8
XFILLER_7_966 VPWR VGND sg13g2_decap_8
XFILLER_10_494 VPWR VGND sg13g2_fill_1
XFILLER_13_91 VPWR VGND sg13g2_decap_8
XFILLER_9_1007 VPWR VGND sg13g2_decap_8
X_5067__337 VPWR VGND net337 sg13g2_tiehi
XFILLER_2_671 VPWR VGND sg13g2_decap_8
XFILLER_29_5 VPWR VGND sg13g2_fill_1
XFILLER_38_837 VPWR VGND sg13g2_fill_2
XFILLER_37_358 VPWR VGND sg13g2_decap_4
XFILLER_37_347 VPWR VGND sg13g2_fill_2
X_5297__383 VPWR VGND net383 sg13g2_tiehi
X_4921_ net155 VGND VPWR _0275_ videogen.test_lut_thingy.pixel_feeder_inst.row\[20\]\[1\]
+ _0006_ sg13g2_dfrbpq_1
X_4852_ net716 net761 _0209_ VPWR VGND sg13g2_nor2_1
X_3803_ videogen.test_lut_thingy.pixel_feeder_inst.row\[22\]\[1\] net608 _1467_ VPWR
+ VGND sg13g2_nor2_1
XFILLER_21_737 VPWR VGND sg13g2_decap_8
X_4783_ net698 net742 _0140_ VPWR VGND sg13g2_nor2_1
XFILLER_21_748 VPWR VGND sg13g2_fill_1
X_3734_ _1396_ _1397_ _1398_ VPWR VGND sg13g2_nor2_1
XFILLER_9_281 VPWR VGND sg13g2_fill_1
X_3665_ _1329_ _1280_ _1328_ videogen.test_lut_thingy.gol_counter_reg\[3\] _0686_
+ VPWR VGND sg13g2_a22oi_1
Xheichips25_bagel_29 VPWR VGND uio_out[1] sg13g2_tielo
X_3596_ _1256_ _1257_ _1258_ _1259_ _1260_ VPWR VGND sg13g2_nor4_1
X_5266_ net298 VGND VPWR _0616_ serialize.tmds_parallel_b\[5\] net667 sg13g2_dfrbpq_1
X_4217_ _1873_ _1830_ _1874_ VPWR VGND sg13g2_xor2_1
XFILLER_18_14 VPWR VGND sg13g2_fill_2
XFILLER_18_25 VPWR VGND sg13g2_fill_1
XFILLER_28_303 VPWR VGND sg13g2_fill_2
X_5197_ net340 VGND VPWR _0547_ videogen.test_lut_thingy.pixel_feeder_inst.row\[4\]\[3\]
+ _0176_ sg13g2_dfrbpq_1
XFILLER_18_58 VPWR VGND sg13g2_fill_2
X_4148_ _1799_ VPWR _1805_ VGND _1794_ _1796_ sg13g2_o21ai_1
XFILLER_28_336 VPWR VGND sg13g2_decap_8
X_4079_ _1525_ _1624_ _1738_ VPWR VGND sg13g2_nor2_1
XFILLER_34_57 VPWR VGND sg13g2_decap_8
XFILLER_11_236 VPWR VGND sg13g2_fill_1
Xclkload1 VPWR clkload1/Y clknet_3_1_0_clk_regs VGND sg13g2_inv_1
XFILLER_4_925 VPWR VGND sg13g2_decap_8
XFILLER_3_413 VPWR VGND sg13g2_decap_8
XFILLER_3_468 VPWR VGND sg13g2_fill_1
XFILLER_3_446 VPWR VGND sg13g2_decap_8
X_5170__73 VPWR VGND net73 sg13g2_tiehi
XFILLER_47_634 VPWR VGND sg13g2_decap_8
XFILLER_46_122 VPWR VGND sg13g2_decap_4
XFILLER_35_818 VPWR VGND sg13g2_fill_2
XFILLER_11_770 VPWR VGND sg13g2_fill_2
XFILLER_7_730 VPWR VGND sg13g2_decap_8
XFILLER_7_763 VPWR VGND sg13g2_fill_2
XFILLER_7_796 VPWR VGND sg13g2_decap_8
X_3450_ _1114_ _1052_ _1113_ VPWR VGND sg13g2_xnor2_1
X_3381_ videogen.fancy_shader.video_y\[6\] videogen.fancy_shader.shader_counter_reg\[6\]
+ _1045_ VPWR VGND sg13g2_and2_1
X_5120_ net231 VGND VPWR _0470_ videogen.test_lut_thingy.pixel_feeder_inst.row\[58\]\[2\]
+ _0107_ sg13g2_dfrbpq_1
X_5051_ net79 VGND VPWR _0000_ videogen.mem_read net650 sg13g2_dfrbpq_1
X_4002_ _1653_ _1655_ _1661_ _1662_ VPWR VGND sg13g2_nor3_1
XFILLER_38_656 VPWR VGND sg13g2_decap_8
X_4904_ net710 net754 _0259_ VPWR VGND sg13g2_nor2_1
X_4835_ net715 net759 _0192_ VPWR VGND sg13g2_nor2_1
XFILLER_14_1001 VPWR VGND sg13g2_fill_2
XFILLER_21_567 VPWR VGND sg13g2_decap_8
X_4766_ net690 net734 _0123_ VPWR VGND sg13g2_nor2_1
X_3717_ videogen.test_lut_thingy.pixel_feeder_inst.row\[23\]\[2\] net584 _1381_ VPWR
+ VGND sg13g2_nor2_1
X_4697_ net719 net764 _0054_ VPWR VGND sg13g2_nor2_1
X_3648_ videogen.test_lut_thingy.pixel_feeder_inst.row\[16\]\[3\] net590 _1312_ VPWR
+ VGND sg13g2_nor2_1
X_4950__110 VPWR VGND net110 sg13g2_tiehi
X_3579_ _1239_ _1240_ _1241_ _1242_ _1243_ VPWR VGND sg13g2_nor4_1
XFILLER_1_917 VPWR VGND sg13g2_decap_8
X_5318_ net182 VGND VPWR _0668_ serialize.shift_reg_c\[6\] clknet_3_0_0_clk_regs sg13g2_dfrbpq_1
Xhold13 serialize.shift_reg_r\[7\] VPWR VGND net458 sg13g2_dlygate4sd3_1
XFILLER_29_24 VPWR VGND sg13g2_fill_2
Xhold35 _2217_ VPWR VGND net480 sg13g2_dlygate4sd3_1
Xhold24 serialize.shift_reg_b\[2\] VPWR VGND net469 sg13g2_dlygate4sd3_1
XFILLER_29_46 VPWR VGND sg13g2_decap_4
XFILLER_29_68 VPWR VGND sg13g2_decap_8
X_5249_ net43 VGND VPWR _0599_ videogen.test_lut_thingy.pixel_feeder_inst.row\[59\]\[3\]
+ _0228_ sg13g2_dfrbpq_1
XFILLER_21_1027 VPWR VGND sg13g2_fill_2
XFILLER_44_615 VPWR VGND sg13g2_decap_8
XFILLER_28_188 VPWR VGND sg13g2_decap_8
X_5276__242 VPWR VGND net242 sg13g2_tiehi
XFILLER_12_512 VPWR VGND sg13g2_fill_1
XFILLER_24_372 VPWR VGND sg13g2_decap_4
XFILLER_25_873 VPWR VGND sg13g2_decap_4
XFILLER_4_722 VPWR VGND sg13g2_decap_8
XFILLER_3_232 VPWR VGND sg13g2_decap_8
XFILLER_4_799 VPWR VGND sg13g2_decap_8
XFILLER_0_961 VPWR VGND sg13g2_decap_8
XFILLER_48_932 VPWR VGND sg13g2_decap_8
XFILLER_19_111 VPWR VGND sg13g2_fill_2
XFILLER_35_637 VPWR VGND sg13g2_decap_8
XFILLER_37_1001 VPWR VGND sg13g2_decap_4
XFILLER_43_670 VPWR VGND sg13g2_decap_8
XFILLER_37_1023 VPWR VGND sg13g2_decap_4
XFILLER_15_350 VPWR VGND sg13g2_fill_2
XFILLER_15_361 VPWR VGND sg13g2_fill_2
XFILLER_22_309 VPWR VGND sg13g2_fill_1
X_2950_ net790 videogen.test_lut_thingy.pixel_feeder_inst.row\[63\]\[2\] _0794_ _0450_
+ VPWR VGND sg13g2_mux2_1
X_2881_ _0745_ _0747_ _0779_ VPWR VGND sg13g2_nor2_2
X_4620_ _2225_ net670 net470 net676 green_tmds_par\[2\] VPWR VGND sg13g2_a22oi_1
X_4551_ _2178_ _2150_ _2134_ VPWR VGND sg13g2_nand2b_1
XFILLER_7_593 VPWR VGND sg13g2_decap_8
X_4482_ VGND VPWR _2097_ _2115_ _2116_ _2059_ sg13g2_a21oi_1
X_3502_ _1158_ _1165_ _1166_ VPWR VGND sg13g2_nor2_1
X_3433_ _1070_ _1061_ _1097_ VPWR VGND sg13g2_xor2_1
XFILLER_44_1027 VPWR VGND sg13g2_fill_2
X_3364_ _1028_ videogen.fancy_shader.video_y\[4\] videogen.fancy_shader.shader_counter_reg\[4\]
+ VPWR VGND sg13g2_xnor2_1
X_5103_ net265 VGND VPWR _0453_ videogen.test_lut_thingy.pixel_feeder_inst.row\[60\]\[1\]
+ _0090_ sg13g2_dfrbpq_1
XFILLER_32_0 VPWR VGND sg13g2_decap_8
X_3295_ _0971_ _0968_ videogen.fancy_shader.video_y\[3\] _0964_ videogen.fancy_shader.video_y\[2\]
+ VPWR VGND sg13g2_a22oi_1
X_5034_ net386 VGND VPWR _0388_ videogen.test_lut_thingy.pixel_feeder_inst.row\[17\]\[1\]
+ _0034_ sg13g2_dfrbpq_1
XFILLER_26_626 VPWR VGND sg13g2_fill_2
XFILLER_26_648 VPWR VGND sg13g2_decap_8
XFILLER_15_15 VPWR VGND sg13g2_fill_2
XFILLER_22_821 VPWR VGND sg13g2_fill_2
X_4818_ net713 net757 _0175_ VPWR VGND sg13g2_nor2_1
X_4749_ net692 net736 _0106_ VPWR VGND sg13g2_nor2_1
Xoutput14 net14 uo_out[1] VPWR VGND sg13g2_buf_1
XFILLER_0_202 VPWR VGND sg13g2_fill_2
XFILLER_1_714 VPWR VGND sg13g2_decap_8
XFILLER_29_420 VPWR VGND sg13g2_decap_8
XFILLER_29_431 VPWR VGND sg13g2_fill_1
XFILLER_29_442 VPWR VGND sg13g2_decap_4
XFILLER_45_935 VPWR VGND sg13g2_decap_4
XFILLER_29_475 VPWR VGND sg13g2_fill_1
XFILLER_17_659 VPWR VGND sg13g2_decap_4
XFILLER_25_681 VPWR VGND sg13g2_decap_8
XFILLER_40_651 VPWR VGND sg13g2_decap_8
XFILLER_9_803 VPWR VGND sg13g2_decap_8
XFILLER_9_836 VPWR VGND sg13g2_fill_1
XFILLER_12_342 VPWR VGND sg13g2_decap_4
XFILLER_40_695 VPWR VGND sg13g2_fill_1
XFILLER_8_346 VPWR VGND sg13g2_fill_1
X_3080_ VGND VPWR videogen.test_lut_thingy.pixel_feeder_inst.state\[1\] _0821_ _0840_
+ _0839_ sg13g2_a21oi_1
XFILLER_36_902 VPWR VGND sg13g2_fill_1
X_5144__183 VPWR VGND net183 sg13g2_tiehi
X_5292__39 VPWR VGND net39 sg13g2_tiehi
XFILLER_36_957 VPWR VGND sg13g2_fill_1
XFILLER_35_445 VPWR VGND sg13g2_fill_1
X_3982_ _1642_ _1058_ _1636_ VPWR VGND sg13g2_xnor2_1
X_2933_ _0791_ _0731_ _0782_ VPWR VGND sg13g2_nand2_2
X_2864_ videogen.test_lut_thingy.pixel_feeder_inst.row\[28\]\[1\] net803 _0775_ _0525_
+ VPWR VGND sg13g2_mux2_1
X_2795_ net581 net558 _0757_ _0761_ VPWR VGND sg13g2_nor3_2
X_4603_ VPWR _0641_ _2216_ VGND sg13g2_inv_1
X_4534_ _2162_ _2160_ _2161_ _2159_ _2130_ VPWR VGND sg13g2_a22oi_1
XFILLER_11_1015 VPWR VGND sg13g2_decap_8
X_4465_ net622 _2066_ _2077_ _2100_ VPWR VGND sg13g2_nor3_1
X_3416_ VGND VPWR _1080_ videogen.fancy_shader.shader_counter_reg\[7\] videogen.fancy_shader.video_y\[7\]
+ sg13g2_or2_1
X_4396_ _2045_ _2041_ _2001_ _2035_ _2030_ VPWR VGND sg13g2_a22oi_1
Xfanout804 net807 net804 VPWR VGND sg13g2_buf_8
Xfanout815 net817 net815 VPWR VGND sg13g2_buf_8
X_3347_ _1010_ _1006_ _1011_ VPWR VGND sg13g2_xor2_1
X_3278_ _0959_ VPWR _0336_ VGND _0687_ _0957_ sg13g2_o21ai_1
X_5017_ net412 VGND VPWR _0371_ red_tmds_par\[0\] net666 sg13g2_dfrbpq_1
XFILLER_26_401 VPWR VGND sg13g2_fill_1
XFILLER_27_946 VPWR VGND sg13g2_decap_8
XFILLER_26_25 VPWR VGND sg13g2_decap_4
XFILLER_26_47 VPWR VGND sg13g2_decap_4
XFILLER_42_927 VPWR VGND sg13g2_fill_2
XFILLER_26_467 VPWR VGND sg13g2_decap_8
XFILLER_42_79 VPWR VGND sg13g2_fill_1
XFILLER_6_806 VPWR VGND sg13g2_decap_8
XFILLER_1_511 VPWR VGND sg13g2_decap_8
XFILLER_49_537 VPWR VGND sg13g2_decap_8
XFILLER_1_588 VPWR VGND sg13g2_decap_8
XFILLER_18_968 VPWR VGND sg13g2_decap_4
XFILLER_45_776 VPWR VGND sg13g2_fill_2
XFILLER_45_765 VPWR VGND sg13g2_decap_8
XFILLER_44_264 VPWR VGND sg13g2_fill_1
XFILLER_16_80 VPWR VGND sg13g2_fill_1
XFILLER_34_1015 VPWR VGND sg13g2_decap_4
XFILLER_41_993 VPWR VGND sg13g2_decap_8
XFILLER_12_150 VPWR VGND sg13g2_decap_8
XFILLER_9_655 VPWR VGND sg13g2_fill_1
XFILLER_8_187 VPWR VGND sg13g2_fill_1
XFILLER_8_176 VPWR VGND sg13g2_fill_1
XFILLER_5_894 VPWR VGND sg13g2_decap_8
XFILLER_4_371 VPWR VGND sg13g2_decap_8
X_4250_ _1882_ _1906_ _1907_ VPWR VGND sg13g2_and2_1
X_3201_ net648 _0905_ _0906_ VPWR VGND sg13g2_and2_1
X_4181_ _1838_ _1095_ _1836_ VPWR VGND sg13g2_nand2b_1
X_3132_ _0669_ net820 net483 _0867_ VPWR VGND sg13g2_and3_1
X_3063_ _0825_ videogen.test_lut_thingy.pixel_feeder_inst.h_counter\[3\] _0823_ _0824_
+ VPWR VGND sg13g2_and3_1
XFILLER_36_721 VPWR VGND sg13g2_decap_8
X_5077__317 VPWR VGND net317 sg13g2_tiehi
XFILLER_17_990 VPWR VGND sg13g2_decap_4
X_3965_ _0355_ _1626_ _0356_ VPWR VGND sg13g2_and2_1
X_3896_ videogen.test_lut_thingy.pixel_feeder_inst.row\[23\]\[0\] net584 _1559_ VPWR
+ VGND sg13g2_nor2_1
X_2916_ net800 videogen.test_lut_thingy.pixel_feeder_inst.row\[56\]\[1\] _0787_ _0477_
+ VPWR VGND sg13g2_mux2_1
X_2847_ net776 videogen.test_lut_thingy.pixel_feeder_inst.row\[26\]\[3\] _0772_ _0539_
+ VPWR VGND sg13g2_mux2_1
XFILLER_12_27 VPWR VGND sg13g2_decap_8
X_2778_ _0747_ _0755_ _0756_ VPWR VGND sg13g2_nor2_2
X_4517_ VPWR _2145_ _2144_ VGND sg13g2_inv_1
X_4448_ net622 _2067_ _2084_ VPWR VGND sg13g2_nor2_1
Xfanout612 net614 net612 VPWR VGND sg13g2_buf_8
Xfanout601 net609 net601 VPWR VGND sg13g2_buf_8
Xfanout623 green\[0\] net623 VPWR VGND sg13g2_buf_2
X_4379_ _2029_ _2001_ _2024_ VPWR VGND sg13g2_nand2_1
Xfanout656 net657 net656 VPWR VGND sg13g2_buf_8
Xfanout645 videogen.test_lut_thingy.pixel_feeder_inst.h_pix\[2\] net645 VPWR VGND
+ sg13g2_buf_8
Xfanout634 videogen.test_lut_thingy.pixel_feeder_inst.h_pix\[5\] net634 VPWR VGND
+ sg13g2_buf_8
Xfanout667 net668 net667 VPWR VGND sg13g2_buf_8
Xfanout689 net691 net689 VPWR VGND sg13g2_buf_8
Xfanout678 net679 net678 VPWR VGND sg13g2_buf_1
XFILLER_46_518 VPWR VGND sg13g2_fill_2
XFILLER_42_702 VPWR VGND sg13g2_decap_8
X_5158__105 VPWR VGND net105 sg13g2_tiehi
XFILLER_41_223 VPWR VGND sg13g2_fill_2
XFILLER_14_437 VPWR VGND sg13g2_decap_4
XFILLER_10_654 VPWR VGND sg13g2_decap_4
XFILLER_6_625 VPWR VGND sg13g2_decap_4
XFILLER_6_614 VPWR VGND sg13g2_decap_8
XFILLER_5_168 VPWR VGND sg13g2_fill_2
XFILLER_5_157 VPWR VGND sg13g2_fill_1
XFILLER_2_853 VPWR VGND sg13g2_decap_8
XFILLER_49_334 VPWR VGND sg13g2_decap_8
XFILLER_37_507 VPWR VGND sg13g2_fill_2
XFILLER_49_367 VPWR VGND sg13g2_decap_8
XFILLER_17_242 VPWR VGND sg13g2_fill_1
XFILLER_18_787 VPWR VGND sg13g2_fill_1
XFILLER_27_90 VPWR VGND sg13g2_decap_8
XFILLER_18_798 VPWR VGND sg13g2_fill_1
XFILLER_21_919 VPWR VGND sg13g2_decap_8
XFILLER_33_779 VPWR VGND sg13g2_decap_4
XFILLER_14_993 VPWR VGND sg13g2_fill_2
XFILLER_20_418 VPWR VGND sg13g2_fill_1
X_3750_ net647 VPWR _1414_ VGND videogen.test_lut_thingy.pixel_feeder_inst.row\[4\]\[2\]
+ net596 sg13g2_o21ai_1
X_2701_ _0719_ net619 _0718_ VPWR VGND sg13g2_nand2_2
X_3681_ videogen.test_lut_thingy.pixel_feeder_inst.row\[46\]\[2\] net607 _1345_ VPWR
+ VGND sg13g2_nor2_1
X_5282_ net194 VGND VPWR _0632_ videogen.test_lut_thingy.pixel_feeder_inst.row\[23\]\[2\]
+ _0251_ sg13g2_dfrbpq_1
X_4302_ _1951_ VPWR _1954_ VGND _1952_ _1953_ sg13g2_o21ai_1
XFILLER_4_61 VPWR VGND sg13g2_fill_1
X_4233_ _1890_ _1172_ _1715_ VPWR VGND sg13g2_nand2_1
X_4164_ _1813_ _1819_ _1172_ _1821_ VPWR VGND _1820_ sg13g2_nand4_1
X_3115_ _0863_ _0861_ _0862_ VPWR VGND sg13g2_nand2_1
X_4095_ _1097_ _1751_ _1752_ VPWR VGND sg13g2_nor2_2
X_3046_ net777 videogen.test_lut_thingy.pixel_feeder_inst.row\[1\]\[3\] _0815_ _0281_
+ VPWR VGND sg13g2_mux2_1
XFILLER_24_702 VPWR VGND sg13g2_fill_2
XFILLER_23_289 VPWR VGND sg13g2_fill_1
X_4997_ net432 VGND VPWR _0351_ videogen.test_lut_thingy.gol_counter_reg\[2\] net652
+ sg13g2_dfrbpq_1
X_3948_ videogen.test_lut_thingy.pixel_feeder_inst.row\[40\]\[0\] net598 _1611_ VPWR
+ VGND sg13g2_nor2_1
X_3879_ videogen.test_lut_thingy.pixel_feeder_inst.row\[8\]\[0\] net589 _1542_ VPWR
+ VGND sg13g2_nor2_1
XFILLER_2_116 VPWR VGND sg13g2_fill_2
XFILLER_24_1025 VPWR VGND sg13g2_decap_4
XFILLER_47_816 VPWR VGND sg13g2_decap_8
XFILLER_42_521 VPWR VGND sg13g2_fill_1
XFILLER_42_510 VPWR VGND sg13g2_decap_8
XFILLER_10_440 VPWR VGND sg13g2_decap_4
XFILLER_7_945 VPWR VGND sg13g2_decap_8
XFILLER_10_473 VPWR VGND sg13g2_decap_8
XFILLER_6_488 VPWR VGND sg13g2_fill_2
XFILLER_2_650 VPWR VGND sg13g2_decap_8
XFILLER_49_175 VPWR VGND sg13g2_decap_4
XFILLER_49_197 VPWR VGND sg13g2_decap_8
X_5258__346 VPWR VGND net346 sg13g2_tiehi
X_4920_ net157 VGND VPWR _0274_ videogen.test_lut_thingy.pixel_feeder_inst.row\[20\]\[0\]
+ _0005_ sg13g2_dfrbpq_1
X_4851_ net702 net746 _0208_ VPWR VGND sg13g2_nor2_1
XFILLER_33_543 VPWR VGND sg13g2_decap_8
X_3802_ videogen.test_lut_thingy.pixel_feeder_inst.row\[23\]\[1\] net584 _1466_ VPWR
+ VGND sg13g2_nor2_1
XFILLER_21_716 VPWR VGND sg13g2_fill_1
X_4782_ net697 net741 _0139_ VPWR VGND sg13g2_nor2_1
X_3733_ videogen.test_lut_thingy.pixel_feeder_inst.row\[31\]\[2\] net578 _1397_ VPWR
+ VGND sg13g2_nor2_1
X_3664_ _0686_ _1327_ _1328_ VPWR VGND sg13g2_nor2_1
X_3595_ videogen.test_lut_thingy.pixel_feeder_inst.row\[45\]\[3\] net575 _1259_ VPWR
+ VGND sg13g2_nor2_1
X_5164__93 VPWR VGND net93 sg13g2_tiehi
X_5265_ net302 VGND VPWR _0615_ serialize.tmds_parallel_b\[3\] net667 sg13g2_dfrbpq_1
X_4216_ _1862_ VPWR _1873_ VGND _1869_ _1871_ sg13g2_o21ai_1
X_5196_ net344 VGND VPWR _0546_ videogen.test_lut_thingy.pixel_feeder_inst.row\[4\]\[2\]
+ _0175_ sg13g2_dfrbpq_1
X_4147_ _1788_ _1791_ _1804_ VPWR VGND sg13g2_nor2_1
XFILLER_29_827 VPWR VGND sg13g2_fill_1
XFILLER_18_37 VPWR VGND sg13g2_decap_8
X_4078_ _0360_ _1733_ _1737_ VPWR VGND sg13g2_nand2_1
X_3029_ videogen.test_lut_thingy.pixel_feeder_inst.row\[13\]\[0\] net814 _0811_ _0376_
+ VPWR VGND sg13g2_mux2_1
XFILLER_12_738 VPWR VGND sg13g2_decap_8
XFILLER_12_749 VPWR VGND sg13g2_fill_2
Xclkload2 VPWR clkload2/Y clknet_3_3_0_clk_regs VGND sg13g2_inv_1
XFILLER_4_904 VPWR VGND sg13g2_decap_8
XFILLER_47_613 VPWR VGND sg13g2_decap_8
XFILLER_43_863 VPWR VGND sg13g2_fill_2
XFILLER_27_381 VPWR VGND sg13g2_fill_1
X_5103__265 VPWR VGND net265 sg13g2_tiehi
XFILLER_24_80 VPWR VGND sg13g2_decap_8
XFILLER_7_775 VPWR VGND sg13g2_decap_8
XFILLER_40_90 VPWR VGND sg13g2_decap_8
XFILLER_6_296 VPWR VGND sg13g2_fill_2
X_3380_ _1044_ _1035_ _1043_ VPWR VGND sg13g2_xnor2_1
X_5050_ net177 VGND VPWR _0003_ videogen.test_lut_thingy.pixel_feeder_inst.state\[1\]
+ net650 sg13g2_dfrbpq_1
X_4001_ _1661_ _1638_ _1659_ VPWR VGND sg13g2_nand2_1
XFILLER_38_635 VPWR VGND sg13g2_decap_8
XFILLER_37_101 VPWR VGND sg13g2_fill_1
XFILLER_37_178 VPWR VGND sg13g2_decap_4
XFILLER_1_84 VPWR VGND sg13g2_fill_2
XFILLER_18_370 VPWR VGND sg13g2_fill_2
X_4903_ net711 net754 _0258_ VPWR VGND sg13g2_nor2_1
XFILLER_34_830 VPWR VGND sg13g2_decap_4
XFILLER_33_373 VPWR VGND sg13g2_fill_2
X_4834_ net716 net760 _0191_ VPWR VGND sg13g2_nor2_1
X_4765_ net689 net733 _0122_ VPWR VGND sg13g2_nor2_1
X_3716_ videogen.test_lut_thingy.pixel_feeder_inst.row\[22\]\[2\] net608 _1380_ VPWR
+ VGND sg13g2_nor2_1
X_4696_ net719 net764 _0053_ VPWR VGND sg13g2_nor2_1
X_3647_ videogen.test_lut_thingy.pixel_feeder_inst.row\[19\]\[3\] net577 _1311_ VPWR
+ VGND sg13g2_nor2_1
X_3578_ videogen.test_lut_thingy.pixel_feeder_inst.row\[49\]\[3\] net570 _1242_ VPWR
+ VGND sg13g2_nor2_1
X_5317_ net198 VGND VPWR _0667_ serialize.shift_reg_c\[5\] clknet_3_0_0_clk_regs sg13g2_dfrbpq_1
XFILLER_0_428 VPWR VGND sg13g2_decap_4
Xhold14 serialize.shift_reg_g\[9\] VPWR VGND net459 sg13g2_dlygate4sd3_1
Xhold36 clockdiv.q0 VPWR VGND net481 sg13g2_dlygate4sd3_1
Xhold25 serialize.shift_reg_g\[6\] VPWR VGND net470 sg13g2_dlygate4sd3_1
X_5248_ net51 VGND VPWR _0598_ videogen.test_lut_thingy.pixel_feeder_inst.row\[59\]\[2\]
+ _0227_ sg13g2_dfrbpq_1
X_5179_ net37 VGND VPWR _0529_ videogen.test_lut_thingy.pixel_feeder_inst.row\[27\]\[1\]
+ _0158_ sg13g2_dfrbpq_1
XFILLER_45_24 VPWR VGND sg13g2_decap_8
XFILLER_16_307 VPWR VGND sg13g2_fill_2
XFILLER_28_167 VPWR VGND sg13g2_decap_4
XFILLER_25_830 VPWR VGND sg13g2_decap_8
XFILLER_40_899 VPWR VGND sg13g2_fill_1
XFILLER_4_701 VPWR VGND sg13g2_decap_8
XFILLER_4_778 VPWR VGND sg13g2_decap_8
XFILLER_0_940 VPWR VGND sg13g2_decap_8
XFILLER_48_911 VPWR VGND sg13g2_decap_8
XFILLER_48_988 VPWR VGND sg13g2_decap_8
XFILLER_47_487 VPWR VGND sg13g2_decap_8
XFILLER_28_690 VPWR VGND sg13g2_fill_2
X_5040__374 VPWR VGND net374 sg13g2_tiehi
X_2880_ videogen.test_lut_thingy.pixel_feeder_inst.row\[52\]\[0\] net811 _0778_ _0504_
+ VPWR VGND sg13g2_mux2_1
X_4957__96 VPWR VGND net96 sg13g2_tiehi
XFILLER_30_387 VPWR VGND sg13g2_fill_1
X_4550_ VGND VPWR _2175_ _2176_ _2177_ _2170_ sg13g2_a21oi_1
X_4972__66 VPWR VGND net66 sg13g2_tiehi
X_4481_ _2115_ _2112_ _2114_ VPWR VGND sg13g2_xnor2_1
X_3501_ _1165_ _1164_ _1001_ VPWR VGND sg13g2_nand2b_1
X_3432_ VGND VPWR _1058_ _1096_ _1093_ _1092_ sg13g2_a21oi_2
X_3363_ _1027_ videogen.fancy_shader.video_y\[4\] net631 VPWR VGND sg13g2_nand2_1
X_5102_ net267 VGND VPWR _0452_ videogen.test_lut_thingy.pixel_feeder_inst.row\[60\]\[0\]
+ _0089_ sg13g2_dfrbpq_1
X_3294_ _0969_ _0970_ _0341_ VPWR VGND sg13g2_nor2_1
X_5033_ net388 VGND VPWR _0387_ videogen.test_lut_thingy.pixel_feeder_inst.row\[17\]\[0\]
+ _0033_ sg13g2_dfrbpq_1
XFILLER_39_988 VPWR VGND sg13g2_decap_4
XFILLER_38_454 VPWR VGND sg13g2_decap_4
XFILLER_38_443 VPWR VGND sg13g2_fill_1
XFILLER_38_498 VPWR VGND sg13g2_decap_8
XFILLER_38_476 VPWR VGND sg13g2_decap_8
XFILLER_41_619 VPWR VGND sg13g2_decap_8
XFILLER_34_682 VPWR VGND sg13g2_decap_4
XFILLER_22_866 VPWR VGND sg13g2_decap_8
XFILLER_22_877 VPWR VGND sg13g2_fill_2
XFILLER_22_888 VPWR VGND sg13g2_decap_8
X_4817_ net718 net762 _0174_ VPWR VGND sg13g2_nor2_1
XFILLER_21_376 VPWR VGND sg13g2_fill_2
X_4748_ net695 net739 _0105_ VPWR VGND sg13g2_nor2_1
X_4679_ net688 net732 _0036_ VPWR VGND sg13g2_nor2_1
Xoutput15 net15 uo_out[2] VPWR VGND sg13g2_buf_1
XFILLER_49_719 VPWR VGND sg13g2_decap_8
XFILLER_45_947 VPWR VGND sg13g2_decap_8
XFILLER_45_914 VPWR VGND sg13g2_decap_8
XFILLER_29_487 VPWR VGND sg13g2_fill_2
XFILLER_40_630 VPWR VGND sg13g2_decap_8
XFILLER_12_387 VPWR VGND sg13g2_decap_8
XFILLER_13_888 VPWR VGND sg13g2_decap_4
XFILLER_48_785 VPWR VGND sg13g2_decap_8
X_3981_ _1641_ _1638_ _1640_ VPWR VGND sg13g2_nand2_1
XFILLER_22_107 VPWR VGND sg13g2_decap_8
XFILLER_44_991 VPWR VGND sg13g2_fill_2
X_2932_ net813 videogen.test_lut_thingy.pixel_feeder_inst.row\[7\]\[0\] _0790_ _0464_
+ VPWR VGND sg13g2_mux2_1
XFILLER_31_641 VPWR VGND sg13g2_decap_4
XFILLER_31_663 VPWR VGND sg13g2_decap_4
X_2863_ videogen.test_lut_thingy.pixel_feeder_inst.row\[28\]\[2\] net792 _0775_ _0526_
+ VPWR VGND sg13g2_mux2_1
X_2794_ net580 net558 _0760_ VPWR VGND sg13g2_nor2_2
X_4602_ _2216_ net673 net466 net679 serialize.tmds_parallel_b\[3\] VPWR VGND sg13g2_a22oi_1
X_4533_ VGND VPWR net625 _2149_ _2161_ _2130_ sg13g2_a21oi_1
X_4464_ VGND VPWR _2097_ _2098_ _2099_ _2059_ sg13g2_a21oi_1
X_3415_ videogen.fancy_shader.video_y\[7\] videogen.fancy_shader.shader_counter_reg\[7\]
+ _1079_ VPWR VGND sg13g2_and2_1
X_4395_ _2044_ _1983_ _2043_ VPWR VGND sg13g2_nand2_1
Xfanout805 net807 net805 VPWR VGND sg13g2_buf_8
Xfanout816 net817 net816 VPWR VGND sg13g2_buf_8
X_3346_ _1010_ _1007_ _1009_ VPWR VGND sg13g2_xnor2_1
XFILLER_39_763 VPWR VGND sg13g2_decap_8
X_5016_ net413 VGND VPWR _0370_ tmds_red.dc_balancing_reg\[4\] net661 sg13g2_dfrbpq_2
X_3277_ videogen.fancy_shader.shader_counter_reg\[8\] _0936_ _0687_ _0959_ VPWR VGND
+ _0953_ sg13g2_nand4_1
XFILLER_26_435 VPWR VGND sg13g2_decap_8
XFILLER_22_652 VPWR VGND sg13g2_decap_4
XFILLER_1_567 VPWR VGND sg13g2_decap_8
XFILLER_49_516 VPWR VGND sg13g2_decap_8
XFILLER_45_744 VPWR VGND sg13g2_decap_8
XFILLER_17_446 VPWR VGND sg13g2_fill_1
X_4924__149 VPWR VGND net149 sg13g2_tiehi
XFILLER_17_468 VPWR VGND sg13g2_decap_4
XFILLER_45_799 VPWR VGND sg13g2_decap_4
XFILLER_44_276 VPWR VGND sg13g2_decap_8
XFILLER_33_939 VPWR VGND sg13g2_fill_1
XFILLER_41_983 VPWR VGND sg13g2_fill_1
XFILLER_41_972 VPWR VGND sg13g2_decap_8
XFILLER_9_634 VPWR VGND sg13g2_decap_4
XFILLER_40_493 VPWR VGND sg13g2_fill_1
XFILLER_12_173 VPWR VGND sg13g2_fill_1
XFILLER_5_873 VPWR VGND sg13g2_decap_8
X_3200_ _0903_ _0904_ _0905_ VPWR VGND sg13g2_nor2_1
X_4180_ _1837_ _1094_ _1836_ VPWR VGND sg13g2_nand2_1
X_3131_ net485 net452 _0867_ VPWR VGND sg13g2_nor2_1
X_3062_ videogen.test_lut_thingy.pixel_feeder_inst.h_counter\[2\] videogen.test_lut_thingy.pixel_feeder_inst.h_counter\[1\]
+ _0824_ VPWR VGND sg13g2_nor2_1
XFILLER_48_582 VPWR VGND sg13g2_decap_8
XFILLER_35_221 VPWR VGND sg13g2_decap_8
XFILLER_24_928 VPWR VGND sg13g2_fill_2
XFILLER_24_939 VPWR VGND sg13g2_fill_2
XFILLER_32_961 VPWR VGND sg13g2_fill_2
X_3964_ _0355_ _1625_ _0357_ VPWR VGND sg13g2_and2_1
X_3895_ videogen.test_lut_thingy.pixel_feeder_inst.row\[21\]\[0\] net576 _1558_ VPWR
+ VGND sg13g2_nor2_1
XFILLER_32_994 VPWR VGND sg13g2_fill_2
X_2915_ net789 videogen.test_lut_thingy.pixel_feeder_inst.row\[56\]\[2\] _0787_ _0478_
+ VPWR VGND sg13g2_mux2_1
X_2846_ _0772_ _0732_ _0760_ VPWR VGND sg13g2_nand2_2
X_2777_ _0712_ _0753_ net619 _0755_ VPWR VGND sg13g2_nand3_1
X_4516_ _2144_ tmds_blue.dc_balancing_reg\[2\] _2142_ VPWR VGND sg13g2_xnor2_1
X_4447_ _2081_ _2082_ _2083_ VPWR VGND sg13g2_nor2b_1
Xfanout602 net603 net602 VPWR VGND sg13g2_buf_8
Xfanout613 net614 net613 VPWR VGND sg13g2_buf_1
Xfanout624 net625 net624 VPWR VGND sg13g2_buf_8
X_4947__116 VPWR VGND net116 sg13g2_tiehi
Xfanout657 net658 net657 VPWR VGND sg13g2_buf_8
X_4378_ _2028_ _2025_ _2027_ _2019_ _1982_ VPWR VGND sg13g2_a22oi_1
Xfanout646 videogen.test_lut_thingy.pixel_feeder_inst.h_pix\[2\] net646 VPWR VGND
+ sg13g2_buf_8
Xfanout635 videogen.test_lut_thingy.pixel_feeder_inst.h_pix\[5\] net635 VPWR VGND
+ sg13g2_buf_8
Xfanout679 net680 net679 VPWR VGND sg13g2_buf_8
Xfanout668 net669 net668 VPWR VGND sg13g2_buf_8
X_3329_ net632 videogen.fancy_shader.video_x\[1\] _0993_ VPWR VGND sg13g2_xor2_1
XFILLER_37_58 VPWR VGND sg13g2_fill_2
XFILLER_2_1014 VPWR VGND sg13g2_decap_8
XFILLER_27_733 VPWR VGND sg13g2_fill_1
XFILLER_42_736 VPWR VGND sg13g2_decap_4
XFILLER_42_725 VPWR VGND sg13g2_fill_1
XFILLER_41_202 VPWR VGND sg13g2_decap_8
XFILLER_26_276 VPWR VGND sg13g2_decap_8
XFILLER_26_287 VPWR VGND sg13g2_decap_8
XFILLER_26_298 VPWR VGND sg13g2_fill_1
XFILLER_10_622 VPWR VGND sg13g2_fill_2
XFILLER_22_482 VPWR VGND sg13g2_fill_2
XFILLER_5_103 VPWR VGND sg13g2_fill_1
XFILLER_10_666 VPWR VGND sg13g2_fill_2
XFILLER_10_699 VPWR VGND sg13g2_fill_1
XFILLER_2_832 VPWR VGND sg13g2_decap_8
XFILLER_49_324 VPWR VGND sg13g2_decap_4
XFILLER_18_700 VPWR VGND sg13g2_fill_1
XFILLER_18_733 VPWR VGND sg13g2_decap_8
XFILLER_18_744 VPWR VGND sg13g2_fill_1
XFILLER_17_254 VPWR VGND sg13g2_decap_8
XFILLER_33_703 VPWR VGND sg13g2_fill_1
XFILLER_14_983 VPWR VGND sg13g2_decap_4
XFILLER_41_791 VPWR VGND sg13g2_decap_8
X_2700_ _0718_ _0676_ _0710_ VPWR VGND sg13g2_xnor2_1
X_3680_ videogen.test_lut_thingy.pixel_feeder_inst.row\[45\]\[2\] net575 _1344_ VPWR
+ VGND sg13g2_nor2_1
X_5113__245 VPWR VGND net245 sg13g2_tiehi
X_5281_ net202 VGND VPWR _0631_ videogen.test_lut_thingy.pixel_feeder_inst.row\[23\]\[1\]
+ _0250_ sg13g2_dfrbpq_1
X_4301_ _1953_ red\[6\] _1947_ VPWR VGND sg13g2_xnor2_1
X_4232_ _1885_ VPWR _1889_ VGND _1881_ _1888_ sg13g2_o21ai_1
X_4163_ VGND VPWR _1820_ _1817_ _1742_ sg13g2_or2_1
X_3114_ _0858_ videogen.test_lut_thingy.pixel_feeder_inst.v_pix\[3\] videogen.test_lut_thingy.pixel_feeder_inst.v_pix\[4\]
+ _0862_ VPWR VGND sg13g2_a21o_1
X_4094_ _1751_ _1066_ _1747_ VPWR VGND sg13g2_nand2_2
XFILLER_49_880 VPWR VGND sg13g2_decap_8
X_3045_ _0815_ _0735_ _0754_ VPWR VGND sg13g2_nand2_2
XFILLER_36_585 VPWR VGND sg13g2_decap_8
X_4996_ net433 VGND VPWR _0350_ videogen.test_lut_thingy.gol_counter_reg\[1\] net652
+ sg13g2_dfrbpq_2
X_3947_ net642 VPWR _1610_ VGND videogen.test_lut_thingy.pixel_feeder_inst.row\[43\]\[0\]
+ net586 sg13g2_o21ai_1
XFILLER_20_953 VPWR VGND sg13g2_decap_8
X_3878_ videogen.test_lut_thingy.pixel_feeder_inst.row\[9\]\[0\] net568 _1541_ VPWR
+ VGND sg13g2_nor2_1
X_2829_ videogen.test_lut_thingy.pixel_feeder_inst.row\[47\]\[1\] net806 _0768_ _0553_
+ VPWR VGND sg13g2_mux2_1
XFILLER_3_8 VPWR VGND sg13g2_decap_8
XFILLER_48_35 VPWR VGND sg13g2_fill_2
XFILLER_24_1004 VPWR VGND sg13g2_decap_8
XFILLER_27_552 VPWR VGND sg13g2_decap_8
XFILLER_14_235 VPWR VGND sg13g2_decap_4
XFILLER_14_268 VPWR VGND sg13g2_fill_2
XFILLER_14_279 VPWR VGND sg13g2_fill_1
XFILLER_11_920 VPWR VGND sg13g2_decap_8
XFILLER_23_780 VPWR VGND sg13g2_decap_4
XFILLER_7_924 VPWR VGND sg13g2_decap_8
XFILLER_13_60 VPWR VGND sg13g2_fill_2
X_5173__61 VPWR VGND net61 sg13g2_tiehi
XFILLER_49_154 VPWR VGND sg13g2_decap_8
XFILLER_38_839 VPWR VGND sg13g2_fill_1
XFILLER_38_806 VPWR VGND sg13g2_fill_2
XFILLER_37_349 VPWR VGND sg13g2_fill_1
XFILLER_18_541 VPWR VGND sg13g2_decap_8
XFILLER_46_883 VPWR VGND sg13g2_decap_8
XFILLER_33_511 VPWR VGND sg13g2_fill_2
X_4850_ net717 net761 _0207_ VPWR VGND sg13g2_nor2_1
X_3801_ videogen.test_lut_thingy.pixel_feeder_inst.row\[20\]\[1\] net595 _1465_ VPWR
+ VGND sg13g2_nor2_1
X_4781_ net696 net739 _0138_ VPWR VGND sg13g2_nor2_1
X_3732_ videogen.test_lut_thingy.pixel_feeder_inst.row\[28\]\[2\] net594 _1396_ VPWR
+ VGND sg13g2_nor2_1
X_3663_ net635 _1303_ _1326_ _1327_ VPWR VGND sg13g2_nor3_1
X_3594_ videogen.test_lut_thingy.pixel_feeder_inst.row\[46\]\[3\] net607 _1258_ VPWR
+ VGND sg13g2_nor2_1
XFILLER_47_1026 VPWR VGND sg13g2_fill_2
X_5264_ net306 VGND VPWR _0614_ blue_tmds_par\[2\] net663 sg13g2_dfrbpq_1
X_4215_ _1852_ _1870_ _1830_ _1872_ VPWR VGND sg13g2_nand3_1
X_5195_ net357 VGND VPWR _0545_ videogen.test_lut_thingy.pixel_feeder_inst.row\[4\]\[1\]
+ _0174_ sg13g2_dfrbpq_1
XFILLER_18_16 VPWR VGND sg13g2_fill_1
X_4146_ _1795_ VPWR _1803_ VGND _1788_ _1800_ sg13g2_o21ai_1
X_4077_ _1736_ VPWR _1737_ VGND _1330_ _1429_ sg13g2_o21ai_1
X_3028_ videogen.test_lut_thingy.pixel_feeder_inst.row\[13\]\[1\] net803 _0811_ _0377_
+ VPWR VGND sg13g2_mux2_1
X_4979_ net52 VGND VPWR _0333_ videogen.fancy_shader.shader_counter_reg\[6\] net658
+ sg13g2_dfrbpq_2
Xclkload3 VPWR clkload3/Y clknet_3_5_0_clk_regs VGND sg13g2_inv_1
X_5235__188 VPWR VGND net188 sg13g2_tiehi
X_5242__115 VPWR VGND net115 sg13g2_tiehi
XFILLER_19_316 VPWR VGND sg13g2_fill_2
XFILLER_47_669 VPWR VGND sg13g2_decap_8
XFILLER_46_157 VPWR VGND sg13g2_fill_2
XFILLER_43_820 VPWR VGND sg13g2_decap_8
XFILLER_43_831 VPWR VGND sg13g2_fill_1
XFILLER_42_363 VPWR VGND sg13g2_fill_2
XFILLER_42_352 VPWR VGND sg13g2_decap_8
XFILLER_15_566 VPWR VGND sg13g2_decap_8
XFILLER_15_577 VPWR VGND sg13g2_decap_4
X_4969__72 VPWR VGND net72 sg13g2_tiehi
XFILLER_42_396 VPWR VGND sg13g2_decap_8
XFILLER_15_599 VPWR VGND sg13g2_fill_1
X_4984__42 VPWR VGND net42 sg13g2_tiehi
XFILLER_3_993 VPWR VGND sg13g2_decap_8
XFILLER_38_614 VPWR VGND sg13g2_decap_8
X_4000_ _1652_ _1638_ _1640_ _1660_ VPWR VGND sg13g2_a21o_1
XFILLER_27_4 VPWR VGND sg13g2_fill_2
XFILLER_37_113 VPWR VGND sg13g2_decap_4
XFILLER_1_63 VPWR VGND sg13g2_decap_8
XFILLER_26_809 VPWR VGND sg13g2_fill_1
XFILLER_46_680 VPWR VGND sg13g2_decap_8
XFILLER_37_168 VPWR VGND sg13g2_decap_4
XFILLER_19_894 VPWR VGND sg13g2_fill_1
X_4902_ net710 net754 _0257_ VPWR VGND sg13g2_nor2_1
XFILLER_33_341 VPWR VGND sg13g2_fill_2
X_4833_ net715 net759 _0190_ VPWR VGND sg13g2_nor2_1
XFILLER_34_897 VPWR VGND sg13g2_fill_2
X_4764_ net690 net734 _0121_ VPWR VGND sg13g2_nor2_1
X_3715_ net646 VPWR _1379_ VGND videogen.test_lut_thingy.pixel_feeder_inst.row\[20\]\[2\]
+ net595 sg13g2_o21ai_1
X_4695_ net720 net766 _0052_ VPWR VGND sg13g2_nor2_1
X_3646_ videogen.test_lut_thingy.pixel_feeder_inst.row\[17\]\[3\] net568 _1310_ VPWR
+ VGND sg13g2_nor2_1
X_3577_ videogen.test_lut_thingy.pixel_feeder_inst.row\[51\]\[3\] net579 _1241_ VPWR
+ VGND sg13g2_nor2_1
X_5316_ net111 VGND VPWR _0666_ videogen.test_lut_thingy.pixel_feeder_inst.row\[21\]\[3\]
+ _0260_ sg13g2_dfrbpq_1
XFILLER_0_407 VPWR VGND sg13g2_decap_8
X_5247_ net59 VGND VPWR _0597_ videogen.test_lut_thingy.pixel_feeder_inst.row\[59\]\[1\]
+ _0226_ sg13g2_dfrbpq_1
Xhold37 serialize.shift_reg_c\[8\] VPWR VGND net482 sg13g2_dlygate4sd3_1
Xhold15 serialize.shift_reg_b\[3\] VPWR VGND net460 sg13g2_dlygate4sd3_1
XFILLER_29_37 VPWR VGND sg13g2_fill_2
Xhold26 serialize.shift_reg_g\[3\] VPWR VGND net471 sg13g2_dlygate4sd3_1
X_5178_ net41 VGND VPWR _0528_ videogen.test_lut_thingy.pixel_feeder_inst.row\[27\]\[0\]
+ _0157_ sg13g2_dfrbpq_1
XFILLER_28_113 VPWR VGND sg13g2_fill_2
X_4129_ _1776_ VPWR _1786_ VGND _1782_ _1784_ sg13g2_o21ai_1
XFILLER_28_146 VPWR VGND sg13g2_decap_8
XFILLER_29_669 VPWR VGND sg13g2_fill_2
XFILLER_37_691 VPWR VGND sg13g2_decap_8
XFILLER_12_503 VPWR VGND sg13g2_fill_2
XFILLER_40_856 VPWR VGND sg13g2_decap_4
XFILLER_6_19 VPWR VGND sg13g2_decap_8
XFILLER_4_757 VPWR VGND sg13g2_decap_8
XFILLER_3_289 VPWR VGND sg13g2_fill_2
XFILLER_0_996 VPWR VGND sg13g2_decap_8
XFILLER_19_102 VPWR VGND sg13g2_fill_1
XFILLER_48_967 VPWR VGND sg13g2_decap_8
XFILLER_19_124 VPWR VGND sg13g2_fill_1
XFILLER_34_138 VPWR VGND sg13g2_decap_8
XFILLER_15_352 VPWR VGND sg13g2_fill_1
XFILLER_15_363 VPWR VGND sg13g2_fill_1
XFILLER_42_182 VPWR VGND sg13g2_fill_2
XFILLER_15_385 VPWR VGND sg13g2_decap_8
XFILLER_16_897 VPWR VGND sg13g2_fill_1
XFILLER_30_333 VPWR VGND sg13g2_fill_2
XFILLER_30_344 VPWR VGND sg13g2_fill_2
X_3500_ _1161_ _1163_ _1160_ _1164_ VPWR VGND sg13g2_nand3_1
X_4480_ _2114_ tmds_green.dc_balancing_reg\[4\] _2113_ VPWR VGND sg13g2_xnor2_1
X_3431_ _1095_ _1090_ _1091_ VPWR VGND sg13g2_nand2_2
X_3362_ VPWR VGND _1007_ _1023_ _1025_ _1008_ _1026_ _1022_ sg13g2_a221oi_1
XFILLER_3_790 VPWR VGND sg13g2_decap_8
X_5101_ net269 VGND VPWR _0451_ videogen.test_lut_thingy.pixel_feeder_inst.row\[63\]\[3\]
+ _0088_ sg13g2_dfrbpq_1
X_3293_ _0970_ videogen.fancy_shader.video_y\[2\] _0964_ VPWR VGND sg13g2_xnor2_1
XFILLER_38_422 VPWR VGND sg13g2_fill_2
X_5032_ net389 VGND VPWR _0386_ green_tmds_par\[7\] net665 sg13g2_dfrbpq_1
XFILLER_15_28 VPWR VGND sg13g2_decap_8
XFILLER_18_190 VPWR VGND sg13g2_decap_4
XFILLER_22_823 VPWR VGND sg13g2_fill_1
XFILLER_22_856 VPWR VGND sg13g2_fill_2
X_4816_ net713 net757 _0173_ VPWR VGND sg13g2_nor2_1
X_4747_ net714 net758 _0104_ VPWR VGND sg13g2_nor2_1
X_4678_ net687 net731 _0035_ VPWR VGND sg13g2_nor2_1
X_3629_ videogen.test_lut_thingy.pixel_feeder_inst.row\[12\]\[3\] net594 _1293_ VPWR
+ VGND sg13g2_nor2_1
Xoutput16 net16 uo_out[3] VPWR VGND sg13g2_buf_1
XFILLER_0_226 VPWR VGND sg13g2_fill_2
XFILLER_0_215 VPWR VGND sg13g2_decap_8
XFILLER_1_749 VPWR VGND sg13g2_decap_8
XFILLER_17_617 VPWR VGND sg13g2_fill_2
XFILLER_16_138 VPWR VGND sg13g2_fill_2
XFILLER_17_639 VPWR VGND sg13g2_fill_2
XFILLER_44_469 VPWR VGND sg13g2_decap_4
XFILLER_13_823 VPWR VGND sg13g2_fill_1
XFILLER_40_686 VPWR VGND sg13g2_decap_8
X_5185__400 VPWR VGND net400 sg13g2_tiehi
XFILLER_4_565 VPWR VGND sg13g2_decap_8
XFILLER_48_764 VPWR VGND sg13g2_decap_8
XFILLER_0_793 VPWR VGND sg13g2_decap_8
XFILLER_47_241 VPWR VGND sg13g2_decap_8
XFILLER_47_285 VPWR VGND sg13g2_decap_4
X_3980_ _1639_ _1099_ _1640_ VPWR VGND sg13g2_xor2_1
XFILLER_16_650 VPWR VGND sg13g2_decap_4
XFILLER_16_694 VPWR VGND sg13g2_fill_2
X_2931_ net803 videogen.test_lut_thingy.pixel_feeder_inst.row\[7\]\[1\] _0790_ _0465_
+ VPWR VGND sg13g2_mux2_1
Xclkbuf_0_clk clk clknet_0_clk VPWR VGND sg13g2_buf_8
X_4601_ VPWR _0640_ _2215_ VGND sg13g2_inv_1
X_2862_ videogen.test_lut_thingy.pixel_feeder_inst.row\[28\]\[3\] net782 _0775_ _0527_
+ VPWR VGND sg13g2_mux2_1
XFILLER_31_675 VPWR VGND sg13g2_decap_8
X_2793_ videogen.test_lut_thingy.pixel_feeder_inst.row\[41\]\[0\] net816 _0759_ _0580_
+ VPWR VGND sg13g2_mux2_1
X_4532_ _2160_ _2155_ net624 VPWR VGND sg13g2_nand2b_1
X_4463_ _2098_ _2089_ _2096_ VPWR VGND sg13g2_nand2b_1
X_3414_ videogen.fancy_shader.shader_counter_reg\[8\] videogen.fancy_shader.video_y\[8\]
+ _1078_ VPWR VGND sg13g2_xor2_1
Xfanout806 net807 net806 VPWR VGND sg13g2_buf_8
X_4394_ _2037_ VPWR _2043_ VGND _1982_ _2042_ sg13g2_o21ai_1
X_5266__298 VPWR VGND net298 sg13g2_tiehi
X_3345_ videogen.fancy_shader.shader_counter_reg\[2\] videogen.fancy_shader.video_y\[2\]
+ _1009_ VPWR VGND sg13g2_xor2_1
Xfanout817 ui_in[4] net817 VPWR VGND sg13g2_buf_8
X_3276_ _0957_ _0958_ _0335_ VPWR VGND sg13g2_nor2_1
XFILLER_39_753 VPWR VGND sg13g2_fill_2
X_5015_ net414 VGND VPWR _0369_ tmds_red.dc_balancing_reg\[3\] net661 sg13g2_dfrbpq_1
X_5123__225 VPWR VGND net225 sg13g2_tiehi
XFILLER_14_609 VPWR VGND sg13g2_fill_2
X_4997__432 VPWR VGND net432 sg13g2_tiehi
XFILLER_10_859 VPWR VGND sg13g2_fill_2
XFILLER_22_697 VPWR VGND sg13g2_decap_8
XFILLER_5_329 VPWR VGND sg13g2_decap_4
XFILLER_1_546 VPWR VGND sg13g2_decap_8
XFILLER_29_230 VPWR VGND sg13g2_decap_4
XFILLER_45_712 VPWR VGND sg13g2_decap_8
XFILLER_45_778 VPWR VGND sg13g2_fill_1
XFILLER_44_255 VPWR VGND sg13g2_decap_4
XFILLER_33_918 VPWR VGND sg13g2_fill_1
XFILLER_12_185 VPWR VGND sg13g2_fill_1
XFILLER_8_167 VPWR VGND sg13g2_fill_2
XFILLER_5_852 VPWR VGND sg13g2_decap_8
X_3130_ _0262_ net819 net763 net481 VPWR VGND sg13g2_and3_1
XFILLER_0_590 VPWR VGND sg13g2_decap_8
XFILLER_48_561 VPWR VGND sg13g2_decap_8
X_3061_ _0674_ videogen.test_lut_thingy.pixel_feeder_inst.v_counter\[2\] videogen.test_lut_thingy.pixel_feeder_inst.v_counter\[1\]
+ _0675_ _0823_ VPWR VGND sg13g2_nor4_1
XFILLER_35_277 VPWR VGND sg13g2_decap_8
XFILLER_35_288 VPWR VGND sg13g2_fill_1
X_3963_ _1429_ _1526_ _1233_ _1626_ VPWR VGND _1624_ sg13g2_nand4_1
X_3894_ net646 VPWR _1557_ VGND videogen.test_lut_thingy.pixel_feeder_inst.row\[22\]\[0\]
+ net608 sg13g2_o21ai_1
X_2914_ net779 videogen.test_lut_thingy.pixel_feeder_inst.row\[56\]\[3\] _0787_ _0479_
+ VPWR VGND sg13g2_mux2_1
X_2845_ net810 videogen.test_lut_thingy.pixel_feeder_inst.row\[50\]\[0\] _0771_ _0540_
+ VPWR VGND sg13g2_mux2_1
XFILLER_31_494 VPWR VGND sg13g2_decap_8
X_4515_ _2143_ tmds_blue.dc_balancing_reg\[2\] _2142_ VPWR VGND sg13g2_nand2_1
X_2776_ _0754_ net620 _0712_ _0753_ VPWR VGND sg13g2_and3_2
X_4446_ _2074_ VPWR _2082_ VGND _2065_ _2080_ sg13g2_o21ai_1
Xfanout614 _0678_ net614 VPWR VGND sg13g2_buf_8
X_4377_ VGND VPWR _1995_ _2021_ _2027_ _1982_ sg13g2_a21oi_1
Xfanout603 net609 net603 VPWR VGND sg13g2_buf_8
Xfanout625 blue\[0\] net625 VPWR VGND sg13g2_buf_8
Xfanout658 net660 net658 VPWR VGND sg13g2_buf_8
Xfanout647 videogen.test_lut_thingy.pixel_feeder_inst.h_pix\[2\] net647 VPWR VGND
+ sg13g2_buf_8
Xfanout636 videogen.test_lut_thingy.pixel_feeder_inst.h_pix\[4\] net636 VPWR VGND
+ sg13g2_buf_8
X_3328_ videogen.fancy_shader.video_x\[1\] net632 _0992_ VPWR VGND sg13g2_nor2_1
Xfanout669 clk_video net669 VPWR VGND sg13g2_buf_8
X_3259_ _0943_ net631 _0946_ VPWR VGND sg13g2_xor2_1
XFILLER_27_701 VPWR VGND sg13g2_decap_4
XFILLER_26_200 VPWR VGND sg13g2_fill_2
XFILLER_41_225 VPWR VGND sg13g2_fill_1
XFILLER_23_951 VPWR VGND sg13g2_decap_8
XFILLER_10_601 VPWR VGND sg13g2_fill_2
Xclkbuf_3_5_0_clk_regs clknet_0_clk_regs clknet_3_5_0_clk_regs VPWR VGND sg13g2_buf_8
XFILLER_5_148 VPWR VGND sg13g2_fill_1
XFILLER_2_811 VPWR VGND sg13g2_decap_8
XFILLER_2_888 VPWR VGND sg13g2_decap_8
XFILLER_37_509 VPWR VGND sg13g2_fill_1
XFILLER_17_233 VPWR VGND sg13g2_decap_8
XFILLER_45_586 VPWR VGND sg13g2_decap_8
XFILLER_17_277 VPWR VGND sg13g2_fill_1
XFILLER_32_247 VPWR VGND sg13g2_fill_1
XFILLER_14_962 VPWR VGND sg13g2_fill_1
XFILLER_14_995 VPWR VGND sg13g2_fill_1
XFILLER_5_682 VPWR VGND sg13g2_fill_2
X_5280_ net210 VGND VPWR _0630_ videogen.test_lut_thingy.pixel_feeder_inst.row\[23\]\[0\]
+ _0249_ sg13g2_dfrbpq_1
X_4300_ VGND VPWR red\[4\] _1949_ _1952_ _1944_ sg13g2_a21oi_1
X_4231_ _1872_ _1887_ _1869_ _1888_ VPWR VGND sg13g2_mux2_1
X_4162_ _1819_ _1742_ _1818_ VPWR VGND sg13g2_nand2_1
X_3113_ videogen.test_lut_thingy.pixel_feeder_inst.v_pix\[3\] _0858_ videogen.test_lut_thingy.pixel_feeder_inst.v_pix\[4\]
+ _0861_ VPWR VGND sg13g2_nand3_1
X_4093_ _1748_ _1638_ _1750_ VPWR VGND sg13g2_xor2_1
X_3044_ net809 videogen.test_lut_thingy.pixel_feeder_inst.row\[18\]\[0\] _0814_ _0284_
+ VPWR VGND sg13g2_mux2_1
X_4995_ net434 VGND VPWR _0349_ videogen.test_lut_thingy.gol_counter_reg\[0\] net652
+ sg13g2_dfrbpq_2
X_3946_ net613 _1603_ _1608_ _1609_ VPWR VGND sg13g2_nor3_1
X_3877_ videogen.test_lut_thingy.pixel_feeder_inst.row\[11\]\[0\] net578 _1540_ VPWR
+ VGND sg13g2_nor2_1
X_2828_ videogen.test_lut_thingy.pixel_feeder_inst.row\[47\]\[2\] net794 _0768_ _0554_
+ VPWR VGND sg13g2_mux2_1
X_2759_ net800 videogen.test_lut_thingy.pixel_feeder_inst.row\[49\]\[1\] _0746_ _0601_
+ VPWR VGND sg13g2_mux2_1
XFILLER_2_118 VPWR VGND sg13g2_fill_1
X_4429_ _2066_ tmds_green.dc_balancing_reg\[1\] _2055_ VPWR VGND sg13g2_xnor2_1
XFILLER_48_14 VPWR VGND sg13g2_decap_8
XFILLER_7_903 VPWR VGND sg13g2_decap_8
XFILLER_11_987 VPWR VGND sg13g2_decap_8
XFILLER_2_685 VPWR VGND sg13g2_decap_8
XFILLER_38_818 VPWR VGND sg13g2_decap_4
XFILLER_46_862 VPWR VGND sg13g2_decap_8
XFILLER_33_501 VPWR VGND sg13g2_fill_2
XFILLER_33_523 VPWR VGND sg13g2_decap_8
X_4780_ net697 net741 _0137_ VPWR VGND sg13g2_nor2_1
X_3800_ net616 VPWR _1464_ VGND videogen.test_lut_thingy.pixel_feeder_inst.row\[21\]\[1\]
+ net576 sg13g2_o21ai_1
XFILLER_33_556 VPWR VGND sg13g2_decap_4
X_3731_ net645 VPWR _1395_ VGND videogen.test_lut_thingy.pixel_feeder_inst.row\[29\]\[2\]
+ net572 sg13g2_o21ai_1
XFILLER_13_291 VPWR VGND sg13g2_decap_8
X_3662_ _0676_ _1314_ _1325_ _1326_ VPWR VGND sg13g2_nor3_1
XFILLER_9_273 VPWR VGND sg13g2_fill_2
X_3593_ videogen.test_lut_thingy.pixel_feeder_inst.row\[44\]\[3\] net596 _1257_ VPWR
+ VGND sg13g2_nor2_1
XFILLER_47_1005 VPWR VGND sg13g2_decap_8
XFILLER_48_0 VPWR VGND sg13g2_decap_8
X_5263_ net310 VGND VPWR _0613_ blue_tmds_par\[1\] net667 sg13g2_dfrbpq_1
X_4214_ _1871_ _1830_ _1852_ _1870_ VPWR VGND sg13g2_and3_1
X_5194_ net361 VGND VPWR _0544_ videogen.test_lut_thingy.pixel_feeder_inst.row\[4\]\[0\]
+ _0173_ sg13g2_dfrbpq_1
X_4145_ _1801_ _1796_ _1794_ _1802_ VPWR VGND sg13g2_a21o_1
XFILLER_37_862 VPWR VGND sg13g2_fill_2
X_4076_ _1735_ _1734_ _1736_ VPWR VGND sg13g2_nor2b_1
XFILLER_43_309 VPWR VGND sg13g2_decap_8
X_3027_ videogen.test_lut_thingy.pixel_feeder_inst.row\[13\]\[2\] net792 _0811_ _0378_
+ VPWR VGND sg13g2_mux2_1
XFILLER_36_372 VPWR VGND sg13g2_fill_1
X_4978_ net54 VGND VPWR _0332_ videogen.fancy_shader.shader_counter_reg\[5\] net658
+ sg13g2_dfrbpq_1
XFILLER_11_206 VPWR VGND sg13g2_fill_1
XFILLER_24_589 VPWR VGND sg13g2_fill_2
X_3929_ net618 VPWR _1592_ VGND videogen.test_lut_thingy.pixel_feeder_inst.row\[54\]\[0\]
+ net603 sg13g2_o21ai_1
Xclkload4 VPWR clkload4/Y clknet_3_7_0_clk_regs VGND sg13g2_inv_1
XFILLER_4_939 VPWR VGND sg13g2_decap_8
XFILLER_3_427 VPWR VGND sg13g2_fill_2
XFILLER_47_648 VPWR VGND sg13g2_decap_8
XFILLER_15_545 VPWR VGND sg13g2_decap_8
XFILLER_43_876 VPWR VGND sg13g2_decap_4
XFILLER_11_740 VPWR VGND sg13g2_fill_2
XFILLER_10_272 VPWR VGND sg13g2_fill_2
XFILLER_11_795 VPWR VGND sg13g2_decap_8
XFILLER_6_298 VPWR VGND sg13g2_fill_1
XFILLER_41_7 VPWR VGND sg13g2_decap_4
XFILLER_3_972 VPWR VGND sg13g2_decap_8
XFILLER_2_471 VPWR VGND sg13g2_fill_2
XFILLER_1_42 VPWR VGND sg13g2_decap_8
XFILLER_19_840 VPWR VGND sg13g2_decap_4
XFILLER_1_86 VPWR VGND sg13g2_fill_1
X_4901_ net710 net754 _0256_ VPWR VGND sg13g2_nor2_1
XFILLER_18_372 VPWR VGND sg13g2_fill_1
X_4832_ net716 net760 _0189_ VPWR VGND sg13g2_nor2_1
XFILLER_33_375 VPWR VGND sg13g2_fill_1
XFILLER_33_386 VPWR VGND sg13g2_decap_8
X_4763_ net701 net745 _0120_ VPWR VGND sg13g2_nor2_1
X_5154__132 VPWR VGND net132 sg13g2_tiehi
X_4694_ net716 net760 _0051_ VPWR VGND sg13g2_nor2_1
X_3714_ _1354_ _1377_ _1378_ VPWR VGND sg13g2_nor2_1
X_3645_ net615 VPWR _1309_ VGND videogen.test_lut_thingy.pixel_feeder_inst.row\[18\]\[3\]
+ net601 sg13g2_o21ai_1
XFILLER_20_29 VPWR VGND sg13g2_decap_8
X_3576_ videogen.test_lut_thingy.pixel_feeder_inst.row\[50\]\[3\] net602 _1240_ VPWR
+ VGND sg13g2_nor2_1
X_5315_ net156 VGND VPWR _0665_ videogen.test_lut_thingy.pixel_feeder_inst.row\[21\]\[2\]
+ _0259_ sg13g2_dfrbpq_1
X_5246_ net67 VGND VPWR _0596_ videogen.test_lut_thingy.pixel_feeder_inst.row\[59\]\[0\]
+ _0225_ sg13g2_dfrbpq_1
Xhold16 serialize.shift_reg_b\[9\] VPWR VGND net461 sg13g2_dlygate4sd3_1
Xhold38 serialize.bit_cnt\[2\] VPWR VGND net483 sg13g2_dlygate4sd3_1
Xhold27 serialize.shift_reg_g\[5\] VPWR VGND net472 sg13g2_dlygate4sd3_1
X_5177_ net45 VGND VPWR _0527_ videogen.test_lut_thingy.pixel_feeder_inst.row\[28\]\[3\]
+ _0156_ sg13g2_dfrbpq_1
X_4128_ _1774_ _1765_ _1785_ VPWR VGND sg13g2_xor2_1
XFILLER_29_648 VPWR VGND sg13g2_decap_8
XFILLER_44_629 VPWR VGND sg13g2_decap_8
XFILLER_43_106 VPWR VGND sg13g2_decap_8
XFILLER_37_670 VPWR VGND sg13g2_decap_8
XFILLER_16_309 VPWR VGND sg13g2_fill_1
X_4059_ _1719_ _1715_ _1718_ _1713_ _1712_ VPWR VGND sg13g2_a22oi_1
XFILLER_24_397 VPWR VGND sg13g2_decap_4
XFILLER_8_519 VPWR VGND sg13g2_decap_8
X_5133__205 VPWR VGND net205 sg13g2_tiehi
XFILLER_4_736 VPWR VGND sg13g2_decap_8
XFILLER_3_246 VPWR VGND sg13g2_decap_8
XFILLER_10_84 VPWR VGND sg13g2_fill_2
Xclkbuf_regs_0_clk clk clk_regs VPWR VGND sg13g2_buf_8
XFILLER_0_975 VPWR VGND sg13g2_decap_8
XFILLER_48_946 VPWR VGND sg13g2_decap_8
XFILLER_47_423 VPWR VGND sg13g2_decap_8
XFILLER_47_401 VPWR VGND sg13g2_fill_1
XFILLER_19_82 VPWR VGND sg13g2_decap_8
XFILLER_19_136 VPWR VGND sg13g2_decap_8
XFILLER_19_158 VPWR VGND sg13g2_decap_8
XFILLER_19_169 VPWR VGND sg13g2_fill_1
XFILLER_16_843 VPWR VGND sg13g2_decap_8
XFILLER_16_865 VPWR VGND sg13g2_fill_2
XFILLER_27_191 VPWR VGND sg13g2_decap_8
XFILLER_43_684 VPWR VGND sg13g2_decap_8
XFILLER_31_813 VPWR VGND sg13g2_decap_8
XFILLER_11_592 VPWR VGND sg13g2_decap_8
X_3430_ _1094_ _1092_ _1093_ VPWR VGND sg13g2_nand2_1
X_3361_ _1009_ _1024_ _1025_ VPWR VGND sg13g2_and2_1
X_5100_ net271 VGND VPWR _0450_ videogen.test_lut_thingy.pixel_feeder_inst.row\[63\]\[2\]
+ _0087_ sg13g2_dfrbpq_1
X_3292_ _0969_ net818 _0968_ VPWR VGND sg13g2_nand2_1
X_5031_ net390 VGND VPWR _0385_ green_tmds_par\[1\] net666 sg13g2_dfrbpq_1
XFILLER_39_924 VPWR VGND sg13g2_fill_1
XFILLER_26_607 VPWR VGND sg13g2_fill_2
XFILLER_18_180 VPWR VGND sg13g2_decap_4
XFILLER_21_312 VPWR VGND sg13g2_decap_8
X_4815_ net695 net740 _0172_ VPWR VGND sg13g2_nor2_1
X_4746_ net714 net758 _0103_ VPWR VGND sg13g2_nor2_1
X_4677_ net681 net726 _0034_ VPWR VGND sg13g2_nor2_1
X_3628_ net640 VPWR _1292_ VGND videogen.test_lut_thingy.pixel_feeder_inst.row\[13\]\[3\]
+ net572 sg13g2_o21ai_1
Xoutput17 net17 uo_out[4] VPWR VGND sg13g2_buf_1
XFILLER_1_728 VPWR VGND sg13g2_decap_8
X_3559_ _1001_ _1220_ _1223_ VPWR VGND sg13g2_and2_1
X_5229_ net212 VGND VPWR _0579_ videogen.test_lut_thingy.pixel_feeder_inst.row\[42\]\[3\]
+ _0208_ sg13g2_dfrbpq_1
XFILLER_5_1013 VPWR VGND sg13g2_decap_8
XFILLER_44_404 VPWR VGND sg13g2_fill_2
XFILLER_44_415 VPWR VGND sg13g2_fill_2
XFILLER_16_106 VPWR VGND sg13g2_decap_8
XFILLER_13_802 VPWR VGND sg13g2_decap_8
XFILLER_9_817 VPWR VGND sg13g2_decap_8
XFILLER_40_665 VPWR VGND sg13g2_decap_8
XFILLER_13_879 VPWR VGND sg13g2_fill_1
XFILLER_4_544 VPWR VGND sg13g2_decap_8
XFILLER_4_599 VPWR VGND sg13g2_decap_8
X_5261__322 VPWR VGND net322 sg13g2_tiehi
XFILLER_0_772 VPWR VGND sg13g2_decap_8
XFILLER_48_743 VPWR VGND sg13g2_decap_8
XFILLER_36_927 VPWR VGND sg13g2_decap_8
XFILLER_36_949 VPWR VGND sg13g2_fill_2
XFILLER_35_426 VPWR VGND sg13g2_decap_4
XFILLER_46_80 VPWR VGND sg13g2_fill_1
X_2930_ net796 videogen.test_lut_thingy.pixel_feeder_inst.row\[7\]\[2\] _0790_ _0466_
+ VPWR VGND sg13g2_mux2_1
X_4600_ _2215_ net673 net464 net679 blue_tmds_par\[2\] VPWR VGND sg13g2_a22oi_1
X_2861_ _0733_ _0764_ _0775_ VPWR VGND sg13g2_nor2_2
X_2792_ videogen.test_lut_thingy.pixel_feeder_inst.row\[41\]\[1\] net806 _0759_ _0581_
+ VPWR VGND sg13g2_mux2_1
XFILLER_30_197 VPWR VGND sg13g2_fill_2
X_5151__146 VPWR VGND net146 sg13g2_tiehi
X_4531_ _2159_ _2157_ _2158_ _2151_ _2127_ VPWR VGND sg13g2_a22oi_1
XFILLER_7_63 VPWR VGND sg13g2_decap_4
X_4462_ _2097_ _2096_ _2089_ VPWR VGND sg13g2_nand2b_1
X_3413_ videogen.fancy_shader.video_y\[8\] videogen.fancy_shader.shader_counter_reg\[8\]
+ _1077_ VPWR VGND sg13g2_and2_1
X_4393_ _2041_ _2026_ _2042_ VPWR VGND sg13g2_xor2_1
Xfanout807 ui_in[5] net807 VPWR VGND sg13g2_buf_8
Xfanout818 net819 net818 VPWR VGND sg13g2_buf_8
X_3344_ videogen.fancy_shader.video_y\[2\] videogen.fancy_shader.shader_counter_reg\[2\]
+ _1008_ VPWR VGND sg13g2_and2_1
X_3275_ VGND VPWR _0936_ _0953_ _0958_ videogen.fancy_shader.shader_counter_reg\[8\]
+ sg13g2_a21oi_1
X_5014_ net415 VGND VPWR _0368_ tmds_red.dc_balancing_reg\[2\] net661 sg13g2_dfrbpq_1
XFILLER_27_905 VPWR VGND sg13g2_decap_4
XFILLER_38_297 VPWR VGND sg13g2_decap_8
XFILLER_35_960 VPWR VGND sg13g2_fill_2
XFILLER_22_621 VPWR VGND sg13g2_decap_8
XFILLER_22_632 VPWR VGND sg13g2_fill_1
XFILLER_34_492 VPWR VGND sg13g2_fill_2
XFILLER_10_805 VPWR VGND sg13g2_decap_8
X_4729_ net694 net738 _0086_ VPWR VGND sg13g2_nor2_1
XFILLER_1_525 VPWR VGND sg13g2_decap_8
XFILLER_18_905 VPWR VGND sg13g2_decap_8
XFILLER_29_242 VPWR VGND sg13g2_fill_1
XFILLER_13_610 VPWR VGND sg13g2_decap_8
XFILLER_12_120 VPWR VGND sg13g2_fill_1
XFILLER_13_676 VPWR VGND sg13g2_decap_4
XFILLER_12_164 VPWR VGND sg13g2_decap_8
XFILLER_12_197 VPWR VGND sg13g2_decap_8
XFILLER_5_831 VPWR VGND sg13g2_decap_8
X_3060_ videogen.test_lut_thingy.pixel_feeder_inst.h_counter\[0\] _0820_ _0822_ VPWR
+ VGND sg13g2_and2_1
XFILLER_48_540 VPWR VGND sg13g2_decap_8
XFILLER_24_919 VPWR VGND sg13g2_fill_1
XFILLER_36_768 VPWR VGND sg13g2_fill_2
XFILLER_23_407 VPWR VGND sg13g2_decap_8
XFILLER_16_470 VPWR VGND sg13g2_decap_8
X_3962_ _1526_ _1624_ _1233_ _1625_ VPWR VGND sg13g2_nand3_1
XFILLER_32_952 VPWR VGND sg13g2_fill_1
X_3893_ _1552_ _1553_ _1554_ _1555_ _1556_ VPWR VGND sg13g2_nor4_1
X_2913_ _0787_ _0731_ _0750_ VPWR VGND sg13g2_nand2_2
X_2844_ net800 videogen.test_lut_thingy.pixel_feeder_inst.row\[50\]\[1\] _0771_ _0541_
+ VPWR VGND sg13g2_mux2_1
X_4514_ _2132_ _2141_ _2142_ VPWR VGND sg13g2_nor2b_2
X_2775_ net634 _0739_ _0753_ VPWR VGND sg13g2_nor2_1
XFILLER_7_190 VPWR VGND sg13g2_decap_8
X_4445_ _2065_ _2074_ _2080_ _2081_ VPWR VGND sg13g2_nor3_1
Xfanout604 net605 net604 VPWR VGND sg13g2_buf_8
X_4376_ _2026_ _1995_ _2021_ VPWR VGND sg13g2_nand2_1
Xfanout615 net618 net615 VPWR VGND sg13g2_buf_8
Xfanout648 videogen.test_lut_thingy.pixel_feeder_inst.h_pix\[0\] net648 VPWR VGND
+ sg13g2_buf_8
X_3327_ _0991_ videogen.fancy_shader.video_x\[1\] net632 VPWR VGND sg13g2_nand2_1
Xfanout637 videogen.test_lut_thingy.pixel_feeder_inst.h_pix\[4\] net637 VPWR VGND
+ sg13g2_buf_8
Xfanout626 net627 net626 VPWR VGND sg13g2_buf_8
Xfanout659 net660 net659 VPWR VGND sg13g2_buf_8
X_3258_ VPWR _0330_ _0945_ VGND sg13g2_inv_1
X_3189_ net563 _0896_ _0897_ _0301_ VPWR VGND sg13g2_nor3_1
XFILLER_42_716 VPWR VGND sg13g2_decap_8
X_4923__151 VPWR VGND net151 sg13g2_tiehi
XFILLER_42_749 VPWR VGND sg13g2_fill_1
XFILLER_10_624 VPWR VGND sg13g2_fill_1
XFILLER_6_639 VPWR VGND sg13g2_decap_8
XFILLER_10_679 VPWR VGND sg13g2_decap_4
XFILLER_2_867 VPWR VGND sg13g2_decap_8
XFILLER_49_348 VPWR VGND sg13g2_decap_8
XFILLER_40_1022 VPWR VGND sg13g2_decap_8
XFILLER_45_565 VPWR VGND sg13g2_decap_8
X_5141__189 VPWR VGND net189 sg13g2_tiehi
XFILLER_32_237 VPWR VGND sg13g2_fill_1
XFILLER_13_440 VPWR VGND sg13g2_decap_8
XFILLER_9_477 VPWR VGND sg13g2_decap_8
XFILLER_9_488 VPWR VGND sg13g2_fill_2
XFILLER_4_182 VPWR VGND sg13g2_fill_2
XFILLER_4_171 VPWR VGND sg13g2_decap_8
X_4230_ _1887_ _1861_ _1872_ VPWR VGND sg13g2_nand2_1
XFILLER_4_86 VPWR VGND sg13g2_decap_8
X_4161_ VGND VPWR _1818_ _1817_ _1814_ sg13g2_or2_1
X_3112_ VGND VPWR _0850_ _0860_ net19 _0852_ sg13g2_a21oi_1
X_4092_ _1749_ _1638_ _1748_ VPWR VGND sg13g2_xnor2_1
X_3043_ net799 videogen.test_lut_thingy.pixel_feeder_inst.row\[18\]\[1\] _0814_ _0285_
+ VPWR VGND sg13g2_mux2_1
XFILLER_36_576 VPWR VGND sg13g2_fill_1
X_4994_ net436 VGND VPWR _0348_ videogen.fancy_shader.video_y\[9\] net656 sg13g2_dfrbpq_2
X_3945_ _1604_ _1605_ _1606_ _1607_ _1608_ VPWR VGND sg13g2_nor4_1
X_4994__436 VPWR VGND net436 sg13g2_tiehi
XFILLER_20_933 VPWR VGND sg13g2_decap_8
XFILLER_32_793 VPWR VGND sg13g2_fill_1
X_3876_ net640 _1533_ _1538_ _1539_ VPWR VGND sg13g2_nor3_1
X_2827_ videogen.test_lut_thingy.pixel_feeder_inst.row\[47\]\[3\] net785 _0768_ _0555_
+ VPWR VGND sg13g2_mux2_1
X_2758_ net789 videogen.test_lut_thingy.pixel_feeder_inst.row\[49\]\[2\] _0746_ _0602_
+ VPWR VGND sg13g2_mux2_1
X_4428_ tmds_green.dc_balancing_reg\[1\] _2055_ _2065_ VPWR VGND sg13g2_nor2_1
X_2689_ _0707_ videogen.test_lut_thingy.pixel_feeder_inst.h_pix\[1\] net648 VPWR VGND
+ sg13g2_nand2b_1
XFILLER_48_37 VPWR VGND sg13g2_fill_1
X_4359_ _1974_ _1975_ _1964_ _2009_ VPWR VGND sg13g2_nand3_1
XFILLER_39_370 VPWR VGND sg13g2_fill_2
XFILLER_15_705 VPWR VGND sg13g2_decap_8
XFILLER_15_716 VPWR VGND sg13g2_fill_1
XFILLER_27_587 VPWR VGND sg13g2_fill_1
XFILLER_15_738 VPWR VGND sg13g2_decap_8
XFILLER_11_966 VPWR VGND sg13g2_decap_8
XFILLER_22_281 VPWR VGND sg13g2_decap_4
XFILLER_7_959 VPWR VGND sg13g2_decap_8
XFILLER_10_487 VPWR VGND sg13g2_decap_8
XFILLER_13_62 VPWR VGND sg13g2_fill_1
XFILLER_2_664 VPWR VGND sg13g2_decap_8
XFILLER_49_112 VPWR VGND sg13g2_fill_1
XFILLER_49_101 VPWR VGND sg13g2_decap_8
XFILLER_37_329 VPWR VGND sg13g2_decap_4
XFILLER_46_841 VPWR VGND sg13g2_decap_8
XFILLER_18_565 VPWR VGND sg13g2_fill_1
XFILLER_18_587 VPWR VGND sg13g2_decap_4
XFILLER_45_395 VPWR VGND sg13g2_decap_8
X_3730_ _1390_ _1391_ _1392_ _1393_ _1394_ VPWR VGND sg13g2_nor4_1
XFILLER_9_252 VPWR VGND sg13g2_decap_8
XFILLER_9_230 VPWR VGND sg13g2_decap_8
X_4937__128 VPWR VGND net128 sg13g2_tiehi
X_3661_ net612 _1319_ _1324_ _1325_ VPWR VGND sg13g2_nor3_1
X_3592_ net646 VPWR _1256_ VGND videogen.test_lut_thingy.pixel_feeder_inst.row\[47\]\[3\]
+ net585 sg13g2_o21ai_1
XFILLER_6_981 VPWR VGND sg13g2_decap_8
XFILLER_47_1028 VPWR VGND sg13g2_fill_1
X_5262_ net314 VGND VPWR _0612_ blue_tmds_par\[0\] net663 sg13g2_dfrbpq_1
X_5193_ net365 VGND VPWR _0543_ videogen.test_lut_thingy.pixel_feeder_inst.row\[50\]\[3\]
+ _0172_ sg13g2_dfrbpq_1
X_4213_ _1870_ _1855_ _1863_ VPWR VGND sg13g2_xnor2_1
X_4144_ _1799_ _1798_ _1790_ _1801_ VPWR VGND sg13g2_a21o_1
XFILLER_28_329 VPWR VGND sg13g2_decap_8
X_4075_ _1329_ _1428_ _1735_ VPWR VGND sg13g2_nor2_1
X_3026_ videogen.test_lut_thingy.pixel_feeder_inst.row\[13\]\[3\] net782 _0811_ _0379_
+ VPWR VGND sg13g2_mux2_1
X_4977_ net56 VGND VPWR _0331_ videogen.fancy_shader.shader_counter_reg\[4\] net654
+ sg13g2_dfrbpq_2
XFILLER_11_218 VPWR VGND sg13g2_fill_2
X_5094__283 VPWR VGND net283 sg13g2_tiehi
X_3928_ _1587_ _1588_ _1589_ _1590_ _1591_ VPWR VGND sg13g2_nor4_1
X_3859_ _1522_ net635 _1523_ VPWR VGND sg13g2_nor2b_1
XFILLER_4_918 VPWR VGND sg13g2_decap_8
XFILLER_3_406 VPWR VGND sg13g2_decap_8
XFILLER_1_7 VPWR VGND sg13g2_decap_8
XFILLER_8_1022 VPWR VGND sg13g2_decap_8
XFILLER_47_627 VPWR VGND sg13g2_decap_8
XFILLER_46_115 VPWR VGND sg13g2_decap_8
XFILLER_46_159 VPWR VGND sg13g2_fill_1
XFILLER_15_502 VPWR VGND sg13g2_fill_2
XFILLER_15_513 VPWR VGND sg13g2_fill_1
XFILLER_24_72 VPWR VGND sg13g2_decap_4
XFILLER_24_94 VPWR VGND sg13g2_fill_2
XFILLER_10_251 VPWR VGND sg13g2_decap_8
XFILLER_7_723 VPWR VGND sg13g2_decap_8
XFILLER_7_701 VPWR VGND sg13g2_decap_8
XFILLER_11_763 VPWR VGND sg13g2_decap_8
XFILLER_7_789 VPWR VGND sg13g2_decap_8
XFILLER_40_82 VPWR VGND sg13g2_decap_4
XFILLER_3_951 VPWR VGND sg13g2_decap_8
XFILLER_2_450 VPWR VGND sg13g2_fill_1
XFILLER_49_80 VPWR VGND sg13g2_decap_8
X_5147__173 VPWR VGND net173 sg13g2_tiehi
X_5161__99 VPWR VGND net99 sg13g2_tiehi
XFILLER_1_21 VPWR VGND sg13g2_decap_8
XFILLER_38_649 VPWR VGND sg13g2_decap_8
X_4900_ net710 net754 _0255_ VPWR VGND sg13g2_nor2_1
XFILLER_33_332 VPWR VGND sg13g2_fill_1
X_4831_ net700 net744 _0188_ VPWR VGND sg13g2_nor2_1
XFILLER_34_899 VPWR VGND sg13g2_fill_1
X_4762_ net701 net745 _0119_ VPWR VGND sg13g2_nor2_1
X_4693_ net721 net765 _0050_ VPWR VGND sg13g2_nor2_1
X_3713_ net634 VPWR _1377_ VGND _1365_ _1376_ sg13g2_o21ai_1
X_3644_ _1304_ _1305_ _1306_ _1307_ _1308_ VPWR VGND sg13g2_nor4_1
X_3575_ net610 VPWR _1239_ VGND videogen.test_lut_thingy.pixel_feeder_inst.row\[48\]\[3\]
+ net591 sg13g2_o21ai_1
X_5269__286 VPWR VGND net286 sg13g2_tiehi
X_5314_ net190 VGND VPWR _0664_ videogen.test_lut_thingy.pixel_feeder_inst.row\[21\]\[1\]
+ _0258_ sg13g2_dfrbpq_1
X_5245_ net75 VGND VPWR _0595_ videogen.test_lut_thingy.pixel_feeder_inst.row\[38\]\[3\]
+ _0224_ sg13g2_dfrbpq_1
Xhold17 serialize.shift_reg_r\[3\] VPWR VGND net462 sg13g2_dlygate4sd3_1
XFILLER_29_39 VPWR VGND sg13g2_fill_1
Xhold28 serialize.shift_reg_g\[7\] VPWR VGND net473 sg13g2_dlygate4sd3_1
Xhold39 _0621_ VPWR VGND net484 sg13g2_dlygate4sd3_1
X_5176_ net49 VGND VPWR _0526_ videogen.test_lut_thingy.pixel_feeder_inst.row\[28\]\[2\]
+ _0155_ sg13g2_dfrbpq_1
XFILLER_21_1009 VPWR VGND sg13g2_fill_1
XFILLER_29_616 VPWR VGND sg13g2_decap_8
X_4127_ _1784_ _1765_ _1774_ VPWR VGND sg13g2_xnor2_1
XFILLER_45_38 VPWR VGND sg13g2_fill_2
XFILLER_44_608 VPWR VGND sg13g2_decap_8
XFILLER_25_811 VPWR VGND sg13g2_decap_8
X_4058_ _1716_ VPWR _1718_ VGND _1700_ _1717_ sg13g2_o21ai_1
X_3009_ net813 videogen.test_lut_thingy.pixel_feeder_inst.row\[15\]\[0\] _0807_ _0395_
+ VPWR VGND sg13g2_mux2_1
XFILLER_24_310 VPWR VGND sg13g2_decap_8
XFILLER_24_321 VPWR VGND sg13g2_fill_2
XFILLER_25_866 VPWR VGND sg13g2_decap_8
XFILLER_25_888 VPWR VGND sg13g2_fill_2
XFILLER_4_715 VPWR VGND sg13g2_decap_8
XFILLER_3_225 VPWR VGND sg13g2_fill_2
XFILLER_0_954 VPWR VGND sg13g2_decap_8
XFILLER_48_925 VPWR VGND sg13g2_decap_8
XFILLER_16_822 VPWR VGND sg13g2_fill_2
XFILLER_43_663 VPWR VGND sg13g2_decap_8
XFILLER_37_1016 VPWR VGND sg13g2_decap_8
XFILLER_27_181 VPWR VGND sg13g2_decap_4
XFILLER_37_1027 VPWR VGND sg13g2_fill_2
XFILLER_30_313 VPWR VGND sg13g2_fill_2
XFILLER_42_184 VPWR VGND sg13g2_fill_1
XFILLER_30_335 VPWR VGND sg13g2_fill_1
XFILLER_11_560 VPWR VGND sg13g2_decap_4
X_5190__377 VPWR VGND net377 sg13g2_tiehi
XFILLER_7_586 VPWR VGND sg13g2_decap_8
X_3360_ videogen.fancy_shader.shader_counter_reg\[3\] videogen.fancy_shader.video_y\[3\]
+ _1024_ VPWR VGND sg13g2_xor2_1
XFILLER_2_291 VPWR VGND sg13g2_decap_8
X_3291_ _0966_ _0967_ _0872_ _0968_ VPWR VGND sg13g2_nand3_1
X_5030_ net391 VGND VPWR _0384_ green_tmds_par\[0\] net666 sg13g2_dfrbpq_1
XFILLER_38_424 VPWR VGND sg13g2_fill_1
XFILLER_47_991 VPWR VGND sg13g2_decap_8
XFILLER_34_641 VPWR VGND sg13g2_fill_2
XFILLER_22_814 VPWR VGND sg13g2_decap_8
X_4814_ net696 net740 _0171_ VPWR VGND sg13g2_nor2_1
XFILLER_33_184 VPWR VGND sg13g2_fill_2
X_4745_ net707 net752 _0102_ VPWR VGND sg13g2_nor2_1
X_4676_ net686 net730 _0033_ VPWR VGND sg13g2_nor2_1
X_3627_ net643 _1285_ _1290_ _1291_ VPWR VGND sg13g2_nor3_1
Xoutput18 net18 uo_out[5] VPWR VGND sg13g2_buf_1
XFILLER_1_707 VPWR VGND sg13g2_decap_8
X_3558_ _1222_ _1200_ _1221_ VPWR VGND sg13g2_xnor2_1
X_3489_ _1153_ net561 _1149_ VPWR VGND sg13g2_xnor2_1
X_5228_ net216 VGND VPWR _0578_ videogen.test_lut_thingy.pixel_feeder_inst.row\[42\]\[2\]
+ _0207_ sg13g2_dfrbpq_1
X_5159_ net103 VGND VPWR _0509_ green_tmds_par\[6\] net665 sg13g2_dfrbpq_1
XFILLER_45_928 VPWR VGND sg13g2_decap_8
XFILLER_45_906 VPWR VGND sg13g2_decap_4
XFILLER_44_449 VPWR VGND sg13g2_fill_2
XFILLER_25_663 VPWR VGND sg13g2_fill_2
XFILLER_40_644 VPWR VGND sg13g2_decap_8
XFILLER_12_335 VPWR VGND sg13g2_decap_8
XFILLER_12_357 VPWR VGND sg13g2_decap_4
XFILLER_21_95 VPWR VGND sg13g2_decap_8
XFILLER_0_751 VPWR VGND sg13g2_decap_8
XFILLER_48_722 VPWR VGND sg13g2_decap_8
XFILLER_48_799 VPWR VGND sg13g2_decap_8
XFILLER_47_276 VPWR VGND sg13g2_decap_4
XFILLER_43_493 VPWR VGND sg13g2_fill_2
XFILLER_43_482 VPWR VGND sg13g2_decap_8
X_2860_ videogen.test_lut_thingy.pixel_feeder_inst.row\[27\]\[0\] net808 _0774_ _0528_
+ VPWR VGND sg13g2_mux2_1
XFILLER_30_132 VPWR VGND sg13g2_decap_8
X_2791_ videogen.test_lut_thingy.pixel_feeder_inst.row\[41\]\[2\] net796 _0759_ _0582_
+ VPWR VGND sg13g2_mux2_1
XFILLER_12_880 VPWR VGND sg13g2_fill_2
X_4530_ _2127_ _2156_ _2158_ VPWR VGND sg13g2_nor2_1
XFILLER_11_1008 VPWR VGND sg13g2_decap_8
X_4461_ _2094_ _2093_ _2096_ VPWR VGND sg13g2_xor2_1
X_3412_ _1071_ _1060_ _1072_ _1076_ VPWR VGND sg13g2_a21o_1
X_4392_ _2041_ _2038_ _2040_ VPWR VGND sg13g2_xnor2_1
X_3343_ _0996_ VPWR _1007_ VGND _0995_ _0997_ sg13g2_o21ai_1
Xfanout808 net812 net808 VPWR VGND sg13g2_buf_8
Xfanout819 net821 net819 VPWR VGND sg13g2_buf_8
XFILLER_39_711 VPWR VGND sg13g2_decap_8
X_3274_ _0934_ _0956_ _0957_ VPWR VGND sg13g2_nor2_1
X_5013_ net416 VGND VPWR _0367_ tmds_red.dc_balancing_reg\[1\] net662 sg13g2_dfrbpq_2
XFILLER_39_777 VPWR VGND sg13g2_decap_4
XFILLER_26_18 VPWR VGND sg13g2_fill_2
XFILLER_27_939 VPWR VGND sg13g2_fill_2
XFILLER_41_419 VPWR VGND sg13g2_decap_4
XFILLER_21_132 VPWR VGND sg13g2_decap_8
XFILLER_21_143 VPWR VGND sg13g2_fill_2
X_2989_ net808 videogen.test_lut_thingy.pixel_feeder_inst.row\[9\]\[0\] _0803_ _0420_
+ VPWR VGND sg13g2_mux2_1
X_4728_ net694 net738 _0085_ VPWR VGND sg13g2_nor2_1
X_4659_ net719 net766 _0018_ VPWR VGND sg13g2_nor2_1
X_5210__288 VPWR VGND net288 sg13g2_tiehi
XFILLER_1_504 VPWR VGND sg13g2_decap_8
XFILLER_44_213 VPWR VGND sg13g2_fill_1
XFILLER_44_202 VPWR VGND sg13g2_decap_8
XFILLER_29_265 VPWR VGND sg13g2_decap_4
XFILLER_45_758 VPWR VGND sg13g2_decap_8
XFILLER_32_408 VPWR VGND sg13g2_fill_1
XFILLER_25_493 VPWR VGND sg13g2_fill_2
XFILLER_40_430 VPWR VGND sg13g2_fill_1
XFILLER_34_1019 VPWR VGND sg13g2_fill_1
XFILLER_5_810 VPWR VGND sg13g2_decap_8
XFILLER_5_887 VPWR VGND sg13g2_decap_8
XFILLER_48_596 VPWR VGND sg13g2_decap_8
X_3961_ _1624_ _1575_ _1623_ _0686_ videogen.test_lut_thingy.gol_counter_reg\[0\]
+ VPWR VGND sg13g2_a22oi_1
X_2912_ net811 videogen.test_lut_thingy.pixel_feeder_inst.row\[55\]\[0\] _0786_ _0480_
+ VPWR VGND sg13g2_mux2_1
XFILLER_17_994 VPWR VGND sg13g2_fill_2
X_3892_ videogen.test_lut_thingy.pixel_feeder_inst.row\[18\]\[0\] net601 _1555_ VPWR
+ VGND sg13g2_nor2_1
XFILLER_31_441 VPWR VGND sg13g2_decap_4
X_2843_ net789 videogen.test_lut_thingy.pixel_feeder_inst.row\[50\]\[2\] _0771_ _0542_
+ VPWR VGND sg13g2_mux2_1
X_2774_ videogen.test_lut_thingy.pixel_feeder_inst.row\[38\]\[0\] net815 _0752_ _0592_
+ VPWR VGND sg13g2_mux2_1
X_4513_ _2139_ _2140_ _2138_ _2141_ VPWR VGND sg13g2_nand3_1
X_4444_ net622 green\[7\] _2080_ VPWR VGND sg13g2_nor2b_1
X_4375_ _2025_ _2024_ _1995_ VPWR VGND sg13g2_nand2b_1
Xfanout605 net608 net605 VPWR VGND sg13g2_buf_8
Xfanout638 net642 net638 VPWR VGND sg13g2_buf_8
Xfanout649 videogen.fancy_shader.video_x\[7\] net649 VPWR VGND sg13g2_buf_8
X_3326_ _0990_ net633 videogen.fancy_shader.video_x\[0\] VPWR VGND sg13g2_nand2_1
Xfanout627 display_enable net627 VPWR VGND sg13g2_buf_2
Xfanout616 net618 net616 VPWR VGND sg13g2_buf_8
X_5025__401 VPWR VGND net401 sg13g2_tiehi
X_3257_ _0944_ VPWR _0945_ VGND videogen.fancy_shader.shader_counter_reg\[3\] _0942_
+ sg13g2_o21ai_1
X_3188_ videogen.test_lut_thingy.pixel_feeder_inst.v_pix\[2\] _0895_ _0897_ VPWR VGND
+ sg13g2_and2_1
XFILLER_2_1028 VPWR VGND sg13g2_fill_1
XFILLER_26_202 VPWR VGND sg13g2_fill_1
XFILLER_26_224 VPWR VGND sg13g2_decap_4
XFILLER_41_216 VPWR VGND sg13g2_fill_2
XFILLER_22_452 VPWR VGND sg13g2_decap_4
XFILLER_10_603 VPWR VGND sg13g2_fill_1
XFILLER_6_607 VPWR VGND sg13g2_fill_2
XFILLER_6_629 VPWR VGND sg13g2_fill_1
XFILLER_1_301 VPWR VGND sg13g2_fill_2
XFILLER_2_846 VPWR VGND sg13g2_decap_8
XFILLER_1_367 VPWR VGND sg13g2_decap_4
XFILLER_40_1001 VPWR VGND sg13g2_decap_8
XFILLER_45_533 VPWR VGND sg13g2_fill_1
XFILLER_14_920 VPWR VGND sg13g2_decap_4
XFILLER_26_780 VPWR VGND sg13g2_fill_1
XFILLER_41_783 VPWR VGND sg13g2_fill_2
XFILLER_9_412 VPWR VGND sg13g2_decap_8
XFILLER_13_496 VPWR VGND sg13g2_decap_4
XFILLER_5_684 VPWR VGND sg13g2_fill_1
XFILLER_4_54 VPWR VGND sg13g2_decap_8
X_4160_ _1816_ _1815_ _1817_ VPWR VGND sg13g2_xor2_1
X_3111_ _0860_ videogen.test_lut_thingy.pixel_feeder_inst.v_pix\[3\] _0858_ VPWR VGND
+ sg13g2_xnor2_1
X_4091_ _1044_ _1747_ _1748_ VPWR VGND sg13g2_and2_1
XFILLER_49_894 VPWR VGND sg13g2_decap_8
X_3042_ net788 videogen.test_lut_thingy.pixel_feeder_inst.row\[18\]\[2\] _0814_ _0286_
+ VPWR VGND sg13g2_mux2_1
X_4993_ net438 VGND VPWR _0347_ videogen.fancy_shader.video_y\[8\] net655 sg13g2_dfrbpq_2
XFILLER_24_739 VPWR VGND sg13g2_decap_4
X_3944_ videogen.test_lut_thingy.pixel_feeder_inst.row\[45\]\[0\] net574 _1607_ VPWR
+ VGND sg13g2_nor2_1
XFILLER_20_901 VPWR VGND sg13g2_fill_1
X_3875_ _1534_ _1535_ _1536_ _1537_ _1538_ VPWR VGND sg13g2_nor4_1
X_2826_ _0757_ net559 _0768_ VPWR VGND sg13g2_nor2b_2
X_2757_ net779 videogen.test_lut_thingy.pixel_feeder_inst.row\[49\]\[3\] _0746_ _0603_
+ VPWR VGND sg13g2_mux2_1
X_2688_ net648 videogen.test_lut_thingy.pixel_feeder_inst.h_pix\[1\] _0706_ VPWR VGND
+ sg13g2_nor2b_1
X_4427_ VGND VPWR net628 _2047_ _0407_ net773 sg13g2_a21oi_1
X_4358_ VGND VPWR net564 _1999_ _2008_ _1998_ sg13g2_a21oi_1
XFILLER_24_1018 VPWR VGND sg13g2_decap_8
XFILLER_47_809 VPWR VGND sg13g2_decap_8
X_3309_ net770 _0979_ _0980_ _0346_ VPWR VGND sg13g2_nor3_1
X_4289_ _1941_ red\[4\] _1939_ VPWR VGND sg13g2_xnor2_1
XFILLER_27_500 VPWR VGND sg13g2_decap_8
XFILLER_27_544 VPWR VGND sg13g2_decap_4
XFILLER_30_709 VPWR VGND sg13g2_fill_1
XFILLER_7_938 VPWR VGND sg13g2_decap_8
XFILLER_10_455 VPWR VGND sg13g2_fill_1
XFILLER_13_74 VPWR VGND sg13g2_decap_4
X_5036__382 VPWR VGND net382 sg13g2_tiehi
XFILLER_13_85 VPWR VGND sg13g2_fill_2
XFILLER_2_643 VPWR VGND sg13g2_decap_8
XFILLER_1_142 VPWR VGND sg13g2_fill_2
XFILLER_1_131 VPWR VGND sg13g2_decap_8
XFILLER_1_175 VPWR VGND sg13g2_fill_2
XFILLER_49_124 VPWR VGND sg13g2_decap_4
XFILLER_49_168 VPWR VGND sg13g2_decap_8
XFILLER_46_820 VPWR VGND sg13g2_decap_8
XFILLER_18_511 VPWR VGND sg13g2_fill_1
XFILLER_38_82 VPWR VGND sg13g2_fill_2
XFILLER_46_897 VPWR VGND sg13g2_decap_8
XFILLER_33_536 VPWR VGND sg13g2_fill_2
XFILLER_20_219 VPWR VGND sg13g2_fill_2
XFILLER_9_275 VPWR VGND sg13g2_fill_1
X_3660_ _1320_ _1321_ _1322_ _1323_ _1324_ VPWR VGND sg13g2_nor4_1
X_3591_ net636 VPWR _1255_ VGND _1249_ _1254_ sg13g2_o21ai_1
XFILLER_6_960 VPWR VGND sg13g2_decap_8
X_5261_ net322 VGND VPWR _0611_ videogen.test_lut_thingy.pixel_feeder_inst.row\[29\]\[3\]
+ _0240_ sg13g2_dfrbpq_1
X_4212_ _1869_ _1865_ _1868_ _1858_ _1854_ VPWR VGND sg13g2_a22oi_1
X_5192_ net369 VGND VPWR _0542_ videogen.test_lut_thingy.pixel_feeder_inst.row\[50\]\[2\]
+ _0171_ sg13g2_dfrbpq_1
X_4143_ _1800_ _1798_ _1799_ VPWR VGND sg13g2_nand2_1
X_4074_ net774 net1 _1734_ VPWR VGND sg13g2_nor2_2
XFILLER_49_691 VPWR VGND sg13g2_decap_8
X_3025_ _0708_ _0783_ _0811_ VPWR VGND sg13g2_nor2_2
XFILLER_37_864 VPWR VGND sg13g2_fill_1
XFILLER_36_330 VPWR VGND sg13g2_decap_8
X_4976_ net58 VGND VPWR _0330_ videogen.fancy_shader.shader_counter_reg\[3\] net659
+ sg13g2_dfrbpq_2
X_3927_ videogen.test_lut_thingy.pixel_feeder_inst.row\[63\]\[0\] net579 _1590_ VPWR
+ VGND sg13g2_nor2_1
X_3858_ net637 _1510_ _1521_ _1522_ VPWR VGND sg13g2_nor3_1
X_2809_ videogen.test_lut_thingy.pixel_feeder_inst.row\[43\]\[0\] net816 _0763_ _0568_
+ VPWR VGND sg13g2_mux2_1
X_3789_ net638 VPWR _1453_ VGND videogen.test_lut_thingy.pixel_feeder_inst.row\[27\]\[1\]
+ net577 sg13g2_o21ai_1
XFILLER_3_429 VPWR VGND sg13g2_fill_1
XFILLER_8_1001 VPWR VGND sg13g2_decap_8
XFILLER_47_606 VPWR VGND sg13g2_decap_8
XFILLER_27_352 VPWR VGND sg13g2_fill_2
XFILLER_27_396 VPWR VGND sg13g2_fill_1
XFILLER_7_768 VPWR VGND sg13g2_decap_8
XFILLER_40_61 VPWR VGND sg13g2_decap_4
XFILLER_6_289 VPWR VGND sg13g2_decap_8
XFILLER_3_930 VPWR VGND sg13g2_decap_8
XFILLER_2_440 VPWR VGND sg13g2_fill_2
XFILLER_38_628 VPWR VGND sg13g2_decap_8
X_4943__122 VPWR VGND net122 sg13g2_tiehi
XFILLER_1_77 VPWR VGND sg13g2_decap_8
XFILLER_46_694 VPWR VGND sg13g2_decap_8
XFILLER_18_363 VPWR VGND sg13g2_decap_8
XFILLER_34_823 VPWR VGND sg13g2_decap_8
XFILLER_34_834 VPWR VGND sg13g2_fill_2
X_4830_ net713 net757 _0187_ VPWR VGND sg13g2_nor2_1
XFILLER_34_867 VPWR VGND sg13g2_fill_1
X_4761_ net697 net741 _0118_ VPWR VGND sg13g2_nor2_1
X_4692_ net719 net764 _0049_ VPWR VGND sg13g2_nor2_1
X_3712_ net637 VPWR _1376_ VGND _1370_ _1375_ sg13g2_o21ai_1
X_3643_ videogen.test_lut_thingy.pixel_feeder_inst.row\[26\]\[3\] net600 _1307_ VPWR
+ VGND sg13g2_nor2_1
X_3574_ _1234_ _1235_ _1236_ _1237_ _1238_ VPWR VGND sg13g2_nor4_1
X_5313_ net206 VGND VPWR _0663_ videogen.test_lut_thingy.pixel_feeder_inst.row\[21\]\[0\]
+ _0257_ sg13g2_dfrbpq_1
X_5244_ net83 VGND VPWR _0594_ videogen.test_lut_thingy.pixel_feeder_inst.row\[38\]\[2\]
+ _0223_ sg13g2_dfrbpq_1
X_5175_ net53 VGND VPWR _0525_ videogen.test_lut_thingy.pixel_feeder_inst.row\[28\]\[1\]
+ _0154_ sg13g2_dfrbpq_1
Xhold29 serialize.shift_reg_r\[5\] VPWR VGND net474 sg13g2_dlygate4sd3_1
Xhold18 serialize.shift_reg_r\[8\] VPWR VGND net463 sg13g2_dlygate4sd3_1
X_4126_ _1768_ VPWR _1783_ VGND _1775_ _1780_ sg13g2_o21ai_1
X_4057_ VPWR VGND _1711_ _1703_ _1698_ _1631_ _1717_ _1632_ sg13g2_a221oi_1
X_3008_ net803 videogen.test_lut_thingy.pixel_feeder_inst.row\[15\]\[1\] _0807_ _0396_
+ VPWR VGND sg13g2_mux2_1
XFILLER_24_344 VPWR VGND sg13g2_decap_4
XFILLER_36_193 VPWR VGND sg13g2_fill_2
XFILLER_40_815 VPWR VGND sg13g2_decap_4
XFILLER_24_355 VPWR VGND sg13g2_decap_4
X_4959_ net92 VGND VPWR _0313_ videogen.test_lut_thingy.pixel_feeder_inst.v_counter\[2\]
+ net654 sg13g2_dfrbpq_2
X_4966__78 VPWR VGND net78 sg13g2_tiehi
X_4981__48 VPWR VGND net48 sg13g2_tiehi
XFILLER_10_97 VPWR VGND sg13g2_decap_8
XFILLER_10_86 VPWR VGND sg13g2_fill_1
XFILLER_48_904 VPWR VGND sg13g2_decap_8
XFILLER_0_933 VPWR VGND sg13g2_decap_8
XFILLER_47_447 VPWR VGND sg13g2_fill_2
XFILLER_34_108 VPWR VGND sg13g2_decap_4
XFILLER_43_642 VPWR VGND sg13g2_decap_8
XFILLER_16_878 VPWR VGND sg13g2_decap_8
XFILLER_15_399 VPWR VGND sg13g2_fill_1
XFILLER_30_325 VPWR VGND sg13g2_decap_4
XFILLER_31_859 VPWR VGND sg13g2_decap_4
XFILLER_7_576 VPWR VGND sg13g2_decap_4
X_3290_ videogen.fancy_shader.video_y\[9\] _0672_ _0845_ _0885_ _0967_ VPWR VGND sg13g2_and4_1
X_5288__71 VPWR VGND net71 sg13g2_tiehi
XFILLER_25_4 VPWR VGND sg13g2_decap_8
XFILLER_38_469 VPWR VGND sg13g2_decap_8
XFILLER_47_970 VPWR VGND sg13g2_decap_8
XFILLER_19_672 VPWR VGND sg13g2_fill_1
XFILLER_46_480 VPWR VGND sg13g2_decap_8
XFILLER_34_620 VPWR VGND sg13g2_decap_8
XFILLER_34_675 VPWR VGND sg13g2_decap_8
XFILLER_34_686 VPWR VGND sg13g2_fill_1
X_4813_ net696 net740 _0170_ VPWR VGND sg13g2_nor2_1
XFILLER_21_358 VPWR VGND sg13g2_decap_4
X_4744_ net707 net751 _0101_ VPWR VGND sg13g2_nor2_1
XFILLER_30_892 VPWR VGND sg13g2_fill_2
X_4675_ _0685_ net566 _0385_ VPWR VGND sg13g2_nor2_1
X_3626_ _1286_ _1287_ _1288_ _1289_ _1290_ VPWR VGND sg13g2_nor4_1
Xoutput19 net19 uo_out[6] VPWR VGND sg13g2_buf_1
X_3557_ _1218_ _1210_ _1208_ _1221_ VPWR VGND sg13g2_a21o_1
X_5227_ net220 VGND VPWR _0577_ videogen.test_lut_thingy.pixel_feeder_inst.row\[42\]\[1\]
+ _0206_ sg13g2_dfrbpq_1
X_3488_ _1144_ VPWR _1152_ VGND _1146_ _1151_ sg13g2_o21ai_1
X_5063__345 VPWR VGND net345 sg13g2_tiehi
X_5158_ net105 VGND VPWR _0508_ green_tmds_par\[2\] net665 sg13g2_dfrbpq_1
X_4109_ _1766_ _1759_ _1760_ _1755_ _1749_ VPWR VGND sg13g2_a22oi_1
X_5089_ net293 VGND VPWR _0439_ videogen.test_lut_thingy.pixel_feeder_inst.row\[62\]\[3\]
+ _0076_ sg13g2_dfrbpq_1
XFILLER_44_406 VPWR VGND sg13g2_fill_1
XFILLER_25_620 VPWR VGND sg13g2_decap_8
XFILLER_40_623 VPWR VGND sg13g2_decap_8
XFILLER_25_697 VPWR VGND sg13g2_decap_8
XFILLER_21_892 VPWR VGND sg13g2_decap_8
XFILLER_0_730 VPWR VGND sg13g2_decap_8
XFILLER_48_701 VPWR VGND sg13g2_decap_8
X_5109__253 VPWR VGND net253 sg13g2_tiehi
XFILLER_48_778 VPWR VGND sg13g2_decap_8
XFILLER_36_907 VPWR VGND sg13g2_decap_4
XFILLER_29_970 VPWR VGND sg13g2_decap_8
X_4940__125 VPWR VGND net125 sg13g2_tiehi
XFILLER_44_962 VPWR VGND sg13g2_fill_2
XFILLER_15_130 VPWR VGND sg13g2_fill_1
XFILLER_15_174 VPWR VGND sg13g2_decap_4
XFILLER_30_100 VPWR VGND sg13g2_fill_1
XFILLER_31_645 VPWR VGND sg13g2_fill_1
XFILLER_30_122 VPWR VGND sg13g2_decap_4
X_2790_ videogen.test_lut_thingy.pixel_feeder_inst.row\[41\]\[3\] net785 _0759_ _0583_
+ VPWR VGND sg13g2_mux2_1
XFILLER_8_841 VPWR VGND sg13g2_fill_1
XFILLER_12_892 VPWR VGND sg13g2_decap_4
XFILLER_31_689 VPWR VGND sg13g2_decap_4
XFILLER_30_199 VPWR VGND sg13g2_fill_1
X_4460_ _2095_ _2093_ _2094_ VPWR VGND sg13g2_nand2b_1
XFILLER_7_98 VPWR VGND sg13g2_fill_2
X_4391_ _2040_ tmds_red.dc_balancing_reg\[4\] _2039_ VPWR VGND sg13g2_xnor2_1
X_3411_ VGND VPWR _1060_ _1071_ _1075_ _1072_ sg13g2_a21oi_1
X_3342_ _1004_ _1002_ _1006_ VPWR VGND sg13g2_xor2_1
XFILLER_3_590 VPWR VGND sg13g2_decap_8
Xfanout809 net812 net809 VPWR VGND sg13g2_buf_8
X_3273_ VGND VPWR videogen.fancy_shader.shader_counter_reg\[8\] _0953_ _0956_ net772
+ sg13g2_a21oi_1
X_5307__254 VPWR VGND net254 sg13g2_tiehi
X_5012_ net417 VGND VPWR _0366_ red\[7\] net664 sg13g2_dfrbpq_2
XFILLER_38_222 VPWR VGND sg13g2_fill_1
XFILLER_16_0 VPWR VGND sg13g2_fill_2
XFILLER_22_601 VPWR VGND sg13g2_decap_8
XFILLER_22_645 VPWR VGND sg13g2_decap_8
XFILLER_22_656 VPWR VGND sg13g2_fill_1
XFILLER_22_678 VPWR VGND sg13g2_decap_4
X_2988_ net798 videogen.test_lut_thingy.pixel_feeder_inst.row\[9\]\[1\] _0803_ _0421_
+ VPWR VGND sg13g2_mux2_1
X_4727_ net684 net728 _0084_ VPWR VGND sg13g2_nor2_1
X_4658_ net721 net766 _0017_ VPWR VGND sg13g2_nor2_1
X_3609_ videogen.test_lut_thingy.pixel_feeder_inst.row\[38\]\[3\] net606 _1273_ VPWR
+ VGND sg13g2_nor2_1
X_4589_ VGND VPWR net626 _2209_ _0618_ _2201_ sg13g2_a21oi_1
XFILLER_49_509 VPWR VGND sg13g2_decap_8
XFILLER_45_726 VPWR VGND sg13g2_decap_4
XFILLER_29_299 VPWR VGND sg13g2_decap_4
XFILLER_44_269 VPWR VGND sg13g2_decap_8
XFILLER_16_30 VPWR VGND sg13g2_fill_1
XFILLER_25_472 VPWR VGND sg13g2_decap_8
XFILLER_9_627 VPWR VGND sg13g2_decap_8
XFILLER_9_638 VPWR VGND sg13g2_fill_2
XFILLER_32_40 VPWR VGND sg13g2_decap_8
XFILLER_5_866 VPWR VGND sg13g2_decap_8
X_5046__362 VPWR VGND net362 sg13g2_tiehi
XFILLER_48_575 VPWR VGND sg13g2_decap_8
XFILLER_17_940 VPWR VGND sg13g2_decap_4
XFILLER_36_759 VPWR VGND sg13g2_fill_1
X_3960_ VGND VPWR _1598_ _1622_ _1623_ _0686_ sg13g2_a21oi_1
X_2911_ net801 videogen.test_lut_thingy.pixel_feeder_inst.row\[55\]\[1\] _0786_ _0481_
+ VPWR VGND sg13g2_mux2_1
X_3891_ videogen.test_lut_thingy.pixel_feeder_inst.row\[19\]\[0\] net578 _1554_ VPWR
+ VGND sg13g2_nor2_1
X_2842_ net779 videogen.test_lut_thingy.pixel_feeder_inst.row\[50\]\[3\] _0771_ _0543_
+ VPWR VGND sg13g2_mux2_1
X_2773_ videogen.test_lut_thingy.pixel_feeder_inst.row\[38\]\[1\] net805 _0752_ _0593_
+ VPWR VGND sg13g2_mux2_1
X_4512_ net624 blue\[7\] blue\[1\] _2140_ VPWR VGND blue\[6\] sg13g2_nand4_1
XFILLER_7_170 VPWR VGND sg13g2_fill_2
X_4443_ _2079_ _2077_ _2078_ VPWR VGND sg13g2_xnor2_1
X_4374_ _2024_ _2021_ _2022_ VPWR VGND sg13g2_xnor2_1
Xfanout606 net608 net606 VPWR VGND sg13g2_buf_8
Xfanout639 net642 net639 VPWR VGND sg13g2_buf_8
X_3325_ VGND VPWR net772 _0353_ _0989_ _0988_ sg13g2_a21oi_2
Xfanout628 display_enable net628 VPWR VGND sg13g2_buf_8
Xfanout617 net618 net617 VPWR VGND sg13g2_buf_8
X_3256_ _0933_ VPWR _0944_ VGND net770 _0943_ sg13g2_o21ai_1
XFILLER_39_531 VPWR VGND sg13g2_fill_1
X_3187_ videogen.test_lut_thingy.pixel_feeder_inst.v_pix\[2\] _0895_ _0896_ VPWR VGND
+ sg13g2_nor2_1
XFILLER_2_1007 VPWR VGND sg13g2_decap_8
XFILLER_27_726 VPWR VGND sg13g2_decap_8
XFILLER_27_748 VPWR VGND sg13g2_fill_1
XFILLER_26_269 VPWR VGND sg13g2_decap_8
XFILLER_23_965 VPWR VGND sg13g2_fill_1
XFILLER_10_615 VPWR VGND sg13g2_decap_8
XFILLER_10_637 VPWR VGND sg13g2_decap_4
XFILLER_2_825 VPWR VGND sg13g2_decap_8
XFILLER_49_328 VPWR VGND sg13g2_fill_2
X_5182__439 VPWR VGND net439 sg13g2_tiehi
XFILLER_17_247 VPWR VGND sg13g2_decap_8
XFILLER_33_729 VPWR VGND sg13g2_decap_8
XFILLER_14_987 VPWR VGND sg13g2_fill_1
XFILLER_4_195 VPWR VGND sg13g2_decap_8
XFILLER_4_66 VPWR VGND sg13g2_decap_4
X_3110_ VGND VPWR _0850_ _0859_ net18 _0852_ sg13g2_a21oi_1
X_4090_ _1015_ _1042_ _1743_ _1747_ VPWR VGND sg13g2_nor3_2
XFILLER_49_873 VPWR VGND sg13g2_decap_8
X_3041_ net777 videogen.test_lut_thingy.pixel_feeder_inst.row\[18\]\[3\] _0814_ _0287_
+ VPWR VGND sg13g2_mux2_1
X_4992_ net440 VGND VPWR _0346_ videogen.fancy_shader.video_y\[7\] net655 sg13g2_dfrbpq_2
XFILLER_32_751 VPWR VGND sg13g2_fill_2
X_3943_ videogen.test_lut_thingy.pixel_feeder_inst.row\[46\]\[0\] net606 _1606_ VPWR
+ VGND sg13g2_nor2_1
XFILLER_17_1026 VPWR VGND sg13g2_fill_2
X_3874_ videogen.test_lut_thingy.pixel_feeder_inst.row\[3\]\[0\] net582 _1537_ VPWR
+ VGND sg13g2_nor2_1
X_2825_ videogen.test_lut_thingy.pixel_feeder_inst.row\[46\]\[0\] net816 _0767_ _0556_
+ VPWR VGND sg13g2_mux2_1
X_2756_ _0746_ _0735_ _0744_ VPWR VGND sg13g2_nand2_2
X_2687_ _0705_ net620 _0702_ VPWR VGND sg13g2_nand2_2
X_4426_ VGND VPWR net628 net556 _0406_ net773 sg13g2_a21oi_1
XFILLER_48_28 VPWR VGND sg13g2_decap_8
X_4357_ VGND VPWR _1996_ _2007_ _0368_ net565 sg13g2_a21oi_1
X_3308_ _0692_ _0974_ _0980_ VPWR VGND sg13g2_nor2_1
X_4288_ _1940_ red\[6\] _1939_ VPWR VGND sg13g2_xnor2_1
XFILLER_39_350 VPWR VGND sg13g2_decap_8
X_3239_ _0927_ _0931_ _0317_ VPWR VGND sg13g2_nor2_1
XFILLER_39_372 VPWR VGND sg13g2_fill_1
XFILLER_14_228 VPWR VGND sg13g2_decap_8
X_5140__191 VPWR VGND net191 sg13g2_tiehi
XFILLER_14_239 VPWR VGND sg13g2_fill_2
XFILLER_23_773 VPWR VGND sg13g2_decap_8
XFILLER_23_784 VPWR VGND sg13g2_fill_1
XFILLER_7_917 VPWR VGND sg13g2_decap_8
XFILLER_13_53 VPWR VGND sg13g2_decap_8
XFILLER_6_438 VPWR VGND sg13g2_decap_4
XFILLER_2_622 VPWR VGND sg13g2_decap_8
XFILLER_2_699 VPWR VGND sg13g2_decap_8
XFILLER_49_147 VPWR VGND sg13g2_decap_8
XFILLER_1_187 VPWR VGND sg13g2_fill_2
XFILLER_37_309 VPWR VGND sg13g2_fill_1
XFILLER_18_534 VPWR VGND sg13g2_decap_8
XFILLER_46_876 VPWR VGND sg13g2_decap_8
X_5193__365 VPWR VGND net365 sg13g2_tiehi
XFILLER_14_773 VPWR VGND sg13g2_fill_2
XFILLER_41_592 VPWR VGND sg13g2_decap_8
XFILLER_9_210 VPWR VGND sg13g2_fill_2
XFILLER_9_287 VPWR VGND sg13g2_decap_4
X_3590_ net639 VPWR _1254_ VGND _1250_ _1253_ sg13g2_o21ai_1
XFILLER_47_1019 VPWR VGND sg13g2_decap_8
X_5260_ net330 VGND VPWR _0610_ videogen.test_lut_thingy.pixel_feeder_inst.row\[29\]\[2\]
+ _0239_ sg13g2_dfrbpq_1
XFILLER_5_471 VPWR VGND sg13g2_decap_8
X_4211_ _1868_ _1866_ _1867_ VPWR VGND sg13g2_nand2_1
X_5191_ net373 VGND VPWR _0541_ videogen.test_lut_thingy.pixel_feeder_inst.row\[50\]\[1\]
+ _0170_ sg13g2_dfrbpq_1
X_4142_ _1788_ VPWR _1799_ VGND _1789_ _1791_ sg13g2_o21ai_1
XFILLER_49_670 VPWR VGND sg13g2_decap_8
XFILLER_37_810 VPWR VGND sg13g2_decap_8
X_4073_ _1731_ _1723_ _1732_ _1733_ VPWR VGND sg13g2_a21o_2
XFILLER_37_832 VPWR VGND sg13g2_fill_2
X_3024_ videogen.test_lut_thingy.pixel_feeder_inst.row\[12\]\[0\] net814 _0810_ _0380_
+ VPWR VGND sg13g2_mux2_1
Xclkbuf_3_4_0_clk_regs clknet_0_clk_regs clknet_3_4_0_clk_regs VPWR VGND sg13g2_buf_8
XFILLER_24_537 VPWR VGND sg13g2_fill_2
XFILLER_36_386 VPWR VGND sg13g2_fill_2
X_4978__54 VPWR VGND net54 sg13g2_tiehi
X_4975_ net60 VGND VPWR _0329_ videogen.fancy_shader.shader_counter_reg\[2\] net656
+ sg13g2_dfrbpq_2
X_5059__350 VPWR VGND net350 sg13g2_tiehi
X_3926_ videogen.test_lut_thingy.pixel_feeder_inst.row\[62\]\[0\] net603 _1589_ VPWR
+ VGND sg13g2_nor2_1
XFILLER_20_732 VPWR VGND sg13g2_decap_8
XFILLER_20_776 VPWR VGND sg13g2_fill_2
X_3857_ net641 _1515_ _1520_ _1521_ VPWR VGND sg13g2_nor3_1
X_2808_ videogen.test_lut_thingy.pixel_feeder_inst.row\[43\]\[1\] net806 _0763_ _0569_
+ VPWR VGND sg13g2_mux2_1
X_3788_ net636 _1440_ _1451_ _1452_ VPWR VGND sg13g2_nor3_1
X_2739_ _0708_ _0733_ _0737_ VPWR VGND sg13g2_nor2_2
X_4409_ _0685_ _2051_ _2052_ VPWR VGND sg13g2_and2_1
XFILLER_27_320 VPWR VGND sg13g2_fill_1
XFILLER_43_813 VPWR VGND sg13g2_decap_8
XFILLER_15_504 VPWR VGND sg13g2_fill_1
XFILLER_42_345 VPWR VGND sg13g2_fill_2
XFILLER_15_559 VPWR VGND sg13g2_decap_8
XFILLER_42_389 VPWR VGND sg13g2_decap_8
X_5073__325 VPWR VGND net325 sg13g2_tiehi
XFILLER_24_96 VPWR VGND sg13g2_fill_1
XFILLER_3_986 VPWR VGND sg13g2_decap_8
XFILLER_37_106 VPWR VGND sg13g2_decap_8
XFILLER_1_56 VPWR VGND sg13g2_decap_8
XFILLER_19_810 VPWR VGND sg13g2_decap_8
XFILLER_19_821 VPWR VGND sg13g2_fill_1
XFILLER_46_673 VPWR VGND sg13g2_decap_8
XFILLER_45_172 VPWR VGND sg13g2_fill_2
XFILLER_19_887 VPWR VGND sg13g2_decap_8
X_4760_ net697 net741 _0117_ VPWR VGND sg13g2_nor2_1
XFILLER_21_529 VPWR VGND sg13g2_decap_4
X_5119__233 VPWR VGND net233 sg13g2_tiehi
X_4691_ net706 net750 _0048_ VPWR VGND sg13g2_nor2_1
X_3711_ net644 VPWR _1375_ VGND _1371_ _1374_ sg13g2_o21ai_1
X_3642_ videogen.test_lut_thingy.pixel_feeder_inst.row\[27\]\[3\] net577 _1306_ VPWR
+ VGND sg13g2_nor2_1
X_5234__192 VPWR VGND net192 sg13g2_tiehi
X_3573_ videogen.test_lut_thingy.pixel_feeder_inst.row\[53\]\[3\] net569 _1237_ VPWR
+ VGND sg13g2_nor2_1
X_5312_ net214 VGND VPWR net447 clockdiv.q0 clknet_3_4_0_clk_regs sg13g2_dfrbpq_1
XFILLER_46_0 VPWR VGND sg13g2_decap_8
X_5050__177 VPWR VGND net177 sg13g2_tiehi
X_5243_ net107 VGND VPWR _0593_ videogen.test_lut_thingy.pixel_feeder_inst.row\[38\]\[1\]
+ _0222_ sg13g2_dfrbpq_1
Xhold19 serialize.shift_reg_b\[4\] VPWR VGND net464 sg13g2_dlygate4sd3_1
X_5174_ net57 VGND VPWR _0524_ videogen.test_lut_thingy.pixel_feeder_inst.row\[28\]\[0\]
+ _0153_ sg13g2_dfrbpq_1
X_4125_ VPWR VGND _1779_ _1769_ _1776_ _1771_ _1782_ _1772_ sg13g2_a221oi_1
XFILLER_45_18 VPWR VGND sg13g2_fill_2
X_4056_ _1716_ _1697_ _1704_ VPWR VGND sg13g2_nand2_1
XFILLER_37_684 VPWR VGND sg13g2_decap_8
X_3007_ net792 videogen.test_lut_thingy.pixel_feeder_inst.row\[15\]\[2\] _0807_ _0397_
+ VPWR VGND sg13g2_mux2_1
XFILLER_40_849 VPWR VGND sg13g2_decap_8
X_4958_ net94 VGND VPWR _0312_ videogen.test_lut_thingy.pixel_feeder_inst.v_counter\[1\]
+ net654 sg13g2_dfrbpq_1
XFILLER_33_890 VPWR VGND sg13g2_fill_1
X_4889_ net681 net725 _0244_ VPWR VGND sg13g2_nor2_1
X_3909_ _1568_ _1569_ _1570_ _1571_ _1572_ VPWR VGND sg13g2_nor4_1
X_5213__276 VPWR VGND net276 sg13g2_tiehi
XFILLER_3_227 VPWR VGND sg13g2_fill_1
XFILLER_10_54 VPWR VGND sg13g2_fill_1
XFILLER_10_32 VPWR VGND sg13g2_decap_8
XFILLER_0_912 VPWR VGND sg13g2_decap_8
XFILLER_0_989 VPWR VGND sg13g2_decap_8
XFILLER_19_117 VPWR VGND sg13g2_decap_8
XFILLER_16_824 VPWR VGND sg13g2_fill_1
XFILLER_27_161 VPWR VGND sg13g2_fill_1
XFILLER_43_621 VPWR VGND sg13g2_decap_8
XFILLER_35_40 VPWR VGND sg13g2_decap_8
XFILLER_42_131 VPWR VGND sg13g2_decap_8
XFILLER_15_378 VPWR VGND sg13g2_decap_8
XFILLER_43_698 VPWR VGND sg13g2_decap_4
XFILLER_3_783 VPWR VGND sg13g2_decap_8
XFILLER_20_1022 VPWR VGND sg13g2_decap_8
XFILLER_18_194 VPWR VGND sg13g2_fill_2
XFILLER_19_695 VPWR VGND sg13g2_fill_2
X_4812_ net696 net740 _0169_ VPWR VGND sg13g2_nor2_1
XFILLER_21_326 VPWR VGND sg13g2_decap_8
X_4743_ net683 net727 _0100_ VPWR VGND sg13g2_nor2_1
X_5056__353 VPWR VGND net353 sg13g2_tiehi
X_4674_ net708 net752 _0032_ VPWR VGND sg13g2_nor2_1
X_3625_ videogen.test_lut_thingy.pixel_feeder_inst.row\[2\]\[3\] net601 _1289_ VPWR
+ VGND sg13g2_nor2_1
X_3556_ _1220_ _1012_ _1217_ VPWR VGND sg13g2_xnor2_1
XFILLER_0_208 VPWR VGND sg13g2_decap_8
X_5226_ net224 VGND VPWR _0576_ videogen.test_lut_thingy.pixel_feeder_inst.row\[42\]\[0\]
+ _0205_ sg13g2_dfrbpq_1
X_3487_ _1136_ _1141_ _1149_ _1151_ VPWR VGND sg13g2_nor3_1
X_5157_ net109 VGND VPWR _0507_ videogen.test_lut_thingy.pixel_feeder_inst.row\[52\]\[3\]
+ _0144_ sg13g2_dfrbpq_1
XFILLER_5_1027 VPWR VGND sg13g2_fill_2
X_4108_ _1761_ _1762_ _1764_ _1765_ VPWR VGND sg13g2_or3_1
X_5088_ net295 VGND VPWR _0438_ videogen.test_lut_thingy.pixel_feeder_inst.row\[62\]\[2\]
+ _0075_ sg13g2_dfrbpq_1
XFILLER_44_429 VPWR VGND sg13g2_decap_4
X_4039_ _1686_ VPWR _1699_ VGND _1693_ _1695_ sg13g2_o21ai_1
XFILLER_13_816 VPWR VGND sg13g2_decap_8
XFILLER_40_679 VPWR VGND sg13g2_decap_8
X_5254__387 VPWR VGND net387 sg13g2_tiehi
X_4933__133 VPWR VGND net133 sg13g2_tiehi
XFILLER_4_558 VPWR VGND sg13g2_decap_8
XFILLER_47_212 VPWR VGND sg13g2_decap_8
XFILLER_0_786 VPWR VGND sg13g2_decap_8
XFILLER_48_757 VPWR VGND sg13g2_decap_8
XFILLER_47_289 VPWR VGND sg13g2_fill_1
XFILLER_16_610 VPWR VGND sg13g2_decap_8
XFILLER_16_654 VPWR VGND sg13g2_fill_2
XFILLER_15_164 VPWR VGND sg13g2_decap_4
XFILLER_16_687 VPWR VGND sg13g2_decap_8
XFILLER_8_831 VPWR VGND sg13g2_decap_4
X_3410_ _1071_ _1072_ _1060_ _1074_ VPWR VGND sg13g2_nand3_1
X_4390_ _2039_ _2009_ _2011_ VPWR VGND sg13g2_nand2_1
X_3341_ _1005_ _1002_ _1004_ VPWR VGND sg13g2_nand2b_1
X_3272_ VGND VPWR _0688_ _0951_ _0334_ _0955_ sg13g2_a21oi_1
X_5011_ net418 VGND VPWR _0365_ red\[6\] net661 sg13g2_dfrbpq_2
XFILLER_19_470 VPWR VGND sg13g2_fill_2
XFILLER_10_819 VPWR VGND sg13g2_decap_4
X_2987_ net787 videogen.test_lut_thingy.pixel_feeder_inst.row\[9\]\[2\] _0803_ _0422_
+ VPWR VGND sg13g2_mux2_1
X_4726_ net698 net742 _0083_ VPWR VGND sg13g2_nor2_1
X_4657_ net686 net732 _0016_ VPWR VGND sg13g2_nor2_1
X_3608_ net647 VPWR _1272_ VGND videogen.test_lut_thingy.pixel_feeder_inst.row\[37\]\[3\]
+ net574 sg13g2_o21ai_1
X_4588_ _2209_ _2203_ _2208_ VPWR VGND sg13g2_xnor2_1
XFILLER_1_539 VPWR VGND sg13g2_decap_8
X_3539_ _1192_ _1202_ _1182_ _1203_ VPWR VGND sg13g2_nand3_1
XFILLER_27_1028 VPWR VGND sg13g2_fill_1
X_5209_ net292 VGND VPWR _0559_ videogen.test_lut_thingy.pixel_feeder_inst.row\[46\]\[3\]
+ _0188_ sg13g2_dfrbpq_1
XFILLER_45_705 VPWR VGND sg13g2_decap_8
XFILLER_44_259 VPWR VGND sg13g2_fill_1
XFILLER_16_53 VPWR VGND sg13g2_fill_2
XFILLER_13_646 VPWR VGND sg13g2_decap_4
XFILLER_12_178 VPWR VGND sg13g2_decap_8
XFILLER_40_498 VPWR VGND sg13g2_decap_8
XFILLER_32_74 VPWR VGND sg13g2_decap_8
XFILLER_5_845 VPWR VGND sg13g2_decap_8
XFILLER_10_1021 VPWR VGND sg13g2_decap_8
X_5189__381 VPWR VGND net381 sg13g2_tiehi
XFILLER_0_583 VPWR VGND sg13g2_decap_8
XFILLER_48_554 VPWR VGND sg13g2_decap_8
XFILLER_17_963 VPWR VGND sg13g2_fill_1
X_2910_ net790 videogen.test_lut_thingy.pixel_feeder_inst.row\[55\]\[2\] _0786_ _0482_
+ VPWR VGND sg13g2_mux2_1
XFILLER_16_484 VPWR VGND sg13g2_fill_2
X_3890_ videogen.test_lut_thingy.pixel_feeder_inst.row\[17\]\[0\] net568 _1553_ VPWR
+ VGND sg13g2_nor2_1
XFILLER_32_944 VPWR VGND sg13g2_fill_2
X_2841_ _0771_ _0744_ _0760_ VPWR VGND sg13g2_nand2_2
XFILLER_31_465 VPWR VGND sg13g2_decap_4
X_2772_ videogen.test_lut_thingy.pixel_feeder_inst.row\[38\]\[2\] net794 _0752_ _0594_
+ VPWR VGND sg13g2_mux2_1
X_4511_ blue\[1\] net624 blue\[6\] _2139_ VPWR VGND sg13g2_or3_1
XFILLER_8_683 VPWR VGND sg13g2_fill_1
XFILLER_8_672 VPWR VGND sg13g2_fill_2
X_5053__356 VPWR VGND net356 sg13g2_tiehi
X_4442_ _2078_ net622 _2067_ VPWR VGND sg13g2_nand2_1
X_4916__161 VPWR VGND net161 sg13g2_tiehi
X_4373_ _2023_ _2021_ _2022_ VPWR VGND sg13g2_nand2b_1
Xfanout607 net608 net607 VPWR VGND sg13g2_buf_8
X_3324_ VGND VPWR _0697_ _0829_ _0989_ _0818_ sg13g2_a21oi_1
Xfanout629 videogen.fancy_shader.video_y\[0\] net629 VPWR VGND sg13g2_buf_8
Xfanout618 _0677_ net618 VPWR VGND sg13g2_buf_8
X_3255_ net633 videogen.fancy_shader.shader_counter_reg\[3\] videogen.fancy_shader.shader_counter_reg\[2\]
+ net632 _0943_ VPWR VGND sg13g2_and4_1
X_3186_ net563 _0894_ _0895_ _0300_ VPWR VGND sg13g2_nor3_1
X_5060__349 VPWR VGND net349 sg13g2_tiehi
XFILLER_41_218 VPWR VGND sg13g2_fill_1
XFILLER_34_292 VPWR VGND sg13g2_decap_8
XFILLER_6_609 VPWR VGND sg13g2_fill_1
X_4709_ net706 net750 _0066_ VPWR VGND sg13g2_nor2_1
XFILLER_2_804 VPWR VGND sg13g2_decap_8
XFILLER_1_303 VPWR VGND sg13g2_fill_1
XFILLER_49_318 VPWR VGND sg13g2_fill_2
XFILLER_45_579 VPWR VGND sg13g2_decap_8
XFILLER_27_74 VPWR VGND sg13g2_fill_2
XFILLER_32_229 VPWR VGND sg13g2_fill_2
XFILLER_13_421 VPWR VGND sg13g2_decap_8
XFILLER_25_281 VPWR VGND sg13g2_decap_8
XFILLER_43_73 VPWR VGND sg13g2_decap_4
XFILLER_13_465 VPWR VGND sg13g2_decap_8
XFILLER_5_675 VPWR VGND sg13g2_decap_8
XFILLER_4_141 VPWR VGND sg13g2_fill_2
XFILLER_4_34 VPWR VGND sg13g2_decap_4
X_5083__305 VPWR VGND net305 sg13g2_tiehi
XFILLER_49_852 VPWR VGND sg13g2_decap_8
X_3040_ _0720_ _0760_ net560 _0814_ VPWR VGND sg13g2_nand3_1
XFILLER_36_502 VPWR VGND sg13g2_fill_1
X_5246__67 VPWR VGND net67 sg13g2_tiehi
X_4991_ net442 VGND VPWR _0345_ videogen.fancy_shader.video_y\[6\] net655 sg13g2_dfrbpq_2
X_3942_ videogen.test_lut_thingy.pixel_feeder_inst.row\[44\]\[0\] net597 _1605_ VPWR
+ VGND sg13g2_nor2_1
X_3873_ videogen.test_lut_thingy.pixel_feeder_inst.row\[0\]\[0\] net590 _1536_ VPWR
+ VGND sg13g2_nor2_1
XFILLER_31_262 VPWR VGND sg13g2_fill_2
XFILLER_32_763 VPWR VGND sg13g2_decap_4
X_2824_ videogen.test_lut_thingy.pixel_feeder_inst.row\[46\]\[1\] net806 _0767_ _0557_
+ VPWR VGND sg13g2_mux2_1
XFILLER_31_273 VPWR VGND sg13g2_decap_8
X_2755_ net560 _0742_ net619 _0745_ VPWR VGND sg13g2_nand3_1
X_2686_ _0704_ net619 _0703_ VPWR VGND sg13g2_nand2_2
X_5167__85 VPWR VGND net85 sg13g2_tiehi
X_4425_ VGND VPWR net628 _2064_ _0405_ net773 sg13g2_a21oi_1
X_4356_ _2007_ _2004_ _2006_ VPWR VGND sg13g2_nand2_1
X_5129__213 VPWR VGND net213 sg13g2_tiehi
X_3307_ VGND VPWR videogen.fancy_shader.video_y\[6\] _0977_ _0979_ videogen.fancy_shader.video_y\[7\]
+ sg13g2_a21oi_1
X_4287_ red\[0\] red\[2\] _1939_ VPWR VGND sg13g2_xor2_1
X_5209__292 VPWR VGND net292 sg13g2_tiehi
X_3238_ _0931_ videogen.test_lut_thingy.pixel_feeder_inst.h_counter\[2\] _0929_ VPWR
+ VGND sg13g2_xnor2_1
X_3169_ _0883_ videogen.fancy_shader.video_x\[8\] _0880_ VPWR VGND sg13g2_xnor2_1
XFILLER_35_590 VPWR VGND sg13g2_decap_8
XFILLER_10_402 VPWR VGND sg13g2_fill_2
XFILLER_11_947 VPWR VGND sg13g2_fill_2
XFILLER_22_295 VPWR VGND sg13g2_fill_2
XFILLER_6_406 VPWR VGND sg13g2_decap_8
XFILLER_13_98 VPWR VGND sg13g2_decap_8
XFILLER_2_678 VPWR VGND sg13g2_decap_8
XFILLER_46_855 VPWR VGND sg13g2_decap_8
XFILLER_33_538 VPWR VGND sg13g2_fill_1
XFILLER_13_284 VPWR VGND sg13g2_decap_8
XFILLER_6_995 VPWR VGND sg13g2_decap_8
X_4913__164 VPWR VGND net164 sg13g2_tiehi
X_4210_ _1867_ _1845_ _1848_ VPWR VGND sg13g2_nand2_1
X_5190_ net377 VGND VPWR _0540_ videogen.test_lut_thingy.pixel_feeder_inst.row\[50\]\[0\]
+ _0169_ sg13g2_dfrbpq_1
X_4141_ VPWR _1798_ _1797_ VGND sg13g2_inv_1
X_4072_ _1732_ net819 net1 VPWR VGND sg13g2_nand2_1
X_3023_ videogen.test_lut_thingy.pixel_feeder_inst.row\[12\]\[1\] net804 _0810_ _0381_
+ VPWR VGND sg13g2_mux2_1
XFILLER_36_365 VPWR VGND sg13g2_decap_8
X_4974_ net62 VGND VPWR _0328_ videogen.fancy_shader.shader_counter_reg\[1\] net659
+ sg13g2_dfrbpq_1
X_4920__157 VPWR VGND net157 sg13g2_tiehi
X_3925_ videogen.test_lut_thingy.pixel_feeder_inst.row\[61\]\[0\] net569 _1588_ VPWR
+ VGND sg13g2_nor2_1
XFILLER_32_571 VPWR VGND sg13g2_decap_8
X_3856_ _1516_ _1517_ _1518_ _1519_ _1520_ VPWR VGND sg13g2_nor4_1
X_2807_ videogen.test_lut_thingy.pixel_feeder_inst.row\[43\]\[2\] net796 _0763_ _0570_
+ VPWR VGND sg13g2_mux2_1
X_3787_ net612 _1445_ _1450_ _1451_ VPWR VGND sg13g2_nor3_1
X_2738_ net808 videogen.test_lut_thingy.pixel_feeder_inst.row\[25\]\[0\] _0736_ _0622_
+ VPWR VGND sg13g2_mux2_1
X_2669_ VPWR _0688_ videogen.fancy_shader.shader_counter_reg\[7\] VGND sg13g2_inv_1
X_4408_ tmds_green.dc_balancing_reg\[0\] tmds_green.dc_balancing_reg\[1\] tmds_green.dc_balancing_reg\[3\]
+ tmds_green.dc_balancing_reg\[2\] _2051_ VPWR VGND sg13g2_nor4_1
X_4339_ _1965_ VPWR _1990_ VGND _1964_ _1975_ sg13g2_o21ai_1
XFILLER_28_800 VPWR VGND sg13g2_decap_4
XFILLER_27_354 VPWR VGND sg13g2_fill_1
XFILLER_43_869 VPWR VGND sg13g2_decap_8
X_5257__363 VPWR VGND net363 sg13g2_tiehi
XFILLER_24_31 VPWR VGND sg13g2_fill_2
XFILLER_10_265 VPWR VGND sg13g2_decap_8
XFILLER_11_788 VPWR VGND sg13g2_decap_8
XFILLER_3_965 VPWR VGND sg13g2_decap_8
XFILLER_2_431 VPWR VGND sg13g2_decap_4
XFILLER_2_464 VPWR VGND sg13g2_decap_4
XFILLER_49_94 VPWR VGND sg13g2_decap_8
XFILLER_1_35 VPWR VGND sg13g2_decap_8
XFILLER_19_833 VPWR VGND sg13g2_decap_8
Xfanout790 net791 net790 VPWR VGND sg13g2_buf_8
XFILLER_46_652 VPWR VGND sg13g2_decap_8
XFILLER_19_877 VPWR VGND sg13g2_fill_2
XFILLER_14_582 VPWR VGND sg13g2_decap_8
X_3710_ _1373_ VPWR _1374_ VGND videogen.test_lut_thingy.pixel_feeder_inst.row\[62\]\[2\]
+ net603 sg13g2_o21ai_1
X_4690_ net705 net749 _0047_ VPWR VGND sg13g2_nor2_1
X_3641_ videogen.test_lut_thingy.pixel_feeder_inst.row\[24\]\[3\] net588 _1305_ VPWR
+ VGND sg13g2_nor2_1
X_3572_ videogen.test_lut_thingy.pixel_feeder_inst.row\[55\]\[3\] net580 _1236_ VPWR
+ VGND sg13g2_nor2_1
X_5311_ net222 VGND VPWR _0661_ serialize.shift_reg_r\[7\] clknet_3_7_0_clk_regs sg13g2_dfrbpq_1
XFILLER_6_792 VPWR VGND sg13g2_decap_8
X_5242_ net115 VGND VPWR _0592_ videogen.test_lut_thingy.pixel_feeder_inst.row\[38\]\[0\]
+ _0221_ sg13g2_dfrbpq_1
XFILLER_39_0 VPWR VGND sg13g2_fill_1
X_5173_ net61 VGND VPWR _0523_ videogen.test_lut_thingy.pixel_feeder_inst.row\[2\]\[3\]
+ _0152_ sg13g2_dfrbpq_1
X_4124_ VGND VPWR _1768_ _1775_ _1781_ _1780_ sg13g2_a21oi_1
Xinput1 ui_in[0] net1 VPWR VGND sg13g2_buf_2
XFILLER_28_107 VPWR VGND sg13g2_fill_2
X_4055_ _1714_ _0994_ _1715_ VPWR VGND sg13g2_xor2_1
XFILLER_37_663 VPWR VGND sg13g2_decap_8
X_3006_ net782 videogen.test_lut_thingy.pixel_feeder_inst.row\[15\]\[3\] _0807_ _0398_
+ VPWR VGND sg13g2_mux2_1
XFILLER_25_825 VPWR VGND sg13g2_fill_1
XFILLER_36_151 VPWR VGND sg13g2_fill_1
XFILLER_36_162 VPWR VGND sg13g2_fill_1
X_4957_ net96 VGND VPWR _0311_ videogen.test_lut_thingy.pixel_feeder_inst.v_counter\[0\]
+ net654 sg13g2_dfrbpq_1
XFILLER_33_880 VPWR VGND sg13g2_fill_1
X_4888_ net681 net725 _0243_ VPWR VGND sg13g2_nor2_1
X_3908_ videogen.test_lut_thingy.pixel_feeder_inst.row\[28\]\[0\] net594 _1571_ VPWR
+ VGND sg13g2_nor2_1
X_3839_ videogen.test_lut_thingy.pixel_feeder_inst.row\[41\]\[1\] net575 _1503_ VPWR
+ VGND sg13g2_nor2_1
XFILLER_20_596 VPWR VGND sg13g2_fill_1
XFILLER_4_729 VPWR VGND sg13g2_decap_8
XFILLER_3_239 VPWR VGND sg13g2_decap_8
XFILLER_10_77 VPWR VGND sg13g2_decap_8
XFILLER_10_66 VPWR VGND sg13g2_decap_8
XFILLER_0_968 VPWR VGND sg13g2_decap_8
XFILLER_48_939 VPWR VGND sg13g2_decap_8
XFILLER_19_107 VPWR VGND sg13g2_decap_4
XFILLER_19_129 VPWR VGND sg13g2_decap_8
XFILLER_47_449 VPWR VGND sg13g2_fill_1
XFILLER_28_652 VPWR VGND sg13g2_decap_8
X_5220__248 VPWR VGND net248 sg13g2_tiehi
XFILLER_43_600 VPWR VGND sg13g2_decap_8
XFILLER_15_324 VPWR VGND sg13g2_decap_4
XFILLER_16_836 VPWR VGND sg13g2_decap_8
XFILLER_43_677 VPWR VGND sg13g2_decap_8
XFILLER_35_74 VPWR VGND sg13g2_fill_2
XFILLER_42_165 VPWR VGND sg13g2_decap_8
XFILLER_11_530 VPWR VGND sg13g2_decap_8
XFILLER_11_541 VPWR VGND sg13g2_decap_4
X_4965__80 VPWR VGND net80 sg13g2_tiehi
X_4980__50 VPWR VGND net50 sg13g2_tiehi
XFILLER_3_762 VPWR VGND sg13g2_decap_8
XFILLER_32_7 VPWR VGND sg13g2_fill_2
X_4910__167 VPWR VGND net167 sg13g2_tiehi
XFILLER_18_162 VPWR VGND sg13g2_decap_8
XFILLER_18_184 VPWR VGND sg13g2_fill_2
X_4811_ net681 net725 _0168_ VPWR VGND sg13g2_nor2_1
X_4742_ net692 net736 _0099_ VPWR VGND sg13g2_nor2_1
X_4673_ net707 net751 _0031_ VPWR VGND sg13g2_nor2_1
X_3624_ videogen.test_lut_thingy.pixel_feeder_inst.row\[1\]\[3\] net568 _1288_ VPWR
+ VGND sg13g2_nor2_1
X_5091__289 VPWR VGND net289 sg13g2_tiehi
X_3555_ _1219_ _1210_ _1218_ VPWR VGND sg13g2_xnor2_1
X_3486_ net561 _1149_ _1150_ VPWR VGND sg13g2_nor2_1
X_5225_ net228 VGND VPWR _0575_ videogen.test_lut_thingy.pixel_feeder_inst.row\[19\]\[3\]
+ _0204_ sg13g2_dfrbpq_1
X_5156_ net113 VGND VPWR _0506_ videogen.test_lut_thingy.pixel_feeder_inst.row\[52\]\[2\]
+ _0143_ sg13g2_dfrbpq_1
XFILLER_5_1006 VPWR VGND sg13g2_decap_8
XFILLER_29_427 VPWR VGND sg13g2_decap_4
X_4107_ _1764_ _1642_ _1747_ VPWR VGND sg13g2_xnor2_1
X_5087_ net297 VGND VPWR _0437_ videogen.test_lut_thingy.pixel_feeder_inst.row\[62\]\[1\]
+ _0074_ sg13g2_dfrbpq_1
X_4038_ _1696_ _1692_ _1693_ _1698_ VPWR VGND sg13g2_a21o_1
XFILLER_25_688 VPWR VGND sg13g2_fill_1
XFILLER_40_658 VPWR VGND sg13g2_decap_8
XFILLER_20_360 VPWR VGND sg13g2_fill_2
X_5137__197 VPWR VGND net197 sg13g2_tiehi
XFILLER_20_393 VPWR VGND sg13g2_decap_4
XFILLER_4_537 VPWR VGND sg13g2_decap_8
XFILLER_0_765 VPWR VGND sg13g2_decap_8
XFILLER_48_736 VPWR VGND sg13g2_decap_8
XFILLER_47_235 VPWR VGND sg13g2_fill_2
X_5302__334 VPWR VGND net334 sg13g2_tiehi
XFILLER_46_51 VPWR VGND sg13g2_fill_2
XFILLER_35_419 VPWR VGND sg13g2_fill_2
XFILLER_43_441 VPWR VGND sg13g2_fill_1
XFILLER_31_603 VPWR VGND sg13g2_fill_1
XFILLER_30_146 VPWR VGND sg13g2_fill_2
XFILLER_8_810 VPWR VGND sg13g2_decap_8
X_3340_ _1004_ videogen.fancy_shader.video_x\[2\] videogen.fancy_shader.shader_counter_reg\[2\]
+ VPWR VGND sg13g2_xnor2_1
X_3271_ _0955_ _0936_ _0954_ _0934_ videogen.fancy_shader.shader_counter_reg\[7\]
+ VPWR VGND sg13g2_a22oi_1
X_5010_ net419 VGND VPWR _0364_ red\[4\] net661 sg13g2_dfrbpq_2
XFILLER_39_736 VPWR VGND sg13g2_fill_2
XFILLER_16_2 VPWR VGND sg13g2_fill_1
XFILLER_35_931 VPWR VGND sg13g2_fill_2
XFILLER_34_430 VPWR VGND sg13g2_fill_1
XFILLER_34_441 VPWR VGND sg13g2_decap_8
XFILLER_21_102 VPWR VGND sg13g2_decap_4
XFILLER_22_614 VPWR VGND sg13g2_decap_8
X_2986_ net776 videogen.test_lut_thingy.pixel_feeder_inst.row\[9\]\[3\] _0803_ _0423_
+ VPWR VGND sg13g2_mux2_1
XFILLER_21_168 VPWR VGND sg13g2_fill_2
X_4725_ net684 net728 _0082_ VPWR VGND sg13g2_nor2_1
XFILLER_30_680 VPWR VGND sg13g2_fill_1
X_4656_ net686 net730 _0015_ VPWR VGND sg13g2_nor2_1
X_3607_ _1267_ _1268_ _1269_ _1270_ _1271_ VPWR VGND sg13g2_nor4_1
X_4587_ _2132_ blue\[6\] _2208_ VPWR VGND sg13g2_xor2_1
X_3538_ _1194_ _1198_ _1032_ _1202_ VPWR VGND sg13g2_nand3_1
XFILLER_1_518 VPWR VGND sg13g2_decap_8
X_3469_ _1127_ _1131_ _1111_ _1133_ VPWR VGND sg13g2_nand3_1
X_5208_ net296 VGND VPWR _0558_ videogen.test_lut_thingy.pixel_feeder_inst.row\[46\]\[2\]
+ _0187_ sg13g2_dfrbpq_1
X_5139_ net193 VGND VPWR _0489_ videogen.test_lut_thingy.pixel_feeder_inst.row\[10\]\[1\]
+ _0126_ sg13g2_dfrbpq_1
XFILLER_29_224 VPWR VGND sg13g2_fill_2
X_5319__138 VPWR VGND net138 sg13g2_tiehi
XFILLER_13_603 VPWR VGND sg13g2_decap_8
XFILLER_16_76 VPWR VGND sg13g2_decap_4
XFILLER_8_117 VPWR VGND sg13g2_fill_2
XFILLER_12_157 VPWR VGND sg13g2_decap_8
XFILLER_13_669 VPWR VGND sg13g2_decap_8
XFILLER_21_680 VPWR VGND sg13g2_decap_8
XFILLER_21_691 VPWR VGND sg13g2_fill_1
XFILLER_5_824 VPWR VGND sg13g2_decap_8
XFILLER_10_1000 VPWR VGND sg13g2_decap_8
X_5150__150 VPWR VGND net150 sg13g2_tiehi
XFILLER_4_378 VPWR VGND sg13g2_decap_4
XFILLER_0_562 VPWR VGND sg13g2_decap_8
XFILLER_48_533 VPWR VGND sg13g2_decap_8
XFILLER_36_728 VPWR VGND sg13g2_decap_4
XFILLER_17_920 VPWR VGND sg13g2_fill_2
XFILLER_32_901 VPWR VGND sg13g2_decap_8
X_2840_ videogen.test_lut_thingy.pixel_feeder_inst.row\[4\]\[0\] net816 _0770_ _0544_
+ VPWR VGND sg13g2_mux2_1
XFILLER_31_455 VPWR VGND sg13g2_decap_4
X_5272__274 VPWR VGND net274 sg13g2_tiehi
XFILLER_12_680 VPWR VGND sg13g2_fill_1
X_5018__411 VPWR VGND net411 sg13g2_tiehi
X_2771_ videogen.test_lut_thingy.pixel_feeder_inst.row\[38\]\[3\] net784 _0752_ _0595_
+ VPWR VGND sg13g2_mux2_1
X_4510_ _2132_ _2137_ blue\[6\] _2138_ VPWR VGND sg13g2_nand3_1
XFILLER_8_651 VPWR VGND sg13g2_fill_2
XFILLER_7_183 VPWR VGND sg13g2_decap_8
XFILLER_7_161 VPWR VGND sg13g2_fill_1
X_4441_ _2077_ _2076_ _2075_ VPWR VGND sg13g2_nand2b_1
X_4372_ VGND VPWR net564 _1992_ _2022_ _1991_ sg13g2_a21oi_1
XFILLER_4_890 VPWR VGND sg13g2_decap_8
X_3323_ videogen.fancy_shader.video_x\[6\] videogen.fancy_shader.video_x\[5\] net649
+ _0988_ VPWR VGND _0876_ sg13g2_nand4_1
Xfanout619 net620 net619 VPWR VGND sg13g2_buf_8
Xfanout608 net609 net608 VPWR VGND sg13g2_buf_8
X_3254_ _0939_ _0941_ _0942_ _0329_ VPWR VGND sg13g2_nor3_1
X_5249__43 VPWR VGND net43 sg13g2_tiehi
X_3185_ _0895_ videogen.test_lut_thingy.pixel_feeder_inst.v_pix\[1\] videogen.test_lut_thingy.pixel_feeder_inst.v_pix\[0\]
+ _0892_ VPWR VGND sg13g2_and3_1
XFILLER_42_709 VPWR VGND sg13g2_decap_8
XFILLER_22_411 VPWR VGND sg13g2_decap_8
XFILLER_34_271 VPWR VGND sg13g2_decap_4
X_5318__182 VPWR VGND net182 sg13g2_tiehi
X_2969_ net811 videogen.test_lut_thingy.pixel_feeder_inst.row\[62\]\[0\] _0798_ _0436_
+ VPWR VGND sg13g2_mux2_1
X_4708_ net705 net749 _0065_ VPWR VGND sg13g2_nor2_1
X_4639_ VPWR _0659_ _2234_ VGND sg13g2_inv_1
X_5284__178 VPWR VGND net178 sg13g2_tiehi
XFILLER_40_1015 VPWR VGND sg13g2_decap_8
XFILLER_17_216 VPWR VGND sg13g2_decap_4
XFILLER_27_97 VPWR VGND sg13g2_decap_4
XFILLER_9_426 VPWR VGND sg13g2_fill_2
XFILLER_40_274 VPWR VGND sg13g2_decap_8
XFILLER_5_698 VPWR VGND sg13g2_decap_8
XFILLER_49_831 VPWR VGND sg13g2_decap_8
XFILLER_1_882 VPWR VGND sg13g2_decap_8
XFILLER_48_385 VPWR VGND sg13g2_decap_4
X_4990_ net444 VGND VPWR _0344_ videogen.fancy_shader.video_y\[5\] net655 sg13g2_dfrbpq_2
XFILLER_44_580 VPWR VGND sg13g2_decap_8
XFILLER_16_293 VPWR VGND sg13g2_decap_8
XFILLER_32_720 VPWR VGND sg13g2_decap_8
X_3941_ net642 VPWR _1604_ VGND videogen.test_lut_thingy.pixel_feeder_inst.row\[47\]\[0\]
+ net585 sg13g2_o21ai_1
XFILLER_17_1028 VPWR VGND sg13g2_fill_1
X_3872_ videogen.test_lut_thingy.pixel_feeder_inst.row\[2\]\[0\] net605 _1535_ VPWR
+ VGND sg13g2_nor2_1
XFILLER_32_753 VPWR VGND sg13g2_fill_1
X_5237__180 VPWR VGND net180 sg13g2_tiehi
XFILLER_31_285 VPWR VGND sg13g2_decap_4
XFILLER_32_786 VPWR VGND sg13g2_decap_8
X_2823_ videogen.test_lut_thingy.pixel_feeder_inst.row\[46\]\[2\] net794 _0767_ _0558_
+ VPWR VGND sg13g2_mux2_1
X_4953__104 VPWR VGND net104 sg13g2_tiehi
X_2754_ _0744_ net619 _0713_ _0742_ VPWR VGND sg13g2_and3_2
XFILLER_9_993 VPWR VGND sg13g2_decap_8
X_2685_ _0696_ _0701_ _0703_ VPWR VGND sg13g2_nor2_2
X_4424_ _2064_ _1940_ _2047_ VPWR VGND sg13g2_xnor2_1
X_4355_ VGND VPWR _1983_ _2005_ _2006_ _1984_ sg13g2_a21oi_1
X_3306_ net769 _0978_ _0345_ VPWR VGND sg13g2_nor2_1
X_4286_ _1934_ _1938_ _1931_ _0366_ VPWR VGND sg13g2_nand3_1
X_3237_ _0927_ _0929_ _0930_ _0316_ VPWR VGND sg13g2_nor3_1
X_3168_ _0882_ videogen.fancy_shader.video_x\[8\] _0880_ VPWR VGND sg13g2_nand2_1
XFILLER_42_517 VPWR VGND sg13g2_decap_4
X_3099_ _0702_ _0715_ _0851_ VPWR VGND sg13g2_nor2_1
XFILLER_23_742 VPWR VGND sg13g2_decap_4
XFILLER_11_904 VPWR VGND sg13g2_decap_4
XFILLER_22_241 VPWR VGND sg13g2_decap_8
XFILLER_11_959 VPWR VGND sg13g2_decap_8
XFILLER_22_274 VPWR VGND sg13g2_decap_8
XFILLER_22_285 VPWR VGND sg13g2_fill_1
X_5216__264 VPWR VGND net264 sg13g2_tiehi
XFILLER_2_602 VPWR VGND sg13g2_decap_8
XFILLER_2_657 VPWR VGND sg13g2_decap_8
X_5186__396 VPWR VGND net396 sg13g2_tiehi
XFILLER_38_52 VPWR VGND sg13g2_fill_2
X_5008__421 VPWR VGND net421 sg13g2_tiehi
XFILLER_46_834 VPWR VGND sg13g2_decap_8
XFILLER_9_212 VPWR VGND sg13g2_fill_1
XFILLER_9_245 VPWR VGND sg13g2_decap_8
X_5015__414 VPWR VGND net414 sg13g2_tiehi
XFILLER_5_440 VPWR VGND sg13g2_decap_4
X_5310__230 VPWR VGND net230 sg13g2_tiehi
XFILLER_6_974 VPWR VGND sg13g2_decap_8
X_4140_ _1797_ _1768_ _1781_ VPWR VGND sg13g2_xnor2_1
X_4071_ _1731_ _1726_ _1730_ VPWR VGND sg13g2_xnor2_1
XFILLER_37_834 VPWR VGND sg13g2_fill_1
X_3022_ videogen.test_lut_thingy.pixel_feeder_inst.row\[12\]\[2\] net792 _0810_ _0382_
+ VPWR VGND sg13g2_mux2_1
X_5022__407 VPWR VGND net407 sg13g2_tiehi
X_4973_ net64 VGND VPWR _0327_ videogen.fancy_shader.shader_counter_reg\[0\] net656
+ sg13g2_dfrbpq_2
XFILLER_36_388 VPWR VGND sg13g2_fill_1
X_3924_ net639 VPWR _1587_ VGND videogen.test_lut_thingy.pixel_feeder_inst.row\[60\]\[0\]
+ net592 sg13g2_o21ai_1
XFILLER_20_712 VPWR VGND sg13g2_decap_4
X_3855_ videogen.test_lut_thingy.pixel_feeder_inst.row\[33\]\[1\] net576 _1519_ VPWR
+ VGND sg13g2_nor2_1
X_2806_ videogen.test_lut_thingy.pixel_feeder_inst.row\[43\]\[3\] net780 _0763_ _0571_
+ VPWR VGND sg13g2_mux2_1
XFILLER_20_778 VPWR VGND sg13g2_fill_1
XFILLER_20_789 VPWR VGND sg13g2_fill_1
X_3786_ _1446_ _1447_ _1448_ _1449_ _1450_ VPWR VGND sg13g2_nor4_1
XFILLER_30_1025 VPWR VGND sg13g2_decap_4
X_2737_ net798 videogen.test_lut_thingy.pixel_feeder_inst.row\[25\]\[1\] _0736_ _0623_
+ VPWR VGND sg13g2_mux2_1
X_2668_ VPWR _0687_ videogen.fancy_shader.shader_counter_reg\[9\] VGND sg13g2_inv_1
X_4407_ _0685_ net566 _0384_ VPWR VGND sg13g2_nor2_1
XFILLER_8_1015 VPWR VGND sg13g2_decap_8
X_4338_ _1989_ _1975_ _1964_ VPWR VGND sg13g2_nand2b_1
X_4269_ _1924_ _1925_ _1926_ VPWR VGND sg13g2_and2_1
XFILLER_46_108 VPWR VGND sg13g2_decap_8
XFILLER_39_160 VPWR VGND sg13g2_fill_1
XFILLER_27_366 VPWR VGND sg13g2_decap_8
XFILLER_43_859 VPWR VGND sg13g2_decap_4
XFILLER_42_347 VPWR VGND sg13g2_fill_1
XFILLER_24_21 VPWR VGND sg13g2_decap_4
XFILLER_11_701 VPWR VGND sg13g2_fill_1
XFILLER_24_65 VPWR VGND sg13g2_decap_8
XFILLER_10_233 VPWR VGND sg13g2_fill_1
XFILLER_7_716 VPWR VGND sg13g2_decap_8
XFILLER_24_87 VPWR VGND sg13g2_decap_8
XFILLER_40_20 VPWR VGND sg13g2_decap_8
XFILLER_6_226 VPWR VGND sg13g2_decap_8
XFILLER_40_97 VPWR VGND sg13g2_fill_1
XFILLER_40_75 VPWR VGND sg13g2_decap_8
XFILLER_3_944 VPWR VGND sg13g2_decap_8
XFILLER_1_14 VPWR VGND sg13g2_decap_8
Xfanout780 net781 net780 VPWR VGND sg13g2_buf_2
Xfanout791 net797 net791 VPWR VGND sg13g2_buf_8
XFILLER_46_631 VPWR VGND sg13g2_decap_8
XFILLER_18_311 VPWR VGND sg13g2_decap_4
XFILLER_19_856 VPWR VGND sg13g2_fill_1
XFILLER_45_174 VPWR VGND sg13g2_fill_1
XFILLER_18_399 VPWR VGND sg13g2_decap_8
X_3640_ net638 VPWR _1304_ VGND videogen.test_lut_thingy.pixel_feeder_inst.row\[25\]\[3\]
+ net567 sg13g2_o21ai_1
X_3571_ videogen.test_lut_thingy.pixel_feeder_inst.row\[52\]\[3\] net592 _1235_ VPWR
+ VGND sg13g2_nor2_1
XFILLER_6_771 VPWR VGND sg13g2_decap_8
X_5310_ net230 VGND VPWR _0660_ serialize.shift_reg_r\[6\] clknet_3_5_0_clk_regs sg13g2_dfrbpq_1
X_5241_ net134 VGND VPWR _0591_ videogen.test_lut_thingy.pixel_feeder_inst.row\[3\]\[3\]
+ _0220_ sg13g2_dfrbpq_1
X_5172_ net65 VGND VPWR _0522_ videogen.test_lut_thingy.pixel_feeder_inst.row\[2\]\[2\]
+ _0151_ sg13g2_dfrbpq_1
X_4123_ VPWR VGND _1754_ _1778_ _1777_ _1771_ _1780_ _1772_ sg13g2_a221oi_1
XFILLER_29_609 VPWR VGND sg13g2_decap_8
X_4054_ _1630_ VPWR _1714_ VGND _0999_ _1170_ sg13g2_o21ai_1
Xinput2 ui_in[1] net2 VPWR VGND sg13g2_buf_2
XFILLER_37_642 VPWR VGND sg13g2_decap_8
X_3005_ _0807_ net559 _0782_ VPWR VGND sg13g2_nand2_2
XFILLER_25_804 VPWR VGND sg13g2_decap_8
XFILLER_24_303 VPWR VGND sg13g2_fill_2
XFILLER_24_336 VPWR VGND sg13g2_decap_4
XFILLER_25_837 VPWR VGND sg13g2_fill_1
XFILLER_36_174 VPWR VGND sg13g2_fill_1
X_4956_ net98 VGND VPWR _0310_ videogen.test_lut_thingy.pixel_feeder_inst.h_pix\[5\]
+ net650 sg13g2_dfrbpq_2
X_4887_ net681 net725 _0242_ VPWR VGND sg13g2_nor2_1
X_3907_ videogen.test_lut_thingy.pixel_feeder_inst.row\[29\]\[0\] net572 _1570_ VPWR
+ VGND sg13g2_nor2_1
X_3838_ videogen.test_lut_thingy.pixel_feeder_inst.row\[43\]\[1\] net586 _1502_ VPWR
+ VGND sg13g2_nor2_1
XFILLER_20_575 VPWR VGND sg13g2_decap_4
XFILLER_4_708 VPWR VGND sg13g2_decap_8
XFILLER_3_218 VPWR VGND sg13g2_decap_8
X_3769_ videogen.test_lut_thingy.pixel_feeder_inst.row\[10\]\[1\] net600 _1433_ VPWR
+ VGND sg13g2_nor2_1
X_5033__388 VPWR VGND net388 sg13g2_tiehi
XFILLER_0_947 VPWR VGND sg13g2_decap_8
XFILLER_48_918 VPWR VGND sg13g2_decap_8
XFILLER_47_406 VPWR VGND sg13g2_decap_4
XFILLER_19_32 VPWR VGND sg13g2_fill_1
XFILLER_19_43 VPWR VGND sg13g2_fill_2
XFILLER_16_815 VPWR VGND sg13g2_decap_8
XFILLER_27_130 VPWR VGND sg13g2_decap_8
X_5005__424 VPWR VGND net424 sg13g2_tiehi
XFILLER_28_686 VPWR VGND sg13g2_decap_4
XFILLER_35_20 VPWR VGND sg13g2_decap_4
XFILLER_43_656 VPWR VGND sg13g2_decap_8
XFILLER_37_1009 VPWR VGND sg13g2_decap_8
XFILLER_31_829 VPWR VGND sg13g2_fill_1
XFILLER_42_199 VPWR VGND sg13g2_decap_8
XFILLER_11_564 VPWR VGND sg13g2_fill_1
XFILLER_7_535 VPWR VGND sg13g2_fill_2
X_5012__417 VPWR VGND net417 sg13g2_tiehi
XFILLER_3_741 VPWR VGND sg13g2_decap_8
X_5268__290 VPWR VGND net290 sg13g2_tiehi
XFILLER_2_284 VPWR VGND sg13g2_decap_8
XFILLER_47_984 VPWR VGND sg13g2_decap_8
XFILLER_34_601 VPWR VGND sg13g2_decap_8
XFILLER_46_494 VPWR VGND sg13g2_decap_8
XFILLER_34_634 VPWR VGND sg13g2_decap_8
X_4810_ net684 net728 _0167_ VPWR VGND sg13g2_nor2_1
XFILLER_22_807 VPWR VGND sg13g2_decap_8
X_5275__250 VPWR VGND net250 sg13g2_tiehi
XFILLER_15_881 VPWR VGND sg13g2_fill_2
X_4741_ net683 net727 _0098_ VPWR VGND sg13g2_nor2_1
X_4672_ net708 net752 _0030_ VPWR VGND sg13g2_nor2_1
X_3623_ videogen.test_lut_thingy.pixel_feeder_inst.row\[0\]\[3\] net589 _1287_ VPWR
+ VGND sg13g2_nor2_1
X_3554_ _1011_ _1217_ _1218_ VPWR VGND sg13g2_nor2_1
X_3485_ _1149_ _1144_ _1147_ _1148_ VPWR VGND sg13g2_and3_2
X_5224_ net232 VGND VPWR _0574_ videogen.test_lut_thingy.pixel_feeder_inst.row\[19\]\[2\]
+ _0203_ sg13g2_dfrbpq_1
X_5155_ net117 VGND VPWR _0505_ videogen.test_lut_thingy.pixel_feeder_inst.row\[52\]\[1\]
+ _0142_ sg13g2_dfrbpq_1
X_4106_ _1755_ _1757_ _1749_ _1763_ VPWR VGND _1758_ sg13g2_nand4_1
X_5086_ net299 VGND VPWR _0436_ videogen.test_lut_thingy.pixel_feeder_inst.row\[62\]\[0\]
+ _0073_ sg13g2_dfrbpq_1
XFILLER_25_601 VPWR VGND sg13g2_decap_4
X_4037_ VGND VPWR _1692_ _1696_ _1697_ _1693_ sg13g2_a21oi_1
XFILLER_25_645 VPWR VGND sg13g2_decap_4
XFILLER_40_637 VPWR VGND sg13g2_decap_8
X_4939_ net126 VGND VPWR _0293_ videogen.fancy_shader.video_x\[5\] net657 sg13g2_dfrbpq_2
XFILLER_21_11 VPWR VGND sg13g2_decap_4
XFILLER_0_744 VPWR VGND sg13g2_decap_8
XFILLER_48_715 VPWR VGND sg13g2_decap_8
XFILLER_43_420 VPWR VGND sg13g2_fill_1
XFILLER_12_851 VPWR VGND sg13g2_decap_8
XFILLER_30_158 VPWR VGND sg13g2_fill_2
XFILLER_11_383 VPWR VGND sg13g2_fill_2
XFILLER_7_354 VPWR VGND sg13g2_decap_8
X_3270_ VPWR _0954_ _0953_ VGND sg13g2_inv_1
XFILLER_39_704 VPWR VGND sg13g2_decap_8
XFILLER_23_4 VPWR VGND sg13g2_fill_2
XFILLER_47_781 VPWR VGND sg13g2_decap_8
X_5291__47 VPWR VGND net47 sg13g2_tiehi
XFILLER_21_125 VPWR VGND sg13g2_decap_8
X_2985_ _0803_ _0735_ _0782_ VPWR VGND sg13g2_nand2_2
X_4724_ net684 net728 _0081_ VPWR VGND sg13g2_nor2_1
X_4655_ net686 net730 _0014_ VPWR VGND sg13g2_nor2_1
X_4586_ _2202_ _2207_ _0617_ VPWR VGND sg13g2_nor2_1
X_3606_ videogen.test_lut_thingy.pixel_feeder_inst.row\[33\]\[3\] net576 _1270_ VPWR
+ VGND sg13g2_nor2_1
X_3537_ _1194_ _1200_ net561 _1201_ VPWR VGND sg13g2_nand3_1
X_3468_ _1132_ _1127_ _1131_ VPWR VGND sg13g2_nand2_1
X_5207_ net300 VGND VPWR _0557_ videogen.test_lut_thingy.pixel_feeder_inst.row\[46\]\[1\]
+ _0186_ sg13g2_dfrbpq_1
X_3399_ VGND VPWR _1063_ videogen.fancy_shader.shader_counter_reg\[7\] videogen.fancy_shader.video_x\[7\]
+ sg13g2_or2_1
X_5138_ net195 VGND VPWR _0488_ videogen.test_lut_thingy.pixel_feeder_inst.row\[10\]\[0\]
+ _0125_ sg13g2_dfrbpq_1
X_5069_ net333 VGND VPWR _0419_ videogen.test_lut_thingy.pixel_feeder_inst.row\[32\]\[3\]
+ _0056_ sg13g2_dfrbpq_1
XFILLER_38_781 VPWR VGND sg13g2_decap_4
XFILLER_26_921 VPWR VGND sg13g2_decap_8
X_5002__427 VPWR VGND net427 sg13g2_tiehi
XFILLER_25_486 VPWR VGND sg13g2_decap_8
XFILLER_16_99 VPWR VGND sg13g2_decap_8
XFILLER_41_979 VPWR VGND sg13g2_decap_4
XFILLER_32_21 VPWR VGND sg13g2_decap_4
XFILLER_5_803 VPWR VGND sg13g2_decap_8
XFILLER_20_191 VPWR VGND sg13g2_fill_2
XFILLER_4_302 VPWR VGND sg13g2_fill_1
XFILLER_0_541 VPWR VGND sg13g2_decap_8
XFILLER_48_512 VPWR VGND sg13g2_decap_8
XFILLER_48_589 VPWR VGND sg13g2_decap_8
XFILLER_29_792 VPWR VGND sg13g2_fill_2
XFILLER_35_228 VPWR VGND sg13g2_fill_2
XFILLER_28_280 VPWR VGND sg13g2_fill_1
XFILLER_43_250 VPWR VGND sg13g2_decap_4
XFILLER_43_294 VPWR VGND sg13g2_decap_8
XFILLER_16_486 VPWR VGND sg13g2_fill_1
XFILLER_31_434 VPWR VGND sg13g2_decap_8
XFILLER_32_946 VPWR VGND sg13g2_fill_1
XFILLER_31_445 VPWR VGND sg13g2_fill_2
XFILLER_8_630 VPWR VGND sg13g2_decap_8
X_2770_ _0724_ _0740_ _0752_ VPWR VGND sg13g2_nor2_2
XFILLER_8_641 VPWR VGND sg13g2_fill_2
XFILLER_7_151 VPWR VGND sg13g2_fill_1
X_4440_ _2074_ VPWR _2076_ VGND _2056_ _2065_ sg13g2_o21ai_1
X_4371_ _2020_ _2012_ _2021_ VPWR VGND sg13g2_xor2_1
X_3322_ VGND VPWR videogen.test_lut_thingy.gol_counter_reg\[3\] _0986_ _0352_ _0987_
+ sg13g2_a21oi_1
Xfanout609 _0707_ net609 VPWR VGND sg13g2_buf_8
X_3253_ videogen.fancy_shader.shader_counter_reg\[2\] _0938_ _0942_ VPWR VGND sg13g2_and2_1
X_3184_ VGND VPWR videogen.test_lut_thingy.pixel_feeder_inst.v_pix\[0\] _0892_ _0894_
+ videogen.test_lut_thingy.pixel_feeder_inst.v_pix\[1\] sg13g2_a21oi_1
XFILLER_26_217 VPWR VGND sg13g2_decap_8
XFILLER_26_228 VPWR VGND sg13g2_fill_1
XFILLER_41_209 VPWR VGND sg13g2_decap_8
XFILLER_23_913 VPWR VGND sg13g2_fill_2
XFILLER_23_946 VPWR VGND sg13g2_fill_1
XFILLER_22_456 VPWR VGND sg13g2_fill_1
XFILLER_22_478 VPWR VGND sg13g2_decap_4
X_2968_ net802 videogen.test_lut_thingy.pixel_feeder_inst.row\[62\]\[1\] _0798_ _0437_
+ VPWR VGND sg13g2_mux2_1
X_4707_ net705 net749 _0064_ VPWR VGND sg13g2_nor2_1
X_2899_ net776 videogen.test_lut_thingy.pixel_feeder_inst.row\[10\]\[3\] _0784_ _0491_
+ VPWR VGND sg13g2_mux2_1
X_4638_ _2234_ net671 net458 net677 red_tmds_par\[5\] VPWR VGND sg13g2_a22oi_1
X_4569_ _2194_ _2177_ _2195_ VPWR VGND sg13g2_nor2b_1
XFILLER_2_839 VPWR VGND sg13g2_decap_8
X_5106__259 VPWR VGND net259 sg13g2_tiehi
XFILLER_27_43 VPWR VGND sg13g2_decap_4
XFILLER_14_913 VPWR VGND sg13g2_decap_8
XFILLER_14_924 VPWR VGND sg13g2_fill_1
XFILLER_26_773 VPWR VGND sg13g2_decap_8
XFILLER_43_31 VPWR VGND sg13g2_decap_8
XFILLER_25_272 VPWR VGND sg13g2_decap_4
XFILLER_9_405 VPWR VGND sg13g2_decap_8
XFILLER_41_798 VPWR VGND sg13g2_fill_2
XFILLER_13_489 VPWR VGND sg13g2_decap_8
XFILLER_4_143 VPWR VGND sg13g2_fill_1
XFILLER_49_810 VPWR VGND sg13g2_decap_8
XFILLER_1_861 VPWR VGND sg13g2_decap_8
XFILLER_0_393 VPWR VGND sg13g2_decap_8
XFILLER_49_887 VPWR VGND sg13g2_decap_8
XFILLER_36_526 VPWR VGND sg13g2_fill_2
X_3940_ _1599_ _1600_ _1601_ _1602_ _1603_ VPWR VGND sg13g2_nor4_1
XFILLER_32_710 VPWR VGND sg13g2_fill_2
X_3871_ net612 VPWR _1534_ VGND videogen.test_lut_thingy.pixel_feeder_inst.row\[1\]\[0\]
+ net568 sg13g2_o21ai_1
XFILLER_31_220 VPWR VGND sg13g2_fill_1
X_2822_ videogen.test_lut_thingy.pixel_feeder_inst.row\[46\]\[3\] net785 _0767_ _0559_
+ VPWR VGND sg13g2_mux2_1
XFILLER_9_972 VPWR VGND sg13g2_decap_8
X_2753_ VPWR _0743_ _0742_ VGND sg13g2_inv_1
X_2684_ _0701_ _0702_ VPWR VGND sg13g2_inv_4
X_4423_ VGND VPWR net628 _2063_ _0404_ net773 sg13g2_a21oi_1
X_4354_ net555 net564 _2000_ _2005_ VPWR VGND sg13g2_nor3_1
X_3305_ _0978_ videogen.fancy_shader.video_y\[6\] _0977_ VPWR VGND sg13g2_xnor2_1
X_4285_ _1624_ _1628_ _1329_ _1938_ VPWR VGND _1734_ sg13g2_nand4_1
X_3236_ videogen.test_lut_thingy.pixel_feeder_inst.h_counter\[1\] _0822_ _0930_ VPWR
+ VGND sg13g2_nor2_1
X_3167_ _0873_ _0880_ _0881_ _0295_ VPWR VGND sg13g2_nor3_1
X_5029__393 VPWR VGND net393 sg13g2_tiehi
X_3098_ VGND VPWR _0696_ _0850_ _0849_ _0848_ sg13g2_a21oi_2
XFILLER_14_209 VPWR VGND sg13g2_decap_4
XFILLER_10_404 VPWR VGND sg13g2_fill_1
XFILLER_11_949 VPWR VGND sg13g2_fill_1
XFILLER_10_448 VPWR VGND sg13g2_decap_8
XFILLER_13_67 VPWR VGND sg13g2_decap_8
XFILLER_13_78 VPWR VGND sg13g2_fill_1
XFILLER_2_636 VPWR VGND sg13g2_decap_8
XFILLER_1_124 VPWR VGND sg13g2_decap_8
XFILLER_49_128 VPWR VGND sg13g2_fill_2
XFILLER_49_117 VPWR VGND sg13g2_decap_8
XFILLER_46_813 VPWR VGND sg13g2_decap_8
X_5223__236 VPWR VGND net236 sg13g2_tiehi
XFILLER_45_323 VPWR VGND sg13g2_fill_2
X_5043__368 VPWR VGND net368 sg13g2_tiehi
XFILLER_18_548 VPWR VGND sg13g2_fill_1
XFILLER_33_507 VPWR VGND sg13g2_decap_4
XFILLER_14_710 VPWR VGND sg13g2_fill_1
XFILLER_41_573 VPWR VGND sg13g2_fill_1
XFILLER_6_953 VPWR VGND sg13g2_decap_8
XFILLER_10_993 VPWR VGND sg13g2_decap_8
X_4070_ _1171_ _1728_ _1729_ _1730_ VPWR VGND sg13g2_nor3_1
XFILLER_49_684 VPWR VGND sg13g2_decap_8
X_3021_ videogen.test_lut_thingy.pixel_feeder_inst.row\[12\]\[3\] net782 _0810_ _0383_
+ VPWR VGND sg13g2_mux2_1
XFILLER_17_592 VPWR VGND sg13g2_decap_8
X_4972_ net66 VGND VPWR _0326_ videogen.test_lut_thingy.pixel_feeder_inst.row\[37\]\[3\]
+ _0024_ sg13g2_dfrbpq_1
X_3923_ net644 _1580_ _1585_ _1586_ VPWR VGND sg13g2_or3_1
X_3854_ videogen.test_lut_thingy.pixel_feeder_inst.row\[32\]\[1\] net598 _1518_ VPWR
+ VGND sg13g2_nor2_1
XFILLER_32_584 VPWR VGND sg13g2_fill_2
X_2805_ _0747_ _0757_ _0763_ VPWR VGND sg13g2_nor2_2
XFILLER_20_746 VPWR VGND sg13g2_fill_1
X_3785_ videogen.test_lut_thingy.pixel_feeder_inst.row\[4\]\[1\] net597 _1449_ VPWR
+ VGND sg13g2_nor2_1
XFILLER_8_290 VPWR VGND sg13g2_decap_8
X_2736_ net787 videogen.test_lut_thingy.pixel_feeder_inst.row\[25\]\[2\] _0736_ _0624_
+ VPWR VGND sg13g2_mux2_1
X_2667_ net2 _0686_ VPWR VGND sg13g2_inv_4
X_4406_ VGND VPWR _1950_ _1986_ _0375_ _2050_ sg13g2_a21oi_1
X_4337_ _1988_ _0690_ _1976_ VPWR VGND sg13g2_xnor2_1
X_4268_ VPWR VGND _1923_ _1732_ _1912_ _1893_ _1925_ _1910_ sg13g2_a221oi_1
X_3219_ _0918_ _0675_ _0891_ VPWR VGND sg13g2_xnor2_1
X_4929__140 VPWR VGND net140 sg13g2_tiehi
XFILLER_39_183 VPWR VGND sg13g2_fill_2
X_4199_ _1844_ _1850_ _1851_ _1855_ _1856_ VPWR VGND sg13g2_nor4_1
XFILLER_27_334 VPWR VGND sg13g2_decap_4
XFILLER_28_835 VPWR VGND sg13g2_decap_8
XFILLER_43_827 VPWR VGND sg13g2_decap_4
XFILLER_42_359 VPWR VGND sg13g2_decap_4
XFILLER_24_11 VPWR VGND sg13g2_decap_4
XFILLER_24_33 VPWR VGND sg13g2_fill_1
XFILLER_10_201 VPWR VGND sg13g2_fill_1
XFILLER_24_44 VPWR VGND sg13g2_fill_1
XFILLER_24_55 VPWR VGND sg13g2_fill_2
XFILLER_3_923 VPWR VGND sg13g2_decap_8
XFILLER_49_63 VPWR VGND sg13g2_decap_8
XFILLER_49_74 VPWR VGND sg13g2_fill_2
XFILLER_46_610 VPWR VGND sg13g2_decap_8
Xfanout792 net793 net792 VPWR VGND sg13g2_buf_8
Xfanout770 net771 net770 VPWR VGND sg13g2_buf_1
Xfanout781 ui_in[7] net781 VPWR VGND sg13g2_buf_8
XFILLER_34_816 VPWR VGND sg13g2_decap_8
XFILLER_46_687 VPWR VGND sg13g2_decap_8
XFILLER_33_337 VPWR VGND sg13g2_decap_4
X_3570_ net644 VPWR _1234_ VGND videogen.test_lut_thingy.pixel_feeder_inst.row\[54\]\[3\]
+ net603 sg13g2_o21ai_1
XFILLER_5_282 VPWR VGND sg13g2_decap_8
X_5240_ net144 VGND VPWR _0590_ videogen.test_lut_thingy.pixel_feeder_inst.row\[3\]\[2\]
+ _0219_ sg13g2_dfrbpq_1
X_5171_ net69 VGND VPWR _0521_ videogen.test_lut_thingy.pixel_feeder_inst.row\[2\]\[1\]
+ _0150_ sg13g2_dfrbpq_1
X_4122_ _1777_ _1754_ _1778_ _1779_ VPWR VGND sg13g2_a21o_1
X_4053_ _1632_ _1698_ _1631_ _1713_ VPWR VGND _1711_ sg13g2_nand4_1
XFILLER_49_481 VPWR VGND sg13g2_decap_8
XFILLER_37_621 VPWR VGND sg13g2_decap_8
X_3004_ videogen.test_lut_thingy.pixel_feeder_inst.row\[14\]\[0\] net813 _0806_ _0399_
+ VPWR VGND sg13g2_mux2_1
XFILLER_36_186 VPWR VGND sg13g2_decap_8
XFILLER_40_819 VPWR VGND sg13g2_fill_1
X_4955_ net100 VGND VPWR _0309_ videogen.test_lut_thingy.pixel_feeder_inst.h_pix\[4\]
+ net650 sg13g2_dfrbpq_2
XFILLER_24_348 VPWR VGND sg13g2_fill_1
X_3906_ videogen.test_lut_thingy.pixel_feeder_inst.row\[30\]\[0\] net604 _1569_ VPWR
+ VGND sg13g2_nor2_1
X_4886_ net681 net725 _0241_ VPWR VGND sg13g2_nor2_1
X_3837_ videogen.test_lut_thingy.pixel_feeder_inst.row\[42\]\[1\] net607 _1501_ VPWR
+ VGND sg13g2_nor2_1
X_3768_ videogen.test_lut_thingy.pixel_feeder_inst.row\[9\]\[1\] net567 _1432_ VPWR
+ VGND sg13g2_nor2_1
X_2719_ videogen.test_lut_thingy.pixel_feeder_inst.row\[23\]\[2\] net793 _0727_ _0632_
+ VPWR VGND sg13g2_mux2_1
X_3699_ videogen.test_lut_thingy.pixel_feeder_inst.row\[48\]\[2\] net591 _1363_ VPWR
+ VGND sg13g2_nor2_1
XFILLER_10_46 VPWR VGND sg13g2_decap_4
XFILLER_0_926 VPWR VGND sg13g2_decap_8
XFILLER_43_635 VPWR VGND sg13g2_decap_8
XFILLER_35_76 VPWR VGND sg13g2_fill_1
XFILLER_35_87 VPWR VGND sg13g2_fill_2
Xclkbuf_3_3_0_clk_regs clknet_0_clk_regs clknet_3_3_0_clk_regs VPWR VGND sg13g2_buf_8
X_4990__444 VPWR VGND net444 sg13g2_tiehi
XFILLER_7_569 VPWR VGND sg13g2_decap_8
XFILLER_3_720 VPWR VGND sg13g2_decap_8
XFILLER_2_241 VPWR VGND sg13g2_fill_2
XFILLER_3_797 VPWR VGND sg13g2_decap_8
XFILLER_2_263 VPWR VGND sg13g2_fill_1
XFILLER_32_9 VPWR VGND sg13g2_fill_1
XFILLER_19_621 VPWR VGND sg13g2_decap_8
XFILLER_20_1003 VPWR VGND sg13g2_fill_2
XFILLER_47_963 VPWR VGND sg13g2_decap_8
XFILLER_18_142 VPWR VGND sg13g2_fill_2
XFILLER_46_473 VPWR VGND sg13g2_decap_8
XFILLER_33_101 VPWR VGND sg13g2_decap_4
XFILLER_34_613 VPWR VGND sg13g2_decap_8
XFILLER_34_668 VPWR VGND sg13g2_decap_8
X_4740_ net692 net736 _0097_ VPWR VGND sg13g2_nor2_1
X_4671_ net707 net751 _0029_ VPWR VGND sg13g2_nor2_1
X_3622_ net615 VPWR _1286_ VGND videogen.test_lut_thingy.pixel_feeder_inst.row\[3\]\[3\]
+ net578 sg13g2_o21ai_1
X_3553_ VGND VPWR _1211_ _1213_ _1217_ _1216_ sg13g2_a21oi_1
XFILLER_44_0 VPWR VGND sg13g2_decap_4
X_3484_ _1127_ _1111_ _1148_ VPWR VGND _1145_ sg13g2_nand3b_1
X_5223_ net236 VGND VPWR _0573_ videogen.test_lut_thingy.pixel_feeder_inst.row\[19\]\[1\]
+ _0202_ sg13g2_dfrbpq_1
X_5154_ net132 VGND VPWR _0504_ videogen.test_lut_thingy.pixel_feeder_inst.row\[52\]\[0\]
+ _0141_ sg13g2_dfrbpq_1
X_4105_ _1749_ _1755_ _1757_ _1758_ _1762_ VPWR VGND sg13g2_and4_1
X_5085_ net301 VGND VPWR _0435_ videogen.test_lut_thingy.pixel_feeder_inst.row\[6\]\[3\]
+ _0072_ sg13g2_dfrbpq_1
XFILLER_2_91 VPWR VGND sg13g2_decap_4
X_4036_ _1688_ VPWR _1696_ VGND _1691_ _1695_ sg13g2_o21ai_1
XFILLER_25_613 VPWR VGND sg13g2_decap_8
XFILLER_24_134 VPWR VGND sg13g2_decap_8
X_4938_ net127 VGND VPWR _0292_ videogen.fancy_shader.video_x\[4\] net656 sg13g2_dfrbpq_2
X_4869_ net692 net736 _0226_ VPWR VGND sg13g2_nor2_1
XFILLER_21_23 VPWR VGND sg13g2_decap_4
XFILLER_0_723 VPWR VGND sg13g2_decap_8
XFILLER_47_204 VPWR VGND sg13g2_decap_4
XFILLER_47_248 VPWR VGND sg13g2_fill_1
XFILLER_29_952 VPWR VGND sg13g2_fill_1
XFILLER_46_53 VPWR VGND sg13g2_fill_1
XFILLER_44_933 VPWR VGND sg13g2_fill_2
XFILLER_28_462 VPWR VGND sg13g2_fill_1
XFILLER_29_996 VPWR VGND sg13g2_fill_1
XFILLER_15_178 VPWR VGND sg13g2_fill_2
XFILLER_30_126 VPWR VGND sg13g2_fill_2
XFILLER_7_311 VPWR VGND sg13g2_fill_2
XFILLER_12_885 VPWR VGND sg13g2_fill_2
X_5116__239 VPWR VGND net239 sg13g2_tiehi
X_5090__291 VPWR VGND net291 sg13g2_tiehi
XFILLER_3_583 VPWR VGND sg13g2_decap_8
XFILLER_38_215 VPWR VGND sg13g2_fill_2
XFILLER_47_760 VPWR VGND sg13g2_decap_8
XFILLER_34_410 VPWR VGND sg13g2_decap_8
XFILLER_35_922 VPWR VGND sg13g2_decap_4
XFILLER_46_270 VPWR VGND sg13g2_fill_1
XFILLER_35_999 VPWR VGND sg13g2_fill_1
X_2984_ net813 videogen.test_lut_thingy.pixel_feeder_inst.row\[31\]\[0\] _0802_ _0424_
+ VPWR VGND sg13g2_mux2_1
XFILLER_22_638 VPWR VGND sg13g2_decap_8
X_4723_ net700 net744 _0080_ VPWR VGND sg13g2_nor2_1
XFILLER_30_671 VPWR VGND sg13g2_decap_8
X_4654_ net688 net732 _0013_ VPWR VGND sg13g2_nor2_1
X_3605_ videogen.test_lut_thingy.pixel_feeder_inst.row\[34\]\[3\] net606 _1269_ VPWR
+ VGND sg13g2_nor2_1
X_4585_ VGND VPWR _2203_ _2205_ _2207_ _2206_ sg13g2_a21oi_1
X_3536_ _1198_ _1032_ _1200_ VPWR VGND sg13g2_xor2_1
X_3467_ VGND VPWR _1131_ _1125_ _1117_ sg13g2_or2_1
X_5206_ net304 VGND VPWR _0556_ videogen.test_lut_thingy.pixel_feeder_inst.row\[46\]\[0\]
+ _0185_ sg13g2_dfrbpq_1
X_3398_ net649 videogen.fancy_shader.shader_counter_reg\[7\] _1062_ VPWR VGND sg13g2_and2_1
X_5137_ net197 VGND VPWR _0487_ videogen.test_lut_thingy.pixel_feeder_inst.row\[0\]\[3\]
+ _0124_ sg13g2_dfrbpq_1
XFILLER_45_719 VPWR VGND sg13g2_decap_8
X_5068_ net335 VGND VPWR _0418_ videogen.test_lut_thingy.pixel_feeder_inst.row\[32\]\[2\]
+ _0055_ sg13g2_dfrbpq_1
X_5295__402 VPWR VGND net402 sg13g2_tiehi
XFILLER_38_771 VPWR VGND sg13g2_fill_2
X_4019_ _1679_ _1663_ _1666_ VPWR VGND sg13g2_nand2_1
XFILLER_37_270 VPWR VGND sg13g2_decap_8
XFILLER_25_410 VPWR VGND sg13g2_fill_2
XFILLER_25_465 VPWR VGND sg13g2_decap_8
XFILLER_40_424 VPWR VGND sg13g2_fill_2
X_5219__252 VPWR VGND net252 sg13g2_tiehi
XFILLER_40_479 VPWR VGND sg13g2_decap_4
XFILLER_8_119 VPWR VGND sg13g2_fill_1
XFILLER_32_33 VPWR VGND sg13g2_decap_8
XFILLER_5_859 VPWR VGND sg13g2_decap_8
XFILLER_0_520 VPWR VGND sg13g2_decap_8
XFILLER_0_597 VPWR VGND sg13g2_decap_8
XFILLER_48_568 VPWR VGND sg13g2_decap_8
XFILLER_17_933 VPWR VGND sg13g2_decap_8
XFILLER_17_944 VPWR VGND sg13g2_fill_1
XFILLER_28_292 VPWR VGND sg13g2_decap_8
X_5196__344 VPWR VGND net344 sg13g2_tiehi
X_4370_ _2013_ VPWR _2020_ VGND tmds_red.dc_balancing_reg\[2\] _1976_ sg13g2_o21ai_1
X_3321_ net819 VPWR _0987_ VGND videogen.test_lut_thingy.gol_counter_reg\[3\] _0986_
+ sg13g2_o21ai_1
X_3252_ videogen.fancy_shader.shader_counter_reg\[2\] _0938_ _0941_ VPWR VGND sg13g2_nor2_1
X_3183_ net563 _0893_ _0299_ VPWR VGND sg13g2_nor2_1
XFILLER_35_741 VPWR VGND sg13g2_decap_8
XFILLER_34_251 VPWR VGND sg13g2_decap_8
XFILLER_22_435 VPWR VGND sg13g2_decap_8
XFILLER_23_958 VPWR VGND sg13g2_decap_8
XFILLER_10_608 VPWR VGND sg13g2_decap_8
X_2967_ net790 videogen.test_lut_thingy.pixel_feeder_inst.row\[62\]\[2\] _0798_ _0438_
+ VPWR VGND sg13g2_mux2_1
X_4706_ net687 net731 _0063_ VPWR VGND sg13g2_nor2_1
X_2898_ _0784_ _0760_ _0782_ VPWR VGND sg13g2_nand2_2
X_4637_ VPWR _0658_ _2233_ VGND sg13g2_inv_1
X_4568_ VPWR VGND _2182_ _2129_ _2193_ _2127_ _2194_ _2189_ sg13g2_a221oi_1
XFILLER_2_818 VPWR VGND sg13g2_decap_8
X_4499_ _2127_ net625 _2128_ VPWR VGND sg13g2_xor2_1
X_5069__333 VPWR VGND net333 sg13g2_tiehi
X_4930__139 VPWR VGND net139 sg13g2_tiehi
X_3519_ _1096_ _1117_ _1180_ _1183_ VPWR VGND sg13g2_nor3_1
XFILLER_25_251 VPWR VGND sg13g2_decap_8
XFILLER_13_435 VPWR VGND sg13g2_fill_1
XFILLER_13_457 VPWR VGND sg13g2_decap_4
XFILLER_9_428 VPWR VGND sg13g2_fill_1
XFILLER_22_991 VPWR VGND sg13g2_decap_4
XFILLER_4_100 VPWR VGND sg13g2_decap_8
XFILLER_49_1020 VPWR VGND sg13g2_decap_8
XFILLER_4_188 VPWR VGND sg13g2_decap_8
XFILLER_1_840 VPWR VGND sg13g2_decap_8
XFILLER_0_350 VPWR VGND sg13g2_fill_2
XFILLER_49_866 VPWR VGND sg13g2_decap_8
XFILLER_1_1022 VPWR VGND sg13g2_decap_8
XFILLER_36_538 VPWR VGND sg13g2_fill_1
XFILLER_17_785 VPWR VGND sg13g2_fill_2
X_3870_ _1529_ _1530_ _1531_ _1532_ _1533_ VPWR VGND sg13g2_nor4_1
XFILLER_31_232 VPWR VGND sg13g2_fill_2
XFILLER_31_243 VPWR VGND sg13g2_fill_2
XFILLER_32_744 VPWR VGND sg13g2_decap_8
X_2821_ _0724_ _0757_ _0767_ VPWR VGND sg13g2_nor2_2
XFILLER_9_951 VPWR VGND sg13g2_decap_8
X_2752_ VGND VPWR net562 _0716_ _0742_ _0738_ sg13g2_a21oi_1
XFILLER_8_450 VPWR VGND sg13g2_fill_1
X_2683_ _0698_ _0699_ _0697_ _0701_ VPWR VGND _0700_ sg13g2_nand4_1
X_4422_ _2063_ _1941_ _2047_ VPWR VGND sg13g2_xnor2_1
X_4353_ _2004_ _2002_ _2003_ _2001_ _1993_ VPWR VGND sg13g2_a22oi_1
X_3304_ net769 _0976_ _0977_ _0344_ VPWR VGND sg13g2_nor3_1
X_4284_ _0365_ _1937_ _1927_ VPWR VGND sg13g2_nand2b_1
X_3235_ videogen.test_lut_thingy.pixel_feeder_inst.h_counter\[1\] _0822_ _0929_ VPWR
+ VGND sg13g2_and2_1
XFILLER_39_343 VPWR VGND sg13g2_fill_2
X_5181__443 VPWR VGND net443 sg13g2_tiehi
X_3166_ net649 _0832_ _0881_ VPWR VGND sg13g2_nor2_1
X_3097_ videogen.fancy_shader.video_y\[9\] _0672_ videogen.fancy_shader.video_y\[5\]
+ _0849_ VPWR VGND sg13g2_nor3_1
X_3999_ _1659_ _1118_ _1658_ VPWR VGND sg13g2_xnor2_1
XFILLER_2_615 VPWR VGND sg13g2_decap_8
XFILLER_38_54 VPWR VGND sg13g2_fill_1
XFILLER_46_869 VPWR VGND sg13g2_decap_8
X_4987__36 VPWR VGND net36 sg13g2_tiehi
X_4906__174 VPWR VGND net174 sg13g2_tiehi
XFILLER_41_552 VPWR VGND sg13g2_decap_8
XFILLER_14_766 VPWR VGND sg13g2_decap_8
XFILLER_41_585 VPWR VGND sg13g2_decap_8
XFILLER_13_298 VPWR VGND sg13g2_decap_4
X_5230__208 VPWR VGND net208 sg13g2_tiehi
XFILLER_10_972 VPWR VGND sg13g2_decap_8
XFILLER_6_932 VPWR VGND sg13g2_decap_8
XFILLER_48_7 VPWR VGND sg13g2_decap_8
XFILLER_0_180 VPWR VGND sg13g2_decap_8
XFILLER_49_663 VPWR VGND sg13g2_decap_8
X_3020_ _0764_ _0783_ _0810_ VPWR VGND sg13g2_nor2_2
X_4971_ net68 VGND VPWR _0325_ videogen.test_lut_thingy.pixel_feeder_inst.row\[37\]\[2\]
+ _0023_ sg13g2_dfrbpq_1
X_3922_ _1581_ _1582_ _1583_ _1584_ _1585_ VPWR VGND sg13g2_nor4_1
X_3853_ videogen.test_lut_thingy.pixel_feeder_inst.row\[35\]\[1\] net586 _1517_ VPWR
+ VGND sg13g2_nor2_1
X_2804_ videogen.test_lut_thingy.pixel_feeder_inst.row\[19\]\[0\] net809 _0762_ _0572_
+ VPWR VGND sg13g2_mux2_1
X_3784_ videogen.test_lut_thingy.pixel_feeder_inst.row\[5\]\[1\] net573 _1448_ VPWR
+ VGND sg13g2_nor2_1
X_2735_ net776 videogen.test_lut_thingy.pixel_feeder_inst.row\[25\]\[3\] _0736_ _0625_
+ VPWR VGND sg13g2_mux2_1
X_2666_ tmds_green.dc_balancing_reg\[4\] _0685_ VPWR VGND sg13g2_inv_4
X_4405_ _0960_ VPWR _2050_ VGND _1950_ _1986_ sg13g2_o21ai_1
XFILLER_5_91 VPWR VGND sg13g2_decap_4
X_4336_ VGND VPWR _1966_ _1986_ _0367_ _1987_ sg13g2_a21oi_1
X_4267_ _1922_ VPWR _1924_ VGND _1912_ _1915_ sg13g2_o21ai_1
X_3218_ VGND VPWR _0917_ _0892_ _0888_ sg13g2_or2_1
X_4198_ VPWR _1855_ _1854_ VGND sg13g2_inv_1
XFILLER_39_195 VPWR VGND sg13g2_decap_4
X_3149_ net649 videogen.fancy_shader.video_x\[6\] videogen.fancy_shader.video_x\[5\]
+ _0871_ VPWR VGND sg13g2_nor3_1
XFILLER_42_327 VPWR VGND sg13g2_fill_2
XFILLER_27_379 VPWR VGND sg13g2_fill_2
XFILLER_11_736 VPWR VGND sg13g2_decap_4
XFILLER_40_11 VPWR VGND sg13g2_decap_4
XFILLER_3_902 VPWR VGND sg13g2_decap_8
XFILLER_46_1023 VPWR VGND sg13g2_decap_4
XFILLER_3_979 VPWR VGND sg13g2_decap_8
XFILLER_49_42 VPWR VGND sg13g2_decap_8
Xfanout760 net761 net760 VPWR VGND sg13g2_buf_8
Xfanout793 net797 net793 VPWR VGND sg13g2_buf_8
Xfanout782 net786 net782 VPWR VGND sg13g2_buf_8
Xfanout771 net772 net771 VPWR VGND sg13g2_buf_8
XFILLER_1_49 VPWR VGND sg13g2_decap_8
XFILLER_46_666 VPWR VGND sg13g2_decap_8
XFILLER_18_357 VPWR VGND sg13g2_fill_2
XFILLER_14_530 VPWR VGND sg13g2_decap_4
XFILLER_14_596 VPWR VGND sg13g2_fill_1
XFILLER_10_791 VPWR VGND sg13g2_decap_8
XFILLER_5_272 VPWR VGND sg13g2_fill_2
XFILLER_5_261 VPWR VGND sg13g2_decap_8
X_5170_ net73 VGND VPWR _0520_ videogen.test_lut_thingy.pixel_feeder_inst.row\[2\]\[0\]
+ _0149_ sg13g2_dfrbpq_1
X_4121_ _1763_ VPWR _1778_ VGND _1756_ _1764_ sg13g2_o21ai_1
X_5126__219 VPWR VGND net219 sg13g2_tiehi
XFILLER_49_460 VPWR VGND sg13g2_decap_8
X_4052_ _1633_ VPWR _1712_ VGND _1697_ _1710_ sg13g2_o21ai_1
X_3003_ videogen.test_lut_thingy.pixel_feeder_inst.row\[14\]\[1\] net803 _0806_ _0400_
+ VPWR VGND sg13g2_mux2_1
X_5241__134 VPWR VGND net134 sg13g2_tiehi
XFILLER_37_677 VPWR VGND sg13g2_decap_8
XFILLER_24_305 VPWR VGND sg13g2_fill_1
XFILLER_40_809 VPWR VGND sg13g2_fill_1
X_4954_ net102 VGND VPWR _0308_ videogen.test_lut_thingy.pixel_feeder_inst.h_pix\[3\]
+ net651 sg13g2_dfrbpq_1
X_3905_ net645 VPWR _1568_ VGND videogen.test_lut_thingy.pixel_feeder_inst.row\[31\]\[0\]
+ net582 sg13g2_o21ai_1
X_4885_ _2200_ _2201_ _0616_ VPWR VGND sg13g2_nor2_1
XFILLER_20_511 VPWR VGND sg13g2_fill_2
XFILLER_20_522 VPWR VGND sg13g2_decap_8
XFILLER_20_533 VPWR VGND sg13g2_fill_1
X_3836_ net612 VPWR _1500_ VGND videogen.test_lut_thingy.pixel_feeder_inst.row\[40\]\[1\]
+ net596 sg13g2_o21ai_1
X_3767_ videogen.test_lut_thingy.pixel_feeder_inst.row\[11\]\[1\] net578 _1431_ VPWR
+ VGND sg13g2_nor2_1
X_2718_ videogen.test_lut_thingy.pixel_feeder_inst.row\[23\]\[3\] net783 _0727_ _0633_
+ VPWR VGND sg13g2_mux2_1
XFILLER_3_209 VPWR VGND sg13g2_fill_1
X_3698_ videogen.test_lut_thingy.pixel_feeder_inst.row\[50\]\[2\] net602 _1362_ VPWR
+ VGND sg13g2_nor2_1
XFILLER_10_25 VPWR VGND sg13g2_decap_8
XFILLER_0_905 VPWR VGND sg13g2_decap_8
X_4319_ VPWR _1971_ _1970_ VGND sg13g2_inv_1
X_5299_ net367 VGND VPWR _0649_ serialize.shift_reg_g\[3\] clknet_3_6_0_clk_regs sg13g2_dfrbpq_1
XFILLER_19_89 VPWR VGND sg13g2_fill_2
XFILLER_43_614 VPWR VGND sg13g2_decap_8
XFILLER_35_33 VPWR VGND sg13g2_decap_8
XFILLER_27_198 VPWR VGND sg13g2_fill_2
XFILLER_11_577 VPWR VGND sg13g2_fill_1
XFILLER_11_599 VPWR VGND sg13g2_decap_8
XFILLER_4_0 VPWR VGND sg13g2_fill_1
XFILLER_3_776 VPWR VGND sg13g2_decap_8
XFILLER_47_942 VPWR VGND sg13g2_decap_8
Xfanout590 net599 net590 VPWR VGND sg13g2_buf_1
XFILLER_18_8 VPWR VGND sg13g2_fill_2
XFILLER_46_452 VPWR VGND sg13g2_decap_4
XFILLER_19_655 VPWR VGND sg13g2_fill_2
XFILLER_19_688 VPWR VGND sg13g2_decap_8
XFILLER_21_319 VPWR VGND sg13g2_decap_8
XFILLER_33_146 VPWR VGND sg13g2_fill_1
XFILLER_30_820 VPWR VGND sg13g2_fill_2
XFILLER_41_190 VPWR VGND sg13g2_decap_8
X_4670_ net708 net752 _0028_ VPWR VGND sg13g2_nor2_1
XFILLER_30_875 VPWR VGND sg13g2_decap_4
X_3621_ _1281_ _1282_ _1283_ _1284_ _1285_ VPWR VGND sg13g2_nor4_1
X_3552_ _1206_ _1215_ _1216_ VPWR VGND sg13g2_and2_1
X_5212__280 VPWR VGND net280 sg13g2_tiehi
X_3483_ _1112_ VPWR _1147_ VGND _1128_ _1145_ sg13g2_o21ai_1
X_5222_ net240 VGND VPWR _0572_ videogen.test_lut_thingy.pixel_feeder_inst.row\[19\]\[0\]
+ _0201_ sg13g2_dfrbpq_1
X_5153_ net136 VGND VPWR _0503_ videogen.test_lut_thingy.pixel_feeder_inst.row\[51\]\[3\]
+ _0140_ sg13g2_dfrbpq_1
X_4104_ _1761_ _1757_ _1758_ _1755_ _1749_ VPWR VGND sg13g2_a22oi_1
XFILLER_2_70 VPWR VGND sg13g2_decap_4
X_5084_ net303 VGND VPWR _0434_ videogen.test_lut_thingy.pixel_feeder_inst.row\[6\]\[2\]
+ _0071_ sg13g2_dfrbpq_1
X_4035_ VGND VPWR _1678_ _1695_ _1694_ _1676_ sg13g2_a21oi_2
XFILLER_13_809 VPWR VGND sg13g2_decap_8
X_4937_ net128 VGND VPWR _0291_ videogen.fancy_shader.video_x\[3\] net657 sg13g2_dfrbpq_2
XFILLER_21_842 VPWR VGND sg13g2_decap_8
X_4868_ net693 net737 _0225_ VPWR VGND sg13g2_nor2_1
X_3819_ videogen.test_lut_thingy.pixel_feeder_inst.row\[55\]\[1\] net580 _1483_ VPWR
+ VGND sg13g2_nor2_1
X_4799_ net709 net753 _0156_ VPWR VGND sg13g2_nor2_1
X_4962__86 VPWR VGND net86 sg13g2_tiehi
XFILLER_0_702 VPWR VGND sg13g2_decap_8
XFILLER_0_779 VPWR VGND sg13g2_decap_8
XFILLER_46_76 VPWR VGND sg13g2_decap_4
XFILLER_46_65 VPWR VGND sg13g2_fill_1
XFILLER_16_603 VPWR VGND sg13g2_decap_8
X_5079__313 VPWR VGND net313 sg13g2_tiehi
XFILLER_43_477 VPWR VGND sg13g2_fill_2
XFILLER_43_499 VPWR VGND sg13g2_decap_4
XFILLER_24_691 VPWR VGND sg13g2_decap_8
XFILLER_8_835 VPWR VGND sg13g2_fill_2
XFILLER_8_824 VPWR VGND sg13g2_decap_8
XFILLER_11_385 VPWR VGND sg13g2_fill_1
XFILLER_3_562 VPWR VGND sg13g2_decap_8
XFILLER_23_6 VPWR VGND sg13g2_fill_1
XFILLER_34_455 VPWR VGND sg13g2_decap_4
XFILLER_35_989 VPWR VGND sg13g2_fill_1
X_2983_ net803 videogen.test_lut_thingy.pixel_feeder_inst.row\[31\]\[1\] _0802_ _0425_
+ VPWR VGND sg13g2_mux2_1
XFILLER_22_628 VPWR VGND sg13g2_decap_4
XFILLER_34_488 VPWR VGND sg13g2_decap_4
X_4722_ net699 net743 _0079_ VPWR VGND sg13g2_nor2_1
X_4653_ net689 net733 _0012_ VPWR VGND sg13g2_nor2_1
X_3604_ videogen.test_lut_thingy.pixel_feeder_inst.row\[35\]\[3\] net586 _1268_ VPWR
+ VGND sg13g2_nor2_1
X_4584_ net626 VPWR _2206_ VGND _2203_ _2205_ sg13g2_o21ai_1
X_3535_ _1032_ _1198_ _1199_ VPWR VGND sg13g2_and2_1
X_3466_ VGND VPWR _1130_ _1129_ _1121_ sg13g2_or2_1
X_5205_ net308 VGND VPWR _0555_ videogen.test_lut_thingy.pixel_feeder_inst.row\[47\]\[3\]
+ _0184_ sg13g2_dfrbpq_1
X_3397_ videogen.fancy_shader.shader_counter_reg\[8\] videogen.fancy_shader.video_x\[8\]
+ _1061_ VPWR VGND sg13g2_xor2_1
X_5136_ net199 VGND VPWR _0486_ videogen.test_lut_thingy.pixel_feeder_inst.row\[0\]\[2\]
+ _0123_ sg13g2_dfrbpq_1
X_5067_ net337 VGND VPWR _0417_ videogen.test_lut_thingy.pixel_feeder_inst.row\[32\]\[1\]
+ _0054_ sg13g2_dfrbpq_1
X_4018_ _1673_ _1677_ _1678_ VPWR VGND sg13g2_and2_1
XFILLER_16_35 VPWR VGND sg13g2_fill_1
XFILLER_16_46 VPWR VGND sg13g2_decap_8
XFILLER_25_455 VPWR VGND sg13g2_decap_4
XFILLER_13_639 VPWR VGND sg13g2_decap_8
XFILLER_20_193 VPWR VGND sg13g2_fill_1
XFILLER_5_838 VPWR VGND sg13g2_decap_8
XFILLER_10_1014 VPWR VGND sg13g2_decap_8
X_5226__224 VPWR VGND net224 sg13g2_tiehi
XFILLER_0_576 VPWR VGND sg13g2_decap_8
XFILLER_48_547 VPWR VGND sg13g2_decap_8
XFILLER_17_956 VPWR VGND sg13g2_decap_8
XFILLER_29_794 VPWR VGND sg13g2_fill_1
XFILLER_44_753 VPWR VGND sg13g2_decap_4
XFILLER_16_477 VPWR VGND sg13g2_decap_8
XFILLER_40_992 VPWR VGND sg13g2_fill_1
X_3320_ net771 _0985_ _0986_ _0351_ VPWR VGND sg13g2_nor3_1
X_3251_ _0938_ _0939_ _0940_ _0328_ VPWR VGND sg13g2_nor3_1
X_3182_ _0893_ videogen.test_lut_thingy.pixel_feeder_inst.v_pix\[0\] _0892_ VPWR VGND
+ sg13g2_xnor2_1
X_5205__308 VPWR VGND net308 sg13g2_tiehi
XFILLER_39_569 VPWR VGND sg13g2_decap_8
X_2966_ VGND VPWR _0671_ _0798_ _0439_ _0799_ sg13g2_a21oi_1
X_4705_ net705 net749 _0062_ VPWR VGND sg13g2_nor2_1
X_2897_ _0783_ _0748_ _0753_ VPWR VGND sg13g2_nand2_2
X_4636_ _2233_ net670 net455 net676 red_tmds_par\[4\] VPWR VGND sg13g2_a22oi_1
X_4567_ _2193_ _2190_ _2192_ VPWR VGND sg13g2_xnor2_1
X_4498_ tmds_blue.dc_balancing_reg\[4\] _0682_ _2126_ _2127_ VPWR VGND sg13g2_a21o_2
X_3518_ _1096_ _1180_ _1182_ VPWR VGND sg13g2_nor2_1
X_3449_ _1027_ VPWR _1113_ VGND _1026_ _1028_ sg13g2_o21ai_1
X_5119_ net233 VGND VPWR _0469_ videogen.test_lut_thingy.pixel_feeder_inst.row\[58\]\[1\]
+ _0106_ sg13g2_dfrbpq_1
XFILLER_26_742 VPWR VGND sg13g2_fill_2
XFILLER_40_244 VPWR VGND sg13g2_decap_4
XFILLER_13_447 VPWR VGND sg13g2_fill_2
XFILLER_43_77 VPWR VGND sg13g2_fill_2
XFILLER_4_134 VPWR VGND sg13g2_decap_8
XFILLER_4_178 VPWR VGND sg13g2_decap_4
XFILLER_1_896 VPWR VGND sg13g2_decap_8
XFILLER_49_845 VPWR VGND sg13g2_decap_8
XFILLER_1_1001 VPWR VGND sg13g2_decap_8
XFILLER_32_734 VPWR VGND sg13g2_decap_4
XFILLER_44_594 VPWR VGND sg13g2_decap_8
X_2820_ videogen.test_lut_thingy.pixel_feeder_inst.row\[45\]\[0\] net816 _0766_ _0560_
+ VPWR VGND sg13g2_mux2_1
XFILLER_9_930 VPWR VGND sg13g2_decap_8
XFILLER_31_255 VPWR VGND sg13g2_fill_2
X_2751_ videogen.test_lut_thingy.pixel_feeder_inst.row\[39\]\[0\] net817 _0741_ _0604_
+ VPWR VGND sg13g2_mux2_1
X_2682_ videogen.fancy_shader.video_x\[8\] videogen.fancy_shader.video_x\[9\] _0700_
+ VPWR VGND sg13g2_nor2b_2
X_4421_ VGND VPWR net628 _2062_ _0403_ net773 sg13g2_a21oi_1
X_4352_ _1983_ net564 net555 _2003_ VPWR VGND sg13g2_a21o_1
X_3303_ videogen.fancy_shader.video_y\[5\] _0975_ _0977_ VPWR VGND sg13g2_and2_1
X_4283_ VGND VPWR _1624_ _1933_ _1937_ _1936_ sg13g2_a21oi_1
X_3234_ _0822_ _0927_ _0928_ _0315_ VPWR VGND sg13g2_nor3_1
X_3165_ net649 _0832_ _0880_ VPWR VGND sg13g2_and2_1
X_3096_ _0846_ _0847_ _0848_ VPWR VGND sg13g2_nor2_1
X_5105__261 VPWR VGND net261 sg13g2_tiehi
XFILLER_35_583 VPWR VGND sg13g2_decap_8
X_3998_ _1658_ _1029_ _1634_ VPWR VGND sg13g2_nand2_1
XFILLER_13_36 VPWR VGND sg13g2_decap_8
XFILLER_13_47 VPWR VGND sg13g2_fill_1
X_2949_ net778 videogen.test_lut_thingy.pixel_feeder_inst.row\[63\]\[3\] _0794_ _0451_
+ VPWR VGND sg13g2_mux2_1
X_4619_ VPWR _0649_ _2224_ VGND sg13g2_inv_1
XFILLER_49_108 VPWR VGND sg13g2_decap_4
XFILLER_38_22 VPWR VGND sg13g2_decap_8
XFILLER_46_848 VPWR VGND sg13g2_decap_8
XFILLER_13_244 VPWR VGND sg13g2_decap_4
XFILLER_9_259 VPWR VGND sg13g2_fill_2
XFILLER_9_237 VPWR VGND sg13g2_decap_4
XFILLER_13_277 VPWR VGND sg13g2_decap_8
XFILLER_6_911 VPWR VGND sg13g2_decap_8
XFILLER_10_951 VPWR VGND sg13g2_decap_8
XFILLER_6_988 VPWR VGND sg13g2_decap_8
X_5087__297 VPWR VGND net297 sg13g2_tiehi
XFILLER_49_642 VPWR VGND sg13g2_decap_8
XFILLER_1_693 VPWR VGND sg13g2_decap_8
XFILLER_23_1024 VPWR VGND sg13g2_decap_4
XFILLER_36_303 VPWR VGND sg13g2_fill_2
XFILLER_36_325 VPWR VGND sg13g2_fill_1
XFILLER_45_892 VPWR VGND sg13g2_decap_8
X_4970_ net70 VGND VPWR _0324_ videogen.test_lut_thingy.pixel_feeder_inst.row\[37\]\[1\]
+ _0022_ sg13g2_dfrbpq_1
XFILLER_44_380 VPWR VGND sg13g2_fill_1
X_3921_ net615 VPWR _1584_ VGND videogen.test_lut_thingy.pixel_feeder_inst.row\[51\]\[0\]
+ net580 sg13g2_o21ai_1
X_3852_ net613 VPWR _1516_ VGND videogen.test_lut_thingy.pixel_feeder_inst.row\[34\]\[1\]
+ net606 sg13g2_o21ai_1
X_2803_ videogen.test_lut_thingy.pixel_feeder_inst.row\[19\]\[1\] net799 _0762_ _0573_
+ VPWR VGND sg13g2_mux2_1
X_3783_ videogen.test_lut_thingy.pixel_feeder_inst.row\[7\]\[1\] net583 _1447_ VPWR
+ VGND sg13g2_nor2_1
XFILLER_9_782 VPWR VGND sg13g2_decap_8
X_2734_ _0736_ _0732_ _0735_ VPWR VGND sg13g2_nand2_2
X_2665_ VPWR _0684_ tmds_green.dc_balancing_reg\[3\] VGND sg13g2_inv_1
X_4404_ net565 _2049_ _0373_ VPWR VGND sg13g2_nor2_1
X_4335_ _0960_ VPWR _1987_ VGND _1966_ _1986_ sg13g2_o21ai_1
X_4266_ VGND VPWR _1903_ _1908_ _1923_ _1916_ sg13g2_a21oi_1
X_3217_ _0836_ _0916_ _0310_ VPWR VGND sg13g2_nor2_1
X_4197_ _1854_ _1118_ _1853_ VPWR VGND sg13g2_xnor2_1
XFILLER_28_804 VPWR VGND sg13g2_fill_2
XFILLER_27_303 VPWR VGND sg13g2_decap_4
X_3148_ net820 _0870_ _0283_ VPWR VGND sg13g2_and2_1
X_5042__370 VPWR VGND net370 sg13g2_tiehi
X_3079_ _0839_ net818 _0838_ VPWR VGND sg13g2_nand2_1
X_5296__394 VPWR VGND net394 sg13g2_tiehi
XFILLER_23_531 VPWR VGND sg13g2_fill_2
XFILLER_35_380 VPWR VGND sg13g2_fill_2
XFILLER_23_564 VPWR VGND sg13g2_decap_8
XFILLER_23_586 VPWR VGND sg13g2_fill_2
XFILLER_10_258 VPWR VGND sg13g2_fill_1
XFILLER_49_21 VPWR VGND sg13g2_decap_8
XFILLER_46_1002 VPWR VGND sg13g2_decap_8
XFILLER_6_4 VPWR VGND sg13g2_fill_2
XFILLER_3_958 VPWR VGND sg13g2_decap_8
XFILLER_2_435 VPWR VGND sg13g2_fill_1
XFILLER_2_446 VPWR VGND sg13g2_decap_4
XFILLER_49_87 VPWR VGND sg13g2_decap_8
Xfanout750 net753 net750 VPWR VGND sg13g2_buf_8
Xfanout794 net796 net794 VPWR VGND sg13g2_buf_8
Xfanout761 net767 net761 VPWR VGND sg13g2_buf_8
XFILLER_1_28 VPWR VGND sg13g2_decap_8
Xfanout783 net786 net783 VPWR VGND sg13g2_buf_8
Xfanout772 _0673_ net772 VPWR VGND sg13g2_buf_8
XFILLER_18_325 VPWR VGND sg13g2_decap_8
XFILLER_19_826 VPWR VGND sg13g2_decap_8
XFILLER_46_645 VPWR VGND sg13g2_decap_8
XFILLER_18_336 VPWR VGND sg13g2_fill_1
XFILLER_34_807 VPWR VGND sg13g2_decap_4
XFILLER_45_166 VPWR VGND sg13g2_fill_1
XFILLER_14_564 VPWR VGND sg13g2_fill_1
XFILLER_41_394 VPWR VGND sg13g2_fill_2
XFILLER_6_785 VPWR VGND sg13g2_decap_8
XFILLER_5_295 VPWR VGND sg13g2_decap_8
X_4120_ _1750_ _1761_ _1762_ _1764_ _1777_ VPWR VGND sg13g2_or4_1
XFILLER_1_490 VPWR VGND sg13g2_decap_8
X_4051_ _1708_ _1707_ _1704_ _1711_ VPWR VGND sg13g2_a21o_1
X_3002_ videogen.test_lut_thingy.pixel_feeder_inst.row\[14\]\[2\] net792 _0806_ _0401_
+ VPWR VGND sg13g2_mux2_1
XFILLER_37_656 VPWR VGND sg13g2_decap_8
XFILLER_25_818 VPWR VGND sg13g2_fill_2
X_4953_ net104 VGND VPWR _0307_ videogen.test_lut_thingy.pixel_feeder_inst.h_pix\[2\]
+ net651 sg13g2_dfrbpq_2
X_3904_ _1563_ _1564_ _1565_ _1566_ _1567_ VPWR VGND sg13g2_nor4_1
X_4884_ _2200_ _2201_ _0615_ VPWR VGND sg13g2_nor2_1
X_4959__92 VPWR VGND net92 sg13g2_tiehi
X_4974__62 VPWR VGND net62 sg13g2_tiehi
X_3835_ _0676_ _1487_ _1498_ _1499_ VPWR VGND sg13g2_or3_1
X_3766_ net638 VPWR _1430_ VGND videogen.test_lut_thingy.pixel_feeder_inst.row\[8\]\[1\]
+ net588 sg13g2_o21ai_1
XFILLER_20_589 VPWR VGND sg13g2_decap_8
X_2717_ _0721_ _0726_ _0727_ VPWR VGND sg13g2_nor2b_2
X_3697_ videogen.test_lut_thingy.pixel_feeder_inst.row\[51\]\[2\] net579 _1361_ VPWR
+ VGND sg13g2_nor2_1
XFILLER_10_59 VPWR VGND sg13g2_decap_8
X_4318_ _1970_ _1955_ _1969_ VPWR VGND sg13g2_nand2_1
X_5298_ net375 VGND VPWR _0648_ serialize.shift_reg_g\[2\] clknet_3_1_0_clk_regs sg13g2_dfrbpq_1
X_4249_ _1873_ _1830_ _1870_ _1906_ VPWR VGND sg13g2_a21o_1
XFILLER_27_144 VPWR VGND sg13g2_fill_2
XFILLER_28_645 VPWR VGND sg13g2_decap_8
XFILLER_16_829 VPWR VGND sg13g2_decap_8
XFILLER_15_328 VPWR VGND sg13g2_fill_2
XFILLER_30_309 VPWR VGND sg13g2_decap_4
XFILLER_35_89 VPWR VGND sg13g2_fill_1
XFILLER_11_523 VPWR VGND sg13g2_decap_8
XFILLER_3_755 VPWR VGND sg13g2_decap_8
XFILLER_2_232 VPWR VGND sg13g2_fill_1
XFILLER_2_298 VPWR VGND sg13g2_decap_4
XFILLER_47_921 VPWR VGND sg13g2_decap_8
Xfanout580 net581 net580 VPWR VGND sg13g2_buf_2
Xfanout591 net593 net591 VPWR VGND sg13g2_buf_8
X_5199__332 VPWR VGND net332 sg13g2_tiehi
XFILLER_47_998 VPWR VGND sg13g2_decap_8
XFILLER_14_350 VPWR VGND sg13g2_fill_1
XFILLER_42_681 VPWR VGND sg13g2_decap_8
XFILLER_30_865 VPWR VGND sg13g2_decap_4
X_3620_ videogen.test_lut_thingy.pixel_feeder_inst.row\[9\]\[3\] net567 _1284_ VPWR
+ VGND sg13g2_nor2_1
X_3551_ _1215_ _1214_ _1205_ VPWR VGND sg13g2_nand2b_1
X_3482_ _1134_ _1132_ _1146_ VPWR VGND sg13g2_xor2_1
X_5221_ net244 VGND VPWR _0571_ videogen.test_lut_thingy.pixel_feeder_inst.row\[43\]\[3\]
+ _0200_ sg13g2_dfrbpq_1
X_5152_ net142 VGND VPWR _0502_ videogen.test_lut_thingy.pixel_feeder_inst.row\[51\]\[2\]
+ _0139_ sg13g2_dfrbpq_1
X_4103_ _1651_ _1753_ _1649_ _1760_ VPWR VGND sg13g2_nand3_1
XFILLER_29_409 VPWR VGND sg13g2_fill_1
X_5083_ net305 VGND VPWR _0433_ videogen.test_lut_thingy.pixel_feeder_inst.row\[6\]\[1\]
+ _0070_ sg13g2_dfrbpq_1
X_4034_ _1694_ _1673_ _1680_ VPWR VGND sg13g2_nand2_1
X_4926__145 VPWR VGND net145 sg13g2_tiehi
XFILLER_24_147 VPWR VGND sg13g2_fill_2
X_4936_ net129 VGND VPWR _0290_ videogen.fancy_shader.video_x\[2\] net657 sg13g2_dfrbpq_2
XFILLER_33_681 VPWR VGND sg13g2_decap_4
XFILLER_21_865 VPWR VGND sg13g2_decap_8
XFILLER_32_180 VPWR VGND sg13g2_decap_8
X_4867_ net720 net765 _0224_ VPWR VGND sg13g2_nor2_1
X_3818_ net644 VPWR _1482_ VGND videogen.test_lut_thingy.pixel_feeder_inst.row\[54\]\[1\]
+ net602 sg13g2_o21ai_1
XFILLER_20_353 VPWR VGND sg13g2_decap_8
X_4798_ net705 net749 _0155_ VPWR VGND sg13g2_nor2_1
XFILLER_20_397 VPWR VGND sg13g2_fill_2
X_3749_ net616 _1407_ _1412_ _1413_ VPWR VGND sg13g2_nor3_1
XFILLER_0_758 VPWR VGND sg13g2_decap_8
XFILLER_48_729 VPWR VGND sg13g2_decap_8
XFILLER_29_965 VPWR VGND sg13g2_fill_1
XFILLER_43_489 VPWR VGND sg13g2_decap_4
XFILLER_8_803 VPWR VGND sg13g2_decap_8
XFILLER_12_865 VPWR VGND sg13g2_decap_4
XFILLER_30_139 VPWR VGND sg13g2_decap_8
XFILLER_7_324 VPWR VGND sg13g2_decap_4
XFILLER_3_541 VPWR VGND sg13g2_decap_8
X_4949__112 VPWR VGND net112 sg13g2_tiehi
XFILLER_39_718 VPWR VGND sg13g2_fill_1
XFILLER_38_228 VPWR VGND sg13g2_fill_2
XFILLER_47_795 VPWR VGND sg13g2_decap_8
XFILLER_34_423 VPWR VGND sg13g2_decap_8
X_2982_ net792 videogen.test_lut_thingy.pixel_feeder_inst.row\[31\]\[2\] _0802_ _0426_
+ VPWR VGND sg13g2_mux2_1
XFILLER_21_106 VPWR VGND sg13g2_fill_1
XFILLER_21_139 VPWR VGND sg13g2_decap_4
X_4721_ net694 net738 _0078_ VPWR VGND sg13g2_nor2_1
X_4652_ net690 net734 _0011_ VPWR VGND sg13g2_nor2_1
XFILLER_30_651 VPWR VGND sg13g2_fill_2
X_3603_ net613 VPWR _1267_ VGND videogen.test_lut_thingy.pixel_feeder_inst.row\[32\]\[3\]
+ net597 sg13g2_o21ai_1
X_4583_ _2205_ blue\[6\] _2198_ VPWR VGND sg13g2_xnor2_1
X_3534_ _1191_ VPWR _1198_ VGND _1195_ _1197_ sg13g2_o21ai_1
X_3465_ _1129_ _1126_ _1111_ _1123_ _1122_ VPWR VGND sg13g2_a22oi_1
X_5204_ net312 VGND VPWR _0554_ videogen.test_lut_thingy.pixel_feeder_inst.row\[47\]\[2\]
+ _0183_ sg13g2_dfrbpq_1
X_3396_ _1060_ videogen.fancy_shader.video_x\[8\] videogen.fancy_shader.shader_counter_reg\[8\]
+ VPWR VGND sg13g2_nand2_1
X_5260__330 VPWR VGND net330 sg13g2_tiehi
X_5135_ net201 VGND VPWR _0485_ videogen.test_lut_thingy.pixel_feeder_inst.row\[0\]\[1\]
+ _0122_ sg13g2_dfrbpq_1
XFILLER_29_217 VPWR VGND sg13g2_decap_8
X_5066_ net339 VGND VPWR _0416_ videogen.test_lut_thingy.pixel_feeder_inst.row\[32\]\[0\]
+ _0053_ sg13g2_dfrbpq_1
XFILLER_44_209 VPWR VGND sg13g2_decap_4
X_4017_ _1674_ _1668_ _1675_ _1677_ VPWR VGND sg13g2_a21o_1
XFILLER_26_913 VPWR VGND sg13g2_decap_4
XFILLER_25_412 VPWR VGND sg13g2_fill_1
XFILLER_26_935 VPWR VGND sg13g2_fill_1
XFILLER_26_979 VPWR VGND sg13g2_decap_8
XFILLER_41_927 VPWR VGND sg13g2_fill_2
X_4919_ net158 VGND VPWR _0273_ serialize.shift_reg_c\[4\] clknet_3_3_0_clk_regs sg13g2_dfrbpq_1
XFILLER_40_448 VPWR VGND sg13g2_decap_4
XFILLER_5_817 VPWR VGND sg13g2_decap_8
X_5115__241 VPWR VGND net241 sg13g2_tiehi
XFILLER_0_555 VPWR VGND sg13g2_decap_8
XFILLER_48_526 VPWR VGND sg13g2_decap_8
XFILLER_17_913 VPWR VGND sg13g2_fill_2
XFILLER_29_773 VPWR VGND sg13g2_fill_1
XFILLER_16_412 VPWR VGND sg13g2_decap_4
XFILLER_16_423 VPWR VGND sg13g2_fill_2
XFILLER_44_765 VPWR VGND sg13g2_fill_2
XFILLER_44_798 VPWR VGND sg13g2_fill_1
XFILLER_31_426 VPWR VGND sg13g2_fill_2
XFILLER_31_459 VPWR VGND sg13g2_fill_2
XFILLER_12_673 VPWR VGND sg13g2_decap_8
XFILLER_7_176 VPWR VGND sg13g2_decap_8
XFILLER_4_883 VPWR VGND sg13g2_decap_8
X_3250_ VGND VPWR net633 _0933_ _0940_ net632 sg13g2_a21oi_1
X_3181_ _0890_ _0891_ _0892_ VPWR VGND sg13g2_nor2_2
XFILLER_21_4 VPWR VGND sg13g2_fill_2
XFILLER_47_592 VPWR VGND sg13g2_decap_8
XFILLER_35_721 VPWR VGND sg13g2_decap_8
XFILLER_34_220 VPWR VGND sg13g2_fill_1
X_5097__277 VPWR VGND net277 sg13g2_tiehi
X_4704_ net687 net731 _0061_ VPWR VGND sg13g2_nor2_1
X_2965_ net778 _0798_ _0799_ VPWR VGND sg13g2_nor2_1
XFILLER_31_960 VPWR VGND sg13g2_fill_1
X_2896_ net634 _0739_ _0749_ _0782_ VPWR VGND sg13g2_nor3_2
XFILLER_8_92 VPWR VGND sg13g2_fill_1
X_4635_ VPWR _0657_ _2232_ VGND sg13g2_inv_1
X_4566_ _2191_ tmds_blue.dc_balancing_reg\[4\] _2192_ VPWR VGND sg13g2_xor2_1
X_3517_ _1100_ VPWR _1181_ VGND _1106_ _1178_ sg13g2_o21ai_1
X_4497_ _0682_ tmds_blue.dc_balancing_reg\[4\] _2125_ _2126_ VPWR VGND sg13g2_nor3_1
X_3448_ _1108_ _1109_ _1059_ _1112_ VPWR VGND sg13g2_mux2_1
X_3379_ _1040_ VPWR _1043_ VGND _1017_ _1042_ sg13g2_o21ai_1
XFILLER_40_1008 VPWR VGND sg13g2_decap_8
X_5118_ net235 VGND VPWR _0468_ videogen.test_lut_thingy.pixel_feeder_inst.row\[58\]\[0\]
+ _0105_ sg13g2_dfrbpq_1
XFILLER_38_570 VPWR VGND sg13g2_fill_2
X_5049_ net176 VGND VPWR _0002_ videogen.test_lut_thingy.pixel_feeder_inst.state\[0\]
+ net650 sg13g2_dfrbpq_1
XFILLER_40_223 VPWR VGND sg13g2_fill_1
XFILLER_9_419 VPWR VGND sg13g2_decap_8
XFILLER_49_824 VPWR VGND sg13g2_decap_8
XFILLER_0_341 VPWR VGND sg13g2_fill_1
XFILLER_1_875 VPWR VGND sg13g2_decap_8
XFILLER_48_356 VPWR VGND sg13g2_fill_2
XFILLER_48_389 VPWR VGND sg13g2_fill_1
XFILLER_16_220 VPWR VGND sg13g2_decap_8
XFILLER_44_573 VPWR VGND sg13g2_decap_8
XFILLER_16_286 VPWR VGND sg13g2_decap_8
XFILLER_31_234 VPWR VGND sg13g2_fill_1
XFILLER_13_960 VPWR VGND sg13g2_decap_4
XFILLER_32_779 VPWR VGND sg13g2_decap_8
X_2750_ videogen.test_lut_thingy.pixel_feeder_inst.row\[39\]\[1\] net805 _0741_ _0605_
+ VPWR VGND sg13g2_mux2_1
XFILLER_9_986 VPWR VGND sg13g2_decap_8
X_2681_ videogen.fancy_shader.video_x\[1\] videogen.fancy_shader.video_x\[0\] _0699_
+ VPWR VGND sg13g2_nor2_1
X_4420_ _2062_ red\[2\] _2046_ VPWR VGND sg13g2_xnor2_1
XFILLER_4_680 VPWR VGND sg13g2_decap_8
X_4351_ _2002_ net564 _1999_ VPWR VGND sg13g2_xnor2_1
X_3302_ videogen.fancy_shader.video_y\[5\] _0975_ _0976_ VPWR VGND sg13g2_nor2_1
X_4282_ VGND VPWR _1627_ _1935_ _1936_ _1929_ sg13g2_a21oi_1
X_3233_ videogen.test_lut_thingy.pixel_feeder_inst.h_counter\[0\] _0820_ _0928_ VPWR
+ VGND sg13g2_nor2_1
XFILLER_39_345 VPWR VGND sg13g2_fill_1
X_5279__218 VPWR VGND net218 sg13g2_tiehi
X_3164_ _0832_ _0873_ _0879_ _0294_ VPWR VGND sg13g2_nor3_1
XFILLER_48_890 VPWR VGND sg13g2_decap_8
X_3095_ _0847_ videogen.fancy_shader.video_y\[2\] _0845_ VPWR VGND sg13g2_nand2_1
XFILLER_35_551 VPWR VGND sg13g2_fill_1
XFILLER_35_562 VPWR VGND sg13g2_decap_8
XFILLER_22_212 VPWR VGND sg13g2_fill_2
XFILLER_23_735 VPWR VGND sg13g2_decap_8
XFILLER_23_746 VPWR VGND sg13g2_fill_1
X_3997_ _1657_ _1654_ _1656_ VPWR VGND sg13g2_nand2_1
XFILLER_22_267 VPWR VGND sg13g2_decap_8
X_2948_ _0794_ net559 _0750_ VPWR VGND sg13g2_nand2_2
X_2879_ videogen.test_lut_thingy.pixel_feeder_inst.row\[52\]\[1\] net801 _0778_ _0505_
+ VPWR VGND sg13g2_mux2_1
X_4618_ _2224_ net671 net472 net677 green_tmds_par\[1\] VPWR VGND sg13g2_a22oi_1
X_4549_ net625 _2130_ _2176_ VPWR VGND sg13g2_nor2_1
XFILLER_8_8 VPWR VGND sg13g2_fill_2
XFILLER_1_138 VPWR VGND sg13g2_decap_4
XFILLER_46_827 VPWR VGND sg13g2_decap_8
XFILLER_26_562 VPWR VGND sg13g2_fill_2
XFILLER_26_584 VPWR VGND sg13g2_fill_1
XFILLER_10_930 VPWR VGND sg13g2_decap_8
XFILLER_16_1021 VPWR VGND sg13g2_decap_8
XFILLER_6_967 VPWR VGND sg13g2_decap_8
XFILLER_49_621 VPWR VGND sg13g2_decap_8
XFILLER_1_672 VPWR VGND sg13g2_decap_8
XFILLER_49_698 VPWR VGND sg13g2_decap_8
XFILLER_36_337 VPWR VGND sg13g2_fill_1
XFILLER_45_871 VPWR VGND sg13g2_decap_8
X_3920_ videogen.test_lut_thingy.pixel_feeder_inst.row\[50\]\[0\] net603 _1583_ VPWR
+ VGND sg13g2_nor2_1
XFILLER_20_705 VPWR VGND sg13g2_decap_8
XFILLER_32_554 VPWR VGND sg13g2_decap_8
X_3851_ _1511_ _1512_ _1513_ _1514_ _1515_ VPWR VGND sg13g2_nor4_1
X_2802_ videogen.test_lut_thingy.pixel_feeder_inst.row\[19\]\[2\] net787 _0762_ _0574_
+ VPWR VGND sg13g2_mux2_1
X_5315__156 VPWR VGND net156 sg13g2_tiehi
X_3782_ net616 VPWR _1446_ VGND videogen.test_lut_thingy.pixel_feeder_inst.row\[6\]\[1\]
+ net605 sg13g2_o21ai_1
X_2733_ net609 net558 _0735_ VPWR VGND sg13g2_nor2_2
XFILLER_8_271 VPWR VGND sg13g2_decap_8
X_2664_ _0683_ net622 VPWR VGND sg13g2_inv_2
X_4403_ _1986_ _1939_ _2049_ VPWR VGND sg13g2_xor2_1
X_4334_ VGND VPWR _1985_ _1986_ _1984_ net555 sg13g2_a21oi_2
XFILLER_8_1008 VPWR VGND sg13g2_decap_8
X_4265_ _1916_ _1899_ _1910_ _1922_ VPWR VGND sg13g2_a21o_1
XFILLER_39_120 VPWR VGND sg13g2_decap_8
X_3216_ _0915_ net634 _0916_ VPWR VGND sg13g2_xor2_1
X_4196_ _1853_ _1770_ _1831_ VPWR VGND sg13g2_xnor2_1
X_3147_ _0867_ _0869_ _0870_ VPWR VGND sg13g2_nor2b_1
XFILLER_27_359 VPWR VGND sg13g2_decap_8
X_3078_ VGND VPWR _0838_ videogen.test_lut_thingy.pixel_feeder_inst.state\[3\] videogen.test_lut_thingy.pixel_feeder_inst.state\[1\]
+ sg13g2_or2_1
XFILLER_42_329 VPWR VGND sg13g2_fill_1
XFILLER_24_25 VPWR VGND sg13g2_fill_2
XFILLER_3_937 VPWR VGND sg13g2_decap_8
XFILLER_2_414 VPWR VGND sg13g2_decap_8
X_5264__306 VPWR VGND net306 sg13g2_tiehi
Xfanout740 net741 net740 VPWR VGND sg13g2_buf_2
Xfanout751 net753 net751 VPWR VGND sg13g2_buf_8
Xfanout784 net785 net784 VPWR VGND sg13g2_buf_8
Xfanout762 net767 net762 VPWR VGND sg13g2_buf_8
Xfanout773 net775 net773 VPWR VGND sg13g2_buf_8
XFILLER_46_624 VPWR VGND sg13g2_decap_8
Xfanout795 net796 net795 VPWR VGND sg13g2_buf_1
XFILLER_27_871 VPWR VGND sg13g2_fill_2
XFILLER_27_882 VPWR VGND sg13g2_fill_2
XFILLER_42_841 VPWR VGND sg13g2_decap_4
XFILLER_26_370 VPWR VGND sg13g2_decap_8
XFILLER_26_392 VPWR VGND sg13g2_decap_8
XFILLER_6_742 VPWR VGND sg13g2_fill_1
X_4050_ VGND VPWR _1707_ _1708_ _1710_ _1704_ sg13g2_a21oi_1
X_3001_ videogen.test_lut_thingy.pixel_feeder_inst.row\[14\]\[3\] net782 _0806_ _0402_
+ VPWR VGND sg13g2_mux2_1
XFILLER_49_495 VPWR VGND sg13g2_decap_8
XFILLER_37_635 VPWR VGND sg13g2_decap_8
X_5026__399 VPWR VGND net399 sg13g2_tiehi
X_4952_ net106 VGND VPWR _0306_ videogen.test_lut_thingy.pixel_feeder_inst.h_pix\[1\]
+ net650 sg13g2_dfrbpq_2
X_4883_ net709 net753 _0240_ VPWR VGND sg13g2_nor2_1
X_3903_ videogen.test_lut_thingy.pixel_feeder_inst.row\[25\]\[0\] net567 _1566_ VPWR
+ VGND sg13g2_nor2_1
XFILLER_32_351 VPWR VGND sg13g2_decap_8
XFILLER_20_513 VPWR VGND sg13g2_fill_1
X_3834_ net615 _1492_ _1497_ _1498_ VPWR VGND sg13g2_nor3_1
XFILLER_32_373 VPWR VGND sg13g2_fill_2
XFILLER_20_579 VPWR VGND sg13g2_fill_2
X_3765_ VPWR _1429_ _1428_ VGND sg13g2_inv_1
X_3696_ net615 VPWR _1360_ VGND videogen.test_lut_thingy.pixel_feeder_inst.row\[49\]\[2\]
+ net570 sg13g2_o21ai_1
X_2716_ net562 VPWR _0726_ VGND net644 net592 sg13g2_o21ai_1
X_4317_ _1968_ VPWR _1969_ VGND _1941_ _1959_ sg13g2_o21ai_1
X_5297_ net383 VGND VPWR _0647_ serialize.shift_reg_g\[1\] clknet_3_1_0_clk_regs sg13g2_dfrbpq_1
X_4248_ _1905_ _1874_ _1891_ VPWR VGND sg13g2_xnor2_1
XFILLER_27_101 VPWR VGND sg13g2_fill_2
X_4179_ _1836_ _1752_ _1835_ VPWR VGND sg13g2_xnor2_1
XFILLER_16_808 VPWR VGND sg13g2_decap_8
XFILLER_28_679 VPWR VGND sg13g2_decap_8
XFILLER_35_13 VPWR VGND sg13g2_decap_8
XFILLER_35_24 VPWR VGND sg13g2_fill_1
XFILLER_43_649 VPWR VGND sg13g2_decap_8
XFILLER_42_115 VPWR VGND sg13g2_fill_1
XFILLER_24_863 VPWR VGND sg13g2_decap_4
XFILLER_7_528 VPWR VGND sg13g2_decap_8
X_5229__212 VPWR VGND net212 sg13g2_tiehi
XFILLER_3_734 VPWR VGND sg13g2_decap_8
XFILLER_2_200 VPWR VGND sg13g2_decap_4
XFILLER_2_277 VPWR VGND sg13g2_decap_8
XFILLER_47_900 VPWR VGND sg13g2_decap_8
Xfanout592 net593 net592 VPWR VGND sg13g2_buf_8
X_5125__221 VPWR VGND net221 sg13g2_tiehi
Xfanout581 net582 net581 VPWR VGND sg13g2_buf_8
Xfanout570 net571 net570 VPWR VGND sg13g2_buf_8
X_5160__101 VPWR VGND net101 sg13g2_tiehi
XFILLER_18_101 VPWR VGND sg13g2_decap_8
XFILLER_19_657 VPWR VGND sg13g2_fill_1
XFILLER_47_977 VPWR VGND sg13g2_decap_8
XFILLER_46_487 VPWR VGND sg13g2_decap_8
XFILLER_34_627 VPWR VGND sg13g2_decap_8
XFILLER_15_852 VPWR VGND sg13g2_decap_4
XFILLER_42_660 VPWR VGND sg13g2_decap_8
XFILLER_30_811 VPWR VGND sg13g2_fill_2
X_3550_ _1214_ _1201_ _1207_ VPWR VGND sg13g2_nand2b_1
X_5220_ net248 VGND VPWR _0570_ videogen.test_lut_thingy.pixel_feeder_inst.row\[43\]\[2\]
+ _0199_ sg13g2_dfrbpq_1
XFILLER_6_594 VPWR VGND sg13g2_fill_1
X_3481_ VPWR VGND _1133_ _1132_ _1130_ _1030_ _1145_ _1031_ sg13g2_a221oi_1
X_5151_ net146 VGND VPWR _0501_ videogen.test_lut_thingy.pixel_feeder_inst.row\[51\]\[1\]
+ _0138_ sg13g2_dfrbpq_1
X_4102_ _1752_ VPWR _1759_ VGND _1648_ _1650_ sg13g2_o21ai_1
X_5082_ net307 VGND VPWR _0432_ videogen.test_lut_thingy.pixel_feeder_inst.row\[6\]\[0\]
+ _0069_ sg13g2_dfrbpq_1
X_4033_ _1693_ _1689_ _1690_ _1687_ _1682_ VPWR VGND sg13g2_a22oi_1
XFILLER_49_270 VPWR VGND sg13g2_fill_1
XFILLER_37_421 VPWR VGND sg13g2_decap_8
XFILLER_37_432 VPWR VGND sg13g2_fill_1
XFILLER_25_605 VPWR VGND sg13g2_fill_2
XFILLER_18_690 VPWR VGND sg13g2_fill_1
XFILLER_25_649 VPWR VGND sg13g2_fill_1
X_4935_ net130 VGND VPWR _0289_ videogen.fancy_shader.video_x\[1\] net659 sg13g2_dfrbpq_2
X_4866_ net718 net762 _0223_ VPWR VGND sg13g2_nor2_1
X_3817_ _1477_ _1478_ _1479_ _1480_ _1481_ VPWR VGND sg13g2_nor4_1
X_4797_ net706 net750 _0154_ VPWR VGND sg13g2_nor2_1
XFILLER_21_899 VPWR VGND sg13g2_decap_4
X_3748_ _1408_ _1409_ _1410_ _1411_ _1412_ VPWR VGND sg13g2_nor4_1
X_3679_ net641 VPWR _1343_ VGND videogen.test_lut_thingy.pixel_feeder_inst.row\[44\]\[2\]
+ net596 sg13g2_o21ai_1
XFILLER_0_737 VPWR VGND sg13g2_decap_8
XFILLER_48_708 VPWR VGND sg13g2_decap_8
XFILLER_47_229 VPWR VGND sg13g2_fill_2
XFILLER_44_925 VPWR VGND sg13g2_fill_1
XFILLER_29_977 VPWR VGND sg13g2_fill_2
XFILLER_15_126 VPWR VGND sg13g2_decap_4
XFILLER_28_498 VPWR VGND sg13g2_decap_4
XFILLER_15_148 VPWR VGND sg13g2_fill_1
XFILLER_23_192 VPWR VGND sg13g2_fill_1
XFILLER_3_520 VPWR VGND sg13g2_decap_8
XFILLER_3_597 VPWR VGND sg13g2_decap_8
XFILLER_19_421 VPWR VGND sg13g2_decap_8
XFILLER_47_774 VPWR VGND sg13g2_decap_8
XFILLER_35_914 VPWR VGND sg13g2_decap_4
XFILLER_22_608 VPWR VGND sg13g2_fill_1
XFILLER_34_435 VPWR VGND sg13g2_fill_1
X_2981_ net782 videogen.test_lut_thingy.pixel_feeder_inst.row\[31\]\[3\] _0802_ _0427_
+ VPWR VGND sg13g2_mux2_1
XFILLER_14_170 VPWR VGND sg13g2_fill_2
X_4720_ net699 net743 _0077_ VPWR VGND sg13g2_nor2_1
X_4651_ net689 net733 _0010_ VPWR VGND sg13g2_nor2_1
X_3602_ net616 _1260_ _1265_ _1266_ VPWR VGND sg13g2_nor3_1
X_4582_ VPWR _2204_ _2203_ VGND sg13g2_inv_1
X_3533_ _1196_ _1185_ _1197_ VPWR VGND sg13g2_xor2_1
XFILLER_42_0 VPWR VGND sg13g2_decap_8
XFILLER_6_391 VPWR VGND sg13g2_decap_8
X_3464_ VGND VPWR _1128_ _1126_ _1121_ sg13g2_or2_1
X_5203_ net316 VGND VPWR _0553_ videogen.test_lut_thingy.pixel_feeder_inst.row\[47\]\[1\]
+ _0182_ sg13g2_dfrbpq_1
X_5134_ net203 VGND VPWR _0484_ videogen.test_lut_thingy.pixel_feeder_inst.row\[0\]\[0\]
+ _0121_ sg13g2_dfrbpq_1
X_3395_ _1059_ _1058_ VPWR VGND sg13g2_inv_2
Xclkbuf_3_2_0_clk_regs clknet_0_clk_regs clknet_3_2_0_clk_regs VPWR VGND sg13g2_buf_8
X_5065_ net341 VGND VPWR _0415_ videogen.test_lut_thingy.pixel_feeder_inst.row\[33\]\[3\]
+ _0052_ sg13g2_dfrbpq_1
X_4016_ VGND VPWR _1668_ _1674_ _1676_ _1675_ sg13g2_a21oi_1
XFILLER_25_479 VPWR VGND sg13g2_decap_8
X_4918_ net159 VGND VPWR _0272_ serialize.shift_reg_c\[3\] clknet_3_2_0_clk_regs sg13g2_dfrbpq_1
X_5039__376 VPWR VGND net376 sg13g2_tiehi
XFILLER_32_14 VPWR VGND sg13g2_decap_8
X_4849_ net715 net759 _0206_ VPWR VGND sg13g2_nor2_1
XFILLER_20_162 VPWR VGND sg13g2_decap_8
XFILLER_20_173 VPWR VGND sg13g2_fill_2
XFILLER_0_534 VPWR VGND sg13g2_decap_8
XFILLER_48_505 VPWR VGND sg13g2_decap_8
XFILLER_43_243 VPWR VGND sg13g2_decap_8
XFILLER_16_435 VPWR VGND sg13g2_fill_2
XFILLER_17_969 VPWR VGND sg13g2_fill_2
XFILLER_43_254 VPWR VGND sg13g2_fill_1
XFILLER_43_287 VPWR VGND sg13g2_decap_8
XFILLER_24_490 VPWR VGND sg13g2_decap_8
XFILLER_7_122 VPWR VGND sg13g2_decap_8
XFILLER_7_100 VPWR VGND sg13g2_fill_1
XFILLER_7_166 VPWR VGND sg13g2_decap_4
XFILLER_7_144 VPWR VGND sg13g2_decap_8
XFILLER_22_80 VPWR VGND sg13g2_fill_2
XFILLER_4_862 VPWR VGND sg13g2_decap_8
XFILLER_3_361 VPWR VGND sg13g2_decap_8
XFILLER_3_350 VPWR VGND sg13g2_decap_8
X_3180_ _0703_ VPWR _0891_ VGND net621 _0838_ sg13g2_o21ai_1
XFILLER_14_4 VPWR VGND sg13g2_fill_2
XFILLER_47_571 VPWR VGND sg13g2_decap_8
XFILLER_19_251 VPWR VGND sg13g2_fill_1
XFILLER_19_262 VPWR VGND sg13g2_fill_2
XFILLER_23_906 VPWR VGND sg13g2_decap_8
XFILLER_34_265 VPWR VGND sg13g2_fill_2
XFILLER_15_490 VPWR VGND sg13g2_fill_1
X_2964_ _0798_ _0750_ VPWR VGND _0724_ sg13g2_nand2b_2
X_4703_ net683 net727 _0060_ VPWR VGND sg13g2_nor2_1
XFILLER_31_972 VPWR VGND sg13g2_fill_2
X_2895_ videogen.test_lut_thingy.pixel_feeder_inst.row\[54\]\[0\] net811 _0781_ _0492_
+ VPWR VGND sg13g2_mux2_1
XFILLER_33_1027 VPWR VGND sg13g2_fill_2
X_4634_ _2232_ net672 net474 net678 red_tmds_par\[3\] VPWR VGND sg13g2_a22oi_1
X_4565_ _2164_ VPWR _2191_ VGND blue\[7\] _2139_ sg13g2_o21ai_1
X_3516_ VPWR VGND net557 _1059_ _1099_ _1090_ _1180_ _1091_ sg13g2_a221oi_1
X_4496_ tmds_blue.dc_balancing_reg\[0\] tmds_blue.dc_balancing_reg\[1\] tmds_blue.dc_balancing_reg\[3\]
+ _2125_ VGND VPWR tmds_blue.dc_balancing_reg\[2\] sg13g2_nor4_2
X_3447_ VGND VPWR _1058_ _1108_ _1111_ _1110_ sg13g2_a21oi_1
X_3378_ _1037_ _1038_ _1020_ _1042_ VPWR VGND sg13g2_nand3_1
X_5117_ net237 VGND VPWR _0467_ videogen.test_lut_thingy.pixel_feeder_inst.row\[7\]\[3\]
+ _0104_ sg13g2_dfrbpq_1
X_5048_ net175 VGND VPWR _0402_ videogen.test_lut_thingy.pixel_feeder_inst.row\[14\]\[3\]
+ _0048_ sg13g2_dfrbpq_1
XFILLER_26_722 VPWR VGND sg13g2_decap_8
XFILLER_14_906 VPWR VGND sg13g2_decap_8
XFILLER_26_766 VPWR VGND sg13g2_decap_8
XFILLER_13_405 VPWR VGND sg13g2_fill_2
XFILLER_25_265 VPWR VGND sg13g2_decap_8
XFILLER_25_276 VPWR VGND sg13g2_fill_1
XFILLER_43_24 VPWR VGND sg13g2_decap_8
XFILLER_4_114 VPWR VGND sg13g2_decap_4
XFILLER_1_854 VPWR VGND sg13g2_decap_8
XFILLER_49_803 VPWR VGND sg13g2_decap_8
XFILLER_0_386 VPWR VGND sg13g2_decap_8
XFILLER_44_552 VPWR VGND sg13g2_decap_8
XFILLER_31_202 VPWR VGND sg13g2_decap_8
XFILLER_9_910 VPWR VGND sg13g2_fill_1
XFILLER_13_972 VPWR VGND sg13g2_decap_8
XFILLER_9_965 VPWR VGND sg13g2_decap_8
X_2680_ _0680_ videogen.fancy_shader.video_x\[3\] videogen.fancy_shader.video_x\[2\]
+ _0698_ VPWR VGND sg13g2_nor3_1
X_4350_ net555 _1983_ _2001_ VPWR VGND sg13g2_nor2_1
X_3301_ net769 _0973_ _0975_ _0343_ VPWR VGND sg13g2_nor3_1
X_4281_ _1428_ _1738_ _1935_ VPWR VGND sg13g2_nor2_1
X_3232_ _0837_ VPWR _0927_ VGND _0903_ _0904_ sg13g2_o21ai_1
XFILLER_39_313 VPWR VGND sg13g2_fill_2
X_3163_ videogen.fancy_shader.video_x\[6\] _0831_ _0879_ VPWR VGND sg13g2_nor2_1
XFILLER_39_357 VPWR VGND sg13g2_fill_2
X_3094_ videogen.fancy_shader.video_y\[6\] videogen.fancy_shader.video_y\[4\] videogen.fancy_shader.video_y\[7\]
+ _0846_ VPWR VGND videogen.fancy_shader.video_y\[3\] sg13g2_nand4_1
XFILLER_35_530 VPWR VGND sg13g2_decap_8
X_3996_ _1642_ VPWR _1656_ VGND _1648_ _1650_ sg13g2_o21ai_1
X_2947_ net811 videogen.test_lut_thingy.pixel_feeder_inst.row\[60\]\[0\] _0793_ _0452_
+ VPWR VGND sg13g2_mux2_1
X_2878_ videogen.test_lut_thingy.pixel_feeder_inst.row\[52\]\[2\] net790 _0778_ _0506_
+ VPWR VGND sg13g2_mux2_1
X_4617_ VPWR _0648_ _2223_ VGND sg13g2_inv_1
X_4548_ _2174_ _2171_ _2175_ VPWR VGND sg13g2_xor2_1
XFILLER_2_629 VPWR VGND sg13g2_decap_8
X_4479_ VGND VPWR _0684_ _2069_ _2113_ _2071_ sg13g2_a21oi_1
XFILLER_46_806 VPWR VGND sg13g2_decap_8
XFILLER_38_390 VPWR VGND sg13g2_fill_1
XFILLER_26_541 VPWR VGND sg13g2_decap_8
XFILLER_41_599 VPWR VGND sg13g2_fill_2
XFILLER_9_217 VPWR VGND sg13g2_fill_2
XFILLER_6_946 VPWR VGND sg13g2_decap_8
XFILLER_10_986 VPWR VGND sg13g2_decap_8
XFILLER_5_423 VPWR VGND sg13g2_decap_8
XFILLER_5_478 VPWR VGND sg13g2_fill_1
XFILLER_49_600 VPWR VGND sg13g2_decap_8
XFILLER_1_651 VPWR VGND sg13g2_decap_8
XFILLER_49_677 VPWR VGND sg13g2_decap_8
XFILLER_36_316 VPWR VGND sg13g2_decap_4
XFILLER_28_90 VPWR VGND sg13g2_decap_8
XFILLER_29_390 VPWR VGND sg13g2_fill_2
XFILLER_45_850 VPWR VGND sg13g2_decap_8
XFILLER_17_585 VPWR VGND sg13g2_decap_8
X_3850_ videogen.test_lut_thingy.pixel_feeder_inst.row\[39\]\[1\] net587 _1514_ VPWR
+ VGND sg13g2_nor2_1
X_2801_ videogen.test_lut_thingy.pixel_feeder_inst.row\[19\]\[3\] net777 _0762_ _0575_
+ VPWR VGND sg13g2_mux2_1
X_3781_ _1441_ _1442_ _1443_ _1444_ _1445_ VPWR VGND sg13g2_nor4_1
X_5135__201 VPWR VGND net201 sg13g2_tiehi
XFILLER_20_739 VPWR VGND sg13g2_decap_8
X_2732_ net808 videogen.test_lut_thingy.pixel_feeder_inst.row\[24\]\[0\] _0734_ _0626_
+ VPWR VGND sg13g2_mux2_1
XFILLER_9_740 VPWR VGND sg13g2_fill_1
X_2663_ VPWR _0682_ blue\[1\] VGND sg13g2_inv_1
XFILLER_8_283 VPWR VGND sg13g2_decap_8
X_4402_ net565 _1986_ _0372_ VPWR VGND sg13g2_nor2_1
X_4333_ net555 _1982_ _1985_ VPWR VGND sg13g2_nor2b_1
X_4264_ _1919_ VPWR _1921_ VGND _1171_ _1920_ sg13g2_o21ai_1
X_5066__339 VPWR VGND net339 sg13g2_tiehi
X_3215_ _0309_ _0837_ _0914_ _0915_ VPWR VGND sg13g2_and3_1
X_4195_ _1850_ _1851_ _1852_ VPWR VGND sg13g2_nor2_2
X_3146_ _0869_ net485 net452 VPWR VGND sg13g2_nand2_1
XFILLER_39_165 VPWR VGND sg13g2_fill_2
X_5222__240 VPWR VGND net240 sg13g2_tiehi
X_3077_ _0836_ _0837_ VPWR VGND sg13g2_inv_4
XFILLER_27_338 VPWR VGND sg13g2_fill_1
XFILLER_24_15 VPWR VGND sg13g2_fill_2
X_3979_ _1082_ _1636_ _1639_ VPWR VGND sg13g2_and2_1
XFILLER_3_916 VPWR VGND sg13g2_decap_8
XFILLER_6_6 VPWR VGND sg13g2_fill_1
XFILLER_49_56 VPWR VGND sg13g2_decap_8
Xfanout741 net742 net741 VPWR VGND sg13g2_buf_8
Xfanout730 net732 net730 VPWR VGND sg13g2_buf_8
Xfanout752 net753 net752 VPWR VGND sg13g2_buf_8
Xfanout763 net767 net763 VPWR VGND sg13g2_buf_1
Xfanout774 net775 net774 VPWR VGND sg13g2_buf_1
Xfanout785 net786 net785 VPWR VGND sg13g2_buf_8
XFILLER_46_603 VPWR VGND sg13g2_decap_8
Xfanout796 net797 net796 VPWR VGND sg13g2_buf_8
XFILLER_19_817 VPWR VGND sg13g2_decap_4
X_5201__324 VPWR VGND net324 sg13g2_tiehi
XFILLER_41_341 VPWR VGND sg13g2_decap_4
XFILLER_41_396 VPWR VGND sg13g2_fill_1
X_5314__190 VPWR VGND net190 sg13g2_tiehi
XFILLER_46_7 VPWR VGND sg13g2_decap_8
XFILLER_30_91 VPWR VGND sg13g2_fill_1
XFILLER_2_993 VPWR VGND sg13g2_decap_8
XFILLER_49_474 VPWR VGND sg13g2_decap_8
XFILLER_37_614 VPWR VGND sg13g2_decap_8
X_3000_ _0724_ _0783_ _0806_ VPWR VGND sg13g2_nor2_2
XFILLER_36_113 VPWR VGND sg13g2_decap_4
XFILLER_18_872 VPWR VGND sg13g2_fill_1
XFILLER_45_691 VPWR VGND sg13g2_decap_8
X_4951_ net108 VGND VPWR _0305_ videogen.test_lut_thingy.pixel_feeder_inst.h_pix\[0\]
+ net650 sg13g2_dfrbpq_2
XFILLER_17_360 VPWR VGND sg13g2_decap_8
XFILLER_36_179 VPWR VGND sg13g2_decap_8
X_3902_ videogen.test_lut_thingy.pixel_feeder_inst.row\[27\]\[0\] net577 _1565_ VPWR
+ VGND sg13g2_nor2_1
X_4882_ net687 net731 _0239_ VPWR VGND sg13g2_nor2_1
X_3833_ _1493_ _1494_ _1495_ _1496_ _1497_ VPWR VGND sg13g2_nor4_1
X_3764_ VGND VPWR _1427_ _1428_ videogen.test_lut_thingy.gol_counter_reg\[2\] _0686_
+ sg13g2_a21oi_2
X_2715_ videogen.test_lut_thingy.pixel_feeder_inst.row\[22\]\[0\] net814 _0725_ _0634_
+ VPWR VGND sg13g2_mux2_1
X_3695_ _1355_ _1356_ _1357_ _1358_ _1359_ VPWR VGND sg13g2_nor4_1
XFILLER_10_39 VPWR VGND sg13g2_decap_8
XFILLER_0_919 VPWR VGND sg13g2_decap_8
X_5296_ net394 VGND VPWR _0646_ serialize.shift_reg_g\[0\] clknet_3_1_0_clk_regs sg13g2_dfrbpq_1
X_4316_ red\[0\] _1954_ _1968_ VPWR VGND sg13g2_nor2_1
X_4247_ VPWR VGND _1888_ _1875_ _1886_ _1877_ _1904_ _1878_ sg13g2_a221oi_1
X_4178_ _1102_ _1833_ _1098_ _1835_ VPWR VGND sg13g2_nand3_1
XFILLER_28_625 VPWR VGND sg13g2_decap_4
XFILLER_27_146 VPWR VGND sg13g2_fill_1
X_3129_ VGND VPWR net763 net481 _0261_ _0866_ sg13g2_a21oi_1
XFILLER_43_628 VPWR VGND sg13g2_decap_8
XFILLER_42_138 VPWR VGND sg13g2_fill_1
XFILLER_24_842 VPWR VGND sg13g2_decap_8
XFILLER_3_713 VPWR VGND sg13g2_decap_8
Xfanout560 _0713_ net560 VPWR VGND sg13g2_buf_8
Xfanout593 net599 net593 VPWR VGND sg13g2_buf_8
Xfanout571 _0729_ net571 VPWR VGND sg13g2_buf_8
Xfanout582 _0723_ net582 VPWR VGND sg13g2_buf_8
XFILLER_19_614 VPWR VGND sg13g2_decap_8
XFILLER_47_956 VPWR VGND sg13g2_decap_8
XFILLER_46_466 VPWR VGND sg13g2_decap_8
XFILLER_18_135 VPWR VGND sg13g2_decap_8
XFILLER_33_105 VPWR VGND sg13g2_fill_1
XFILLER_25_80 VPWR VGND sg13g2_decap_8
XFILLER_41_171 VPWR VGND sg13g2_fill_1
XFILLER_14_385 VPWR VGND sg13g2_fill_1
X_3480_ _1135_ _1143_ _1134_ _1144_ VPWR VGND sg13g2_nand3_1
X_5150_ net150 VGND VPWR _0500_ videogen.test_lut_thingy.pixel_feeder_inst.row\[51\]\[0\]
+ _0137_ sg13g2_dfrbpq_1
X_5081_ net309 VGND VPWR _0431_ videogen.test_lut_thingy.pixel_feeder_inst.row\[30\]\[3\]
+ _0068_ sg13g2_dfrbpq_1
XFILLER_2_790 VPWR VGND sg13g2_decap_8
X_4101_ _1651_ _1752_ _1649_ _1758_ VPWR VGND sg13g2_nand3_1
XFILLER_37_400 VPWR VGND sg13g2_fill_1
XFILLER_2_40 VPWR VGND sg13g2_fill_2
X_4032_ _1689_ _1690_ _1692_ VPWR VGND sg13g2_and2_1
XFILLER_49_293 VPWR VGND sg13g2_decap_8
XFILLER_2_84 VPWR VGND sg13g2_decap_8
XFILLER_2_95 VPWR VGND sg13g2_fill_1
XFILLER_38_989 VPWR VGND sg13g2_fill_1
X_4934_ net131 VGND VPWR _0288_ videogen.fancy_shader.video_x\[0\] net659 sg13g2_dfrbpq_2
XFILLER_21_812 VPWR VGND sg13g2_decap_8
XFILLER_21_823 VPWR VGND sg13g2_fill_1
XFILLER_33_672 VPWR VGND sg13g2_fill_1
X_4865_ net720 net765 _0222_ VPWR VGND sg13g2_nor2_1
X_3816_ videogen.test_lut_thingy.pixel_feeder_inst.row\[50\]\[1\] net602 _1480_ VPWR
+ VGND sg13g2_nor2_1
X_4796_ net705 net749 _0153_ VPWR VGND sg13g2_nor2_1
XFILLER_20_366 VPWR VGND sg13g2_fill_1
X_3747_ videogen.test_lut_thingy.pixel_feeder_inst.row\[13\]\[2\] net573 _1411_ VPWR
+ VGND sg13g2_nor2_1
X_3678_ net647 _1336_ _1341_ _1342_ VPWR VGND sg13g2_nor3_1
XFILLER_0_716 VPWR VGND sg13g2_decap_8
X_5279_ net218 VGND VPWR _0629_ videogen.test_lut_thingy.pixel_feeder_inst.row\[24\]\[3\]
+ _0248_ sg13g2_dfrbpq_1
XFILLER_29_945 VPWR VGND sg13g2_decap_8
XFILLER_29_989 VPWR VGND sg13g2_decap_8
XFILLER_16_617 VPWR VGND sg13g2_fill_1
XFILLER_11_311 VPWR VGND sg13g2_decap_8
XFILLER_12_823 VPWR VGND sg13g2_decap_4
XFILLER_24_683 VPWR VGND sg13g2_decap_4
XFILLER_3_510 VPWR VGND sg13g2_decap_4
XFILLER_3_576 VPWR VGND sg13g2_decap_8
XFILLER_38_208 VPWR VGND sg13g2_decap_8
XFILLER_4_1023 VPWR VGND sg13g2_decap_4
XFILLER_19_433 VPWR VGND sg13g2_fill_2
XFILLER_47_753 VPWR VGND sg13g2_decap_8
XFILLER_46_263 VPWR VGND sg13g2_decap_8
XFILLER_34_403 VPWR VGND sg13g2_decap_8
XFILLER_35_926 VPWR VGND sg13g2_fill_2
XFILLER_43_981 VPWR VGND sg13g2_fill_2
X_2980_ _0802_ net559 _0732_ VPWR VGND sg13g2_nand2_2
XFILLER_15_650 VPWR VGND sg13g2_decap_8
XFILLER_15_672 VPWR VGND sg13g2_decap_8
XFILLER_30_620 VPWR VGND sg13g2_decap_8
X_4650_ net690 net734 _0009_ VPWR VGND sg13g2_nor2_1
XFILLER_30_653 VPWR VGND sg13g2_fill_1
X_3601_ _1261_ _1262_ _1263_ _1264_ _1265_ VPWR VGND sg13g2_nor4_1
X_4581_ _2203_ _2131_ VPWR VGND _2127_ sg13g2_nand2b_2
XFILLER_7_882 VPWR VGND sg13g2_decap_8
X_3532_ _1183_ VPWR _1196_ VGND _1186_ _1188_ sg13g2_o21ai_1
X_3463_ _1121_ _1126_ _1127_ VPWR VGND sg13g2_nor2_1
X_5202_ net320 VGND VPWR _0552_ videogen.test_lut_thingy.pixel_feeder_inst.row\[47\]\[0\]
+ _0181_ sg13g2_dfrbpq_1
X_5133_ net205 VGND VPWR _0483_ videogen.test_lut_thingy.pixel_feeder_inst.row\[55\]\[3\]
+ _0120_ sg13g2_dfrbpq_1
X_3394_ _1058_ _1044_ _1056_ VPWR VGND sg13g2_xnor2_1
XFILLER_35_0 VPWR VGND sg13g2_decap_8
X_5064_ net343 VGND VPWR _0414_ videogen.test_lut_thingy.pixel_feeder_inst.row\[33\]\[2\]
+ _0051_ sg13g2_dfrbpq_1
X_4015_ _1663_ _1665_ _1675_ VPWR VGND sg13g2_nor2_1
X_5143__185 VPWR VGND net185 sg13g2_tiehi
XFILLER_25_403 VPWR VGND sg13g2_fill_2
XFILLER_25_436 VPWR VGND sg13g2_fill_2
XFILLER_41_929 VPWR VGND sg13g2_fill_1
X_4917_ net160 VGND VPWR _0271_ serialize.shift_reg_c\[2\] clknet_3_0_0_clk_regs sg13g2_dfrbpq_1
XFILLER_33_480 VPWR VGND sg13g2_decap_8
X_4848_ net717 net761 _0205_ VPWR VGND sg13g2_nor2_1
X_4779_ net702 net746 _0136_ VPWR VGND sg13g2_nor2_1
XFILLER_10_1028 VPWR VGND sg13g2_fill_1
XFILLER_0_513 VPWR VGND sg13g2_decap_8
XFILLER_29_720 VPWR VGND sg13g2_decap_8
XFILLER_29_731 VPWR VGND sg13g2_fill_1
X_5306__262 VPWR VGND net262 sg13g2_tiehi
XFILLER_17_926 VPWR VGND sg13g2_decap_8
XFILLER_28_285 VPWR VGND sg13g2_decap_8
XFILLER_8_624 VPWR VGND sg13g2_fill_2
XFILLER_8_679 VPWR VGND sg13g2_decap_4
XFILLER_8_668 VPWR VGND sg13g2_decap_4
XFILLER_4_841 VPWR VGND sg13g2_decap_8
XFILLER_21_6 VPWR VGND sg13g2_fill_1
XFILLER_26_1024 VPWR VGND sg13g2_decap_4
XFILLER_47_550 VPWR VGND sg13g2_decap_8
XFILLER_34_211 VPWR VGND sg13g2_decap_8
XFILLER_34_244 VPWR VGND sg13g2_decap_8
X_2963_ net811 videogen.test_lut_thingy.pixel_feeder_inst.row\[61\]\[0\] _0796_ _0440_
+ VPWR VGND sg13g2_mux2_1
XFILLER_34_299 VPWR VGND sg13g2_decap_8
X_4702_ net684 net728 _0059_ VPWR VGND sg13g2_nor2_1
X_2894_ videogen.test_lut_thingy.pixel_feeder_inst.row\[54\]\[1\] net801 _0781_ _0493_
+ VPWR VGND sg13g2_mux2_1
XFILLER_30_483 VPWR VGND sg13g2_decap_4
XFILLER_8_83 VPWR VGND sg13g2_decap_4
XFILLER_8_61 VPWR VGND sg13g2_decap_4
X_4633_ VPWR _0656_ _2231_ VGND sg13g2_inv_1
X_4564_ _2173_ VPWR _2190_ VGND _2171_ _2174_ sg13g2_o21ai_1
XFILLER_7_690 VPWR VGND sg13g2_fill_1
X_3515_ _1179_ _1099_ net557 VPWR VGND sg13g2_nand2_1
X_4495_ net820 _2124_ _0511_ VPWR VGND sg13g2_and2_1
X_3446_ _1059_ _1109_ _1110_ VPWR VGND sg13g2_and2_1
X_3377_ _1041_ _1037_ _1038_ VPWR VGND sg13g2_nand2_1
X_5116_ net239 VGND VPWR _0466_ videogen.test_lut_thingy.pixel_feeder_inst.row\[7\]\[2\]
+ _0103_ sg13g2_dfrbpq_1
X_5047_ net360 VGND VPWR _0401_ videogen.test_lut_thingy.pixel_feeder_inst.row\[14\]\[2\]
+ _0047_ sg13g2_dfrbpq_1
XFILLER_38_583 VPWR VGND sg13g2_fill_2
XFILLER_25_233 VPWR VGND sg13g2_decap_4
X_5076__319 VPWR VGND net319 sg13g2_tiehi
XFILLER_13_428 VPWR VGND sg13g2_decap_8
XFILLER_25_288 VPWR VGND sg13g2_fill_1
XFILLER_21_450 VPWR VGND sg13g2_decap_4
XFILLER_22_995 VPWR VGND sg13g2_fill_1
XFILLER_21_494 VPWR VGND sg13g2_decap_8
XFILLER_49_1013 VPWR VGND sg13g2_decap_8
XFILLER_1_833 VPWR VGND sg13g2_decap_8
XFILLER_49_859 VPWR VGND sg13g2_decap_8
XFILLER_1_1015 VPWR VGND sg13g2_decap_8
XFILLER_44_520 VPWR VGND sg13g2_fill_1
XFILLER_29_594 VPWR VGND sg13g2_fill_2
XFILLER_17_778 VPWR VGND sg13g2_decap_8
XFILLER_31_225 VPWR VGND sg13g2_decap_8
XFILLER_40_781 VPWR VGND sg13g2_fill_2
XFILLER_9_944 VPWR VGND sg13g2_decap_8
XFILLER_8_487 VPWR VGND sg13g2_decap_4
X_3300_ videogen.fancy_shader.video_y\[4\] _0972_ _0975_ VPWR VGND sg13g2_and2_1
X_4280_ _0362_ _1931_ _1934_ VPWR VGND sg13g2_nand2_1
X_3231_ _0917_ _0926_ _0314_ VPWR VGND sg13g2_nor2_1
X_3162_ _0831_ _0873_ _0878_ _0293_ VPWR VGND sg13g2_nor3_1
XFILLER_39_336 VPWR VGND sg13g2_decap_8
X_3093_ videogen.fancy_shader.video_y\[1\] net629 _0845_ VPWR VGND sg13g2_and2_1
XFILLER_22_203 VPWR VGND sg13g2_decap_4
XFILLER_35_597 VPWR VGND sg13g2_fill_2
X_3995_ _1655_ _1642_ _1644_ _1645_ VPWR VGND sg13g2_and3_1
XFILLER_10_409 VPWR VGND sg13g2_fill_2
X_2946_ net801 videogen.test_lut_thingy.pixel_feeder_inst.row\[60\]\[1\] _0793_ _0453_
+ VPWR VGND sg13g2_mux2_1
X_2877_ videogen.test_lut_thingy.pixel_feeder_inst.row\[52\]\[3\] net780 _0778_ _0507_
+ VPWR VGND sg13g2_mux2_1
XFILLER_30_280 VPWR VGND sg13g2_fill_1
X_4616_ _2223_ net671 net476 net677 green_tmds_par\[2\] VPWR VGND sg13g2_a22oi_1
X_4547_ _2174_ _2165_ _2172_ VPWR VGND sg13g2_xnor2_1
X_4478_ _2095_ VPWR _2112_ VGND _2090_ _2092_ sg13g2_o21ai_1
X_3429_ _1076_ _1088_ _1074_ _1093_ VPWR VGND sg13g2_nand3_1
XFILLER_39_881 VPWR VGND sg13g2_fill_1
XFILLER_18_509 VPWR VGND sg13g2_fill_2
XFILLER_26_520 VPWR VGND sg13g2_decap_8
XFILLER_26_575 VPWR VGND sg13g2_decap_4
XFILLER_41_545 VPWR VGND sg13g2_decap_8
XFILLER_41_578 VPWR VGND sg13g2_decap_8
XFILLER_22_781 VPWR VGND sg13g2_decap_8
XFILLER_6_925 VPWR VGND sg13g2_decap_8
XFILLER_10_965 VPWR VGND sg13g2_decap_8
XFILLER_1_630 VPWR VGND sg13g2_decap_8
XFILLER_49_656 VPWR VGND sg13g2_decap_8
XFILLER_0_173 VPWR VGND sg13g2_decap_8
XFILLER_44_361 VPWR VGND sg13g2_fill_1
X_2800_ _0721_ _0747_ _0762_ VPWR VGND sg13g2_nor2_2
X_3780_ videogen.test_lut_thingy.pixel_feeder_inst.row\[15\]\[1\] net583 _1444_ VPWR
+ VGND sg13g2_nor2_1
XFILLER_32_578 VPWR VGND sg13g2_fill_2
X_2731_ net798 videogen.test_lut_thingy.pixel_feeder_inst.row\[24\]\[1\] _0734_ _0627_
+ VPWR VGND sg13g2_mux2_1
XFILLER_9_796 VPWR VGND sg13g2_decap_8
X_2662_ net621 _0681_ VPWR VGND sg13g2_inv_4
X_4401_ VGND VPWR red\[0\] _2046_ _0371_ _2048_ sg13g2_a21oi_1
X_4332_ _1982_ _1983_ _1984_ VPWR VGND sg13g2_nor2b_2
X_5163__95 VPWR VGND net95 sg13g2_tiehi
XFILLER_5_84 VPWR VGND sg13g2_decap_8
X_4263_ VGND VPWR _1910_ _1914_ _1920_ _1893_ sg13g2_a21oi_1
X_3214_ _0915_ net636 _0913_ VPWR VGND sg13g2_nand2_1
X_4194_ _1839_ _1841_ _1851_ VPWR VGND sg13g2_and2_1
X_3145_ net452 net670 _0282_ VPWR VGND sg13g2_nor2b_1
XFILLER_39_199 VPWR VGND sg13g2_fill_2
X_3076_ _0836_ net818 VPWR VGND videogen.test_lut_thingy.pixel_feeder_inst.state\[0\]
+ sg13g2_nand2b_2
XFILLER_36_851 VPWR VGND sg13g2_fill_2
X_3978_ _1638_ _1105_ _1637_ VPWR VGND sg13g2_xnor2_1
X_2929_ net785 videogen.test_lut_thingy.pixel_feeder_inst.row\[7\]\[3\] _0790_ _0467_
+ VPWR VGND sg13g2_mux2_1
XFILLER_40_15 VPWR VGND sg13g2_fill_1
XFILLER_49_35 VPWR VGND sg13g2_decap_8
XFILLER_46_1027 VPWR VGND sg13g2_fill_2
XFILLER_46_1016 VPWR VGND sg13g2_decap_8
Xfanout720 net721 net720 VPWR VGND sg13g2_buf_8
Xfanout731 net732 net731 VPWR VGND sg13g2_buf_8
Xfanout742 net748 net742 VPWR VGND sg13g2_buf_8
Xfanout764 net766 net764 VPWR VGND sg13g2_buf_8
Xfanout753 net768 net753 VPWR VGND sg13g2_buf_8
Xfanout775 _0673_ net775 VPWR VGND sg13g2_buf_2
Xfanout797 ui_in[6] net797 VPWR VGND sg13g2_buf_8
Xfanout786 ui_in[7] net786 VPWR VGND sg13g2_buf_8
XFILLER_46_659 VPWR VGND sg13g2_decap_8
XFILLER_14_523 VPWR VGND sg13g2_decap_8
XFILLER_27_884 VPWR VGND sg13g2_fill_1
XFILLER_14_534 VPWR VGND sg13g2_fill_2
XFILLER_14_589 VPWR VGND sg13g2_decap_8
XFILLER_6_700 VPWR VGND sg13g2_decap_8
XFILLER_10_751 VPWR VGND sg13g2_decap_8
XFILLER_10_762 VPWR VGND sg13g2_fill_1
XFILLER_10_784 VPWR VGND sg13g2_decap_8
XFILLER_5_254 VPWR VGND sg13g2_decap_8
XFILLER_6_799 VPWR VGND sg13g2_decap_8
XFILLER_2_972 VPWR VGND sg13g2_decap_8
XFILLER_49_453 VPWR VGND sg13g2_decap_8
XFILLER_36_103 VPWR VGND sg13g2_decap_4
XFILLER_36_136 VPWR VGND sg13g2_fill_2
XFILLER_45_670 VPWR VGND sg13g2_decap_8
X_4950_ net110 VGND VPWR _0304_ videogen.test_lut_thingy.pixel_feeder_inst.v_pix\[5\]
+ net653 sg13g2_dfrbpq_1
XFILLER_33_810 VPWR VGND sg13g2_decap_8
X_5102__267 VPWR VGND net267 sg13g2_tiehi
X_3901_ videogen.test_lut_thingy.pixel_feeder_inst.row\[24\]\[0\] net588 _1564_ VPWR
+ VGND sg13g2_nor2_1
X_4881_ net705 net749 _0238_ VPWR VGND sg13g2_nor2_1
X_3832_ videogen.test_lut_thingy.pixel_feeder_inst.row\[60\]\[1\] net592 _1496_ VPWR
+ VGND sg13g2_nor2_1
XFILLER_9_560 VPWR VGND sg13g2_decap_8
X_3763_ _0686_ _1378_ _1426_ _1427_ VPWR VGND sg13g2_nor3_1
X_2714_ videogen.test_lut_thingy.pixel_feeder_inst.row\[22\]\[1\] net804 _0725_ _0635_
+ VPWR VGND sg13g2_mux2_1
X_3694_ videogen.test_lut_thingy.pixel_feeder_inst.row\[57\]\[2\] net570 _1358_ VPWR
+ VGND sg13g2_nor2_1
X_4315_ _1962_ VPWR _1967_ VGND _1940_ _1963_ sg13g2_o21ai_1
X_5295_ net402 VGND VPWR _0645_ serialize.shift_reg_b\[7\] clknet_3_2_0_clk_regs sg13g2_dfrbpq_1
X_4246_ _1891_ _1892_ _1901_ _1903_ VPWR VGND sg13g2_or3_1
X_4177_ _1834_ _1102_ _1833_ VPWR VGND sg13g2_nand2_1
X_3128_ net819 VPWR _0866_ VGND net763 net481 sg13g2_o21ai_1
XFILLER_43_607 VPWR VGND sg13g2_decap_8
XFILLER_28_659 VPWR VGND sg13g2_decap_4
X_3059_ _0821_ _0820_ VPWR VGND sg13g2_inv_2
XFILLER_13_1026 VPWR VGND sg13g2_fill_2
XFILLER_3_769 VPWR VGND sg13g2_decap_8
Xfanout572 net573 net572 VPWR VGND sg13g2_buf_8
Xfanout583 net587 net583 VPWR VGND sg13g2_buf_8
Xfanout561 _1141_ net561 VPWR VGND sg13g2_buf_8
XFILLER_47_935 VPWR VGND sg13g2_decap_8
Xfanout594 net599 net594 VPWR VGND sg13g2_buf_8
XFILLER_46_456 VPWR VGND sg13g2_fill_2
XFILLER_46_445 VPWR VGND sg13g2_decap_8
XFILLER_15_821 VPWR VGND sg13g2_decap_8
XFILLER_18_169 VPWR VGND sg13g2_fill_1
X_4999__430 VPWR VGND net430 sg13g2_tiehi
XFILLER_14_331 VPWR VGND sg13g2_decap_4
XFILLER_27_692 VPWR VGND sg13g2_fill_1
XFILLER_15_865 VPWR VGND sg13g2_decap_8
XFILLER_30_813 VPWR VGND sg13g2_fill_1
XFILLER_42_695 VPWR VGND sg13g2_decap_8
XFILLER_41_183 VPWR VGND sg13g2_decap_8
XFILLER_30_857 VPWR VGND sg13g2_fill_2
X_4956__98 VPWR VGND net98 sg13g2_tiehi
X_4971__68 VPWR VGND net68 sg13g2_tiehi
X_5080_ net311 VGND VPWR _0430_ videogen.test_lut_thingy.pixel_feeder_inst.row\[30\]\[2\]
+ _0067_ sg13g2_dfrbpq_1
X_4100_ _1753_ VPWR _1757_ VGND _1648_ _1650_ sg13g2_o21ai_1
X_4031_ _1691_ _1689_ _1690_ VPWR VGND sg13g2_nand2_1
XFILLER_38_957 VPWR VGND sg13g2_fill_2
X_4933_ net133 VGND VPWR _0287_ videogen.test_lut_thingy.pixel_feeder_inst.row\[18\]\[3\]
+ _0016_ sg13g2_dfrbpq_1
XFILLER_21_835 VPWR VGND sg13g2_decap_8
XFILLER_32_161 VPWR VGND sg13g2_fill_1
X_4864_ net718 net762 _0221_ VPWR VGND sg13g2_nor2_1
X_3815_ videogen.test_lut_thingy.pixel_feeder_inst.row\[49\]\[1\] net570 _1479_ VPWR
+ VGND sg13g2_nor2_1
XFILLER_20_334 VPWR VGND sg13g2_fill_2
X_4795_ net689 net733 _0152_ VPWR VGND sg13g2_nor2_1
X_3746_ videogen.test_lut_thingy.pixel_feeder_inst.row\[14\]\[2\] net604 _1410_ VPWR
+ VGND sg13g2_nor2_1
X_3677_ _1337_ _1338_ _1339_ _1340_ _1341_ VPWR VGND sg13g2_nor4_1
X_5278_ net226 VGND VPWR _0628_ videogen.test_lut_thingy.pixel_feeder_inst.row\[24\]\[2\]
+ _0247_ sg13g2_dfrbpq_1
X_4229_ _1883_ _1884_ _1880_ _1886_ VPWR VGND sg13g2_nand3_1
XFILLER_46_58 VPWR VGND sg13g2_decap_8
XFILLER_28_445 VPWR VGND sg13g2_fill_2
XFILLER_29_979 VPWR VGND sg13g2_fill_1
XFILLER_12_802 VPWR VGND sg13g2_decap_8
XFILLER_8_817 VPWR VGND sg13g2_decap_8
XFILLER_3_500 VPWR VGND sg13g2_fill_2
XFILLER_3_555 VPWR VGND sg13g2_decap_8
X_5049__176 VPWR VGND net176 sg13g2_tiehi
XFILLER_47_732 VPWR VGND sg13g2_decap_8
XFILLER_4_1002 VPWR VGND sg13g2_decap_8
XFILLER_34_448 VPWR VGND sg13g2_decap_8
XFILLER_34_459 VPWR VGND sg13g2_fill_2
XFILLER_42_492 VPWR VGND sg13g2_decap_8
X_3600_ videogen.test_lut_thingy.pixel_feeder_inst.row\[43\]\[3\] net581 _1264_ VPWR
+ VGND sg13g2_nor2_1
X_4580_ _2200_ _2202_ _0614_ VPWR VGND sg13g2_nor2_1
XFILLER_7_861 VPWR VGND sg13g2_decap_8
X_3531_ _1032_ _1182_ _1192_ _1193_ _1195_ VPWR VGND sg13g2_and4_1
XFILLER_6_360 VPWR VGND sg13g2_decap_8
X_3462_ VPWR VGND _1124_ _1118_ _1122_ _1096_ _1126_ _1107_ sg13g2_a221oi_1
X_5201_ net324 VGND VPWR _0551_ videogen.test_lut_thingy.pixel_feeder_inst.row\[48\]\[3\]
+ _0180_ sg13g2_dfrbpq_1
X_3393_ _1055_ _1047_ _1057_ VPWR VGND sg13g2_xor2_1
X_5132_ net207 VGND VPWR _0482_ videogen.test_lut_thingy.pixel_feeder_inst.row\[55\]\[2\]
+ _0119_ sg13g2_dfrbpq_1
Xclkbuf_1_0__f_clk clknet_0_clk clknet_1_0__leaf_clk VPWR VGND sg13g2_buf_8
X_5063_ net345 VGND VPWR _0413_ videogen.test_lut_thingy.pixel_feeder_inst.row\[33\]\[1\]
+ _0050_ sg13g2_dfrbpq_1
XFILLER_37_242 VPWR VGND sg13g2_fill_1
X_4014_ _1674_ _1638_ _1653_ VPWR VGND sg13g2_xnor2_1
XFILLER_25_448 VPWR VGND sg13g2_decap_8
XFILLER_25_459 VPWR VGND sg13g2_fill_2
X_4916_ net161 VGND VPWR _0270_ serialize.shift_reg_c\[1\] clknet_3_0_0_clk_regs sg13g2_dfrbpq_1
X_4847_ net686 net730 _0204_ VPWR VGND sg13g2_nor2_1
XFILLER_21_687 VPWR VGND sg13g2_decap_4
X_4778_ net702 net746 _0135_ VPWR VGND sg13g2_nor2_1
XFILLER_10_1007 VPWR VGND sg13g2_decap_8
X_3729_ videogen.test_lut_thingy.pixel_feeder_inst.row\[27\]\[2\] net577 _1393_ VPWR
+ VGND sg13g2_nor2_1
XFILLER_0_569 VPWR VGND sg13g2_decap_8
XFILLER_28_253 VPWR VGND sg13g2_fill_2
XFILLER_29_798 VPWR VGND sg13g2_fill_2
XFILLER_16_437 VPWR VGND sg13g2_fill_1
XFILLER_17_949 VPWR VGND sg13g2_decap_8
XFILLER_32_908 VPWR VGND sg13g2_fill_1
X_4996__433 VPWR VGND net433 sg13g2_tiehi
XFILLER_11_164 VPWR VGND sg13g2_fill_1
XFILLER_12_665 VPWR VGND sg13g2_decap_4
XFILLER_4_820 VPWR VGND sg13g2_decap_8
XFILLER_22_93 VPWR VGND sg13g2_decap_8
XFILLER_4_897 VPWR VGND sg13g2_decap_8
XFILLER_26_1014 VPWR VGND sg13g2_fill_1
XFILLER_39_529 VPWR VGND sg13g2_fill_2
XFILLER_39_518 VPWR VGND sg13g2_fill_1
XFILLER_14_6 VPWR VGND sg13g2_fill_1
XFILLER_19_264 VPWR VGND sg13g2_fill_1
XFILLER_35_735 VPWR VGND sg13g2_fill_2
XFILLER_22_418 VPWR VGND sg13g2_decap_4
X_2962_ net801 videogen.test_lut_thingy.pixel_feeder_inst.row\[61\]\[1\] _0796_ _0441_
+ VPWR VGND sg13g2_mux2_1
X_4701_ net683 net727 _0058_ VPWR VGND sg13g2_nor2_1
X_2893_ videogen.test_lut_thingy.pixel_feeder_inst.row\[54\]\[2\] net790 _0781_ _0494_
+ VPWR VGND sg13g2_mux2_1
X_4632_ _2231_ net671 net457 net677 red_tmds_par\[2\] VPWR VGND sg13g2_a22oi_1
XFILLER_31_974 VPWR VGND sg13g2_fill_1
X_4563_ _2188_ VPWR _2189_ VGND _2169_ _2178_ sg13g2_o21ai_1
X_3514_ _1092_ _1093_ _1058_ _1178_ VPWR VGND sg13g2_nand3_1
X_4494_ _2053_ _2058_ net628 _2124_ VPWR VGND sg13g2_nand3_1
X_3445_ _1095_ _1096_ _1107_ _1109_ VPWR VGND sg13g2_mux2_1
X_3376_ VPWR _1040_ _1039_ VGND sg13g2_inv_1
X_5115_ net241 VGND VPWR _0465_ videogen.test_lut_thingy.pixel_feeder_inst.row\[7\]\[1\]
+ _0102_ sg13g2_dfrbpq_1
XFILLER_38_540 VPWR VGND sg13g2_fill_1
X_5046_ net362 VGND VPWR _0400_ videogen.test_lut_thingy.pixel_feeder_inst.row\[14\]\[1\]
+ _0046_ sg13g2_dfrbpq_1
XFILLER_13_407 VPWR VGND sg13g2_fill_1
XFILLER_22_930 VPWR VGND sg13g2_fill_2
XFILLER_40_237 VPWR VGND sg13g2_decap_8
XFILLER_5_606 VPWR VGND sg13g2_fill_2
X_5176__49 VPWR VGND net49 sg13g2_tiehi
XFILLER_4_127 VPWR VGND sg13g2_decap_8
XFILLER_1_812 VPWR VGND sg13g2_decap_8
XFILLER_49_838 VPWR VGND sg13g2_decap_8
X_4946__118 VPWR VGND net118 sg13g2_tiehi
XFILLER_1_889 VPWR VGND sg13g2_decap_8
X_5204__312 VPWR VGND net312 sg13g2_tiehi
XFILLER_44_510 VPWR VGND sg13g2_fill_2
XFILLER_16_234 VPWR VGND sg13g2_fill_2
XFILLER_17_82 VPWR VGND sg13g2_fill_2
XFILLER_32_716 VPWR VGND sg13g2_fill_1
XFILLER_44_587 VPWR VGND sg13g2_decap_8
XFILLER_32_727 VPWR VGND sg13g2_decap_8
XFILLER_32_738 VPWR VGND sg13g2_fill_2
XFILLER_9_901 VPWR VGND sg13g2_decap_8
XFILLER_25_790 VPWR VGND sg13g2_fill_1
XFILLER_9_923 VPWR VGND sg13g2_decap_8
XFILLER_8_455 VPWR VGND sg13g2_decap_4
XFILLER_4_694 VPWR VGND sg13g2_decap_8
X_3230_ VGND VPWR videogen.test_lut_thingy.pixel_feeder_inst.v_counter\[2\] _0923_
+ _0926_ videogen.test_lut_thingy.pixel_feeder_inst.v_counter\[3\] sg13g2_a21oi_1
X_3161_ videogen.fancy_shader.video_x\[5\] _0830_ _0878_ VPWR VGND sg13g2_nor2_1
X_3092_ videogen.fancy_shader.video_y\[3\] videogen.fancy_shader.video_y\[2\] _0844_
+ VPWR VGND sg13g2_and2_1
XFILLER_47_392 VPWR VGND sg13g2_fill_1
X_5245__75 VPWR VGND net75 sg13g2_tiehi
XFILLER_35_576 VPWR VGND sg13g2_decap_8
X_3994_ _1654_ _1641_ _1652_ VPWR VGND sg13g2_nand2_1
XFILLER_22_248 VPWR VGND sg13g2_fill_1
XFILLER_22_259 VPWR VGND sg13g2_decap_4
X_2945_ net790 videogen.test_lut_thingy.pixel_feeder_inst.row\[60\]\[2\] _0793_ _0454_
+ VPWR VGND sg13g2_mux2_1
X_2876_ _0745_ _0764_ _0778_ VPWR VGND sg13g2_nor2_2
XFILLER_30_270 VPWR VGND sg13g2_decap_4
X_4615_ VPWR _0647_ _2222_ VGND sg13g2_inv_1
X_4546_ _2173_ _2165_ _2172_ VPWR VGND sg13g2_nand2_1
XFILLER_2_609 VPWR VGND sg13g2_fill_2
X_5112__247 VPWR VGND net247 sg13g2_tiehi
X_4477_ VGND VPWR _2110_ _2111_ _0410_ net565 sg13g2_a21oi_1
X_3428_ _1089_ VPWR _1092_ VGND _1073_ _1075_ sg13g2_o21ai_1
X_3359_ videogen.fancy_shader.video_y\[3\] videogen.fancy_shader.shader_counter_reg\[3\]
+ _1023_ VPWR VGND sg13g2_and2_1
X_5029_ net393 VGND VPWR _0383_ videogen.test_lut_thingy.pixel_feeder_inst.row\[12\]\[3\]
+ _0032_ sg13g2_dfrbpq_1
XFILLER_13_237 VPWR VGND sg13g2_decap_8
XFILLER_16_1002 VPWR VGND sg13g2_decap_4
XFILLER_9_219 VPWR VGND sg13g2_fill_1
XFILLER_10_944 VPWR VGND sg13g2_decap_8
XFILLER_6_904 VPWR VGND sg13g2_decap_8
XFILLER_1_686 VPWR VGND sg13g2_decap_8
XFILLER_49_635 VPWR VGND sg13g2_decap_8
XFILLER_23_1028 VPWR VGND sg13g2_fill_1
XFILLER_45_885 VPWR VGND sg13g2_decap_8
XFILLER_44_373 VPWR VGND sg13g2_decap_8
XFILLER_32_524 VPWR VGND sg13g2_fill_2
XFILLER_13_760 VPWR VGND sg13g2_decap_8
X_2730_ net787 videogen.test_lut_thingy.pixel_feeder_inst.row\[24\]\[2\] _0734_ _0628_
+ VPWR VGND sg13g2_mux2_1
XFILLER_9_731 VPWR VGND sg13g2_decap_8
XFILLER_8_263 VPWR VGND sg13g2_fill_2
XFILLER_9_764 VPWR VGND sg13g2_fill_2
XFILLER_9_775 VPWR VGND sg13g2_decap_8
X_2661_ VPWR _0680_ net649 VGND sg13g2_inv_1
X_4400_ _0960_ VPWR _2048_ VGND red\[0\] _2046_ sg13g2_o21ai_1
XFILLER_5_992 VPWR VGND sg13g2_decap_8
XFILLER_5_41 VPWR VGND sg13g2_fill_2
X_4331_ VGND VPWR _1979_ _1983_ _1980_ _0691_ sg13g2_a21oi_2
X_4262_ _1919_ _1912_ _1915_ VPWR VGND sg13g2_xnor2_1
X_3213_ VGND VPWR _0914_ _0913_ net636 sg13g2_or2_1
X_4193_ VPWR VGND _1847_ _1841_ _1843_ _1837_ _1850_ _1838_ sg13g2_a221oi_1
X_3144_ net453 net670 _0273_ VPWR VGND sg13g2_and2_1
XFILLER_39_156 VPWR VGND sg13g2_decap_4
XFILLER_10_0 VPWR VGND sg13g2_fill_2
X_3075_ VGND VPWR _0681_ _0835_ _0003_ net769 sg13g2_a21oi_1
XFILLER_35_362 VPWR VGND sg13g2_decap_8
X_3977_ _1637_ _1056_ _1636_ VPWR VGND sg13g2_nand2_1
XFILLER_23_579 VPWR VGND sg13g2_fill_2
XFILLER_10_229 VPWR VGND sg13g2_decap_4
X_2928_ _0790_ net559 _0754_ VPWR VGND sg13g2_nand2_2
XFILLER_40_27 VPWR VGND sg13g2_decap_8
X_2859_ videogen.test_lut_thingy.pixel_feeder_inst.row\[27\]\[1\] net798 _0774_ _0529_
+ VPWR VGND sg13g2_mux2_1
X_4529_ _2157_ net625 _2154_ VPWR VGND sg13g2_nand2_1
XFILLER_49_14 VPWR VGND sg13g2_decap_8
Xfanout721 net722 net721 VPWR VGND sg13g2_buf_8
Xfanout710 net711 net710 VPWR VGND sg13g2_buf_8
Xfanout732 net735 net732 VPWR VGND sg13g2_buf_8
Xfanout765 net766 net765 VPWR VGND sg13g2_buf_8
Xfanout754 net755 net754 VPWR VGND sg13g2_buf_8
Xfanout776 net781 net776 VPWR VGND sg13g2_buf_8
Xfanout743 net748 net743 VPWR VGND sg13g2_buf_8
Xfanout787 net791 net787 VPWR VGND sg13g2_buf_8
Xfanout798 net802 net798 VPWR VGND sg13g2_buf_8
XFILLER_46_638 VPWR VGND sg13g2_decap_8
XFILLER_39_690 VPWR VGND sg13g2_decap_8
XFILLER_45_159 VPWR VGND sg13g2_decap_8
XFILLER_26_340 VPWR VGND sg13g2_fill_2
XFILLER_27_852 VPWR VGND sg13g2_fill_1
XFILLER_27_896 VPWR VGND sg13g2_fill_2
X_4968__74 VPWR VGND net74 sg13g2_tiehi
XFILLER_41_387 VPWR VGND sg13g2_decap_8
X_4983__44 VPWR VGND net44 sg13g2_tiehi
XFILLER_6_778 VPWR VGND sg13g2_decap_8
XFILLER_5_233 VPWR VGND sg13g2_decap_4
XFILLER_30_82 VPWR VGND sg13g2_decap_4
XFILLER_2_951 VPWR VGND sg13g2_decap_8
XFILLER_1_461 VPWR VGND sg13g2_fill_1
XFILLER_49_432 VPWR VGND sg13g2_decap_8
X_5065__341 VPWR VGND net341 sg13g2_tiehi
XFILLER_7_1022 VPWR VGND sg13g2_decap_8
XFILLER_37_649 VPWR VGND sg13g2_decap_8
X_4880_ net706 net750 _0237_ VPWR VGND sg13g2_nor2_1
X_3900_ net610 VPWR _1563_ VGND videogen.test_lut_thingy.pixel_feeder_inst.row\[26\]\[0\]
+ net600 sg13g2_o21ai_1
XFILLER_32_321 VPWR VGND sg13g2_fill_2
X_5256__371 VPWR VGND net371 sg13g2_tiehi
XFILLER_20_505 VPWR VGND sg13g2_fill_1
X_3831_ videogen.test_lut_thingy.pixel_feeder_inst.row\[63\]\[1\] net579 _1495_ VPWR
+ VGND sg13g2_nor2_1
XFILLER_33_888 VPWR VGND sg13g2_fill_2
X_3762_ net635 _1402_ _1425_ _1426_ VPWR VGND sg13g2_nor3_1
X_2713_ videogen.test_lut_thingy.pixel_feeder_inst.row\[22\]\[2\] net793 _0725_ _0636_
+ VPWR VGND sg13g2_mux2_1
X_3693_ videogen.test_lut_thingy.pixel_feeder_inst.row\[56\]\[2\] net591 _1357_ VPWR
+ VGND sg13g2_nor2_1
X_4314_ _1964_ tmds_red.dc_balancing_reg\[1\] _1966_ VPWR VGND sg13g2_xor2_1
X_5294_ net437 VGND VPWR _0644_ serialize.shift_reg_b\[6\] clknet_3_0_0_clk_regs sg13g2_dfrbpq_1
X_4245_ _1893_ _1901_ _1902_ VPWR VGND sg13g2_nor2_1
X_4176_ _1057_ _1114_ _1831_ _1833_ VPWR VGND sg13g2_nor3_1
X_3127_ _0834_ _0839_ _0000_ VPWR VGND sg13g2_nor2_1
XFILLER_27_137 VPWR VGND sg13g2_decap_8
X_3058_ videogen.fancy_shader.video_y\[9\] _0693_ _0817_ _0820_ VGND VPWR _0819_ sg13g2_nor4_2
XFILLER_23_332 VPWR VGND sg13g2_decap_8
XFILLER_23_365 VPWR VGND sg13g2_fill_1
XFILLER_11_516 VPWR VGND sg13g2_decap_8
XFILLER_11_549 VPWR VGND sg13g2_fill_2
XFILLER_3_748 VPWR VGND sg13g2_decap_8
XFILLER_2_247 VPWR VGND sg13g2_fill_2
XFILLER_47_914 VPWR VGND sg13g2_decap_8
Xfanout584 net587 net584 VPWR VGND sg13g2_buf_1
Xfanout573 net576 net573 VPWR VGND sg13g2_buf_8
Xfanout562 _0704_ net562 VPWR VGND sg13g2_buf_8
XFILLER_46_424 VPWR VGND sg13g2_decap_8
Xfanout595 net599 net595 VPWR VGND sg13g2_buf_1
XFILLER_34_608 VPWR VGND sg13g2_fill_1
XFILLER_42_674 VPWR VGND sg13g2_decap_8
XFILLER_41_140 VPWR VGND sg13g2_decap_8
XFILLER_15_877 VPWR VGND sg13g2_decap_4
XFILLER_30_869 VPWR VGND sg13g2_fill_1
XFILLER_41_92 VPWR VGND sg13g2_fill_2
X_4030_ _1669_ _1672_ _1681_ _1690_ VPWR VGND sg13g2_or3_1
X_4932_ net135 VGND VPWR _0286_ videogen.test_lut_thingy.pixel_feeder_inst.row\[18\]\[2\]
+ _0015_ sg13g2_dfrbpq_1
X_4863_ net699 net743 _0220_ VPWR VGND sg13g2_nor2_1
XFILLER_32_173 VPWR VGND sg13g2_decap_8
XFILLER_33_685 VPWR VGND sg13g2_fill_2
X_3814_ videogen.test_lut_thingy.pixel_feeder_inst.row\[48\]\[1\] net591 _1478_ VPWR
+ VGND sg13g2_nor2_1
X_4794_ net707 net751 _0151_ VPWR VGND sg13g2_nor2_1
X_3745_ videogen.test_lut_thingy.pixel_feeder_inst.row\[12\]\[2\] net594 _1409_ VPWR
+ VGND sg13g2_nor2_1
X_3676_ videogen.test_lut_thingy.pixel_feeder_inst.row\[33\]\[2\] net574 _1340_ VPWR
+ VGND sg13g2_nor2_1
X_5277_ net234 VGND VPWR _0627_ videogen.test_lut_thingy.pixel_feeder_inst.row\[24\]\[1\]
+ _0246_ sg13g2_dfrbpq_1
X_4228_ _1885_ _1883_ _1884_ VPWR VGND sg13g2_nand2_1
X_4159_ _1816_ _1792_ _1802_ VPWR VGND sg13g2_xnor2_1
XFILLER_29_958 VPWR VGND sg13g2_decap_8
XFILLER_43_416 VPWR VGND sg13g2_decap_4
XFILLER_23_140 VPWR VGND sg13g2_fill_2
XFILLER_12_858 VPWR VGND sg13g2_decap_8
XFILLER_12_869 VPWR VGND sg13g2_fill_1
XFILLER_7_328 VPWR VGND sg13g2_fill_1
XFILLER_7_317 VPWR VGND sg13g2_decap_8
XFILLER_3_534 VPWR VGND sg13g2_decap_8
XFILLER_47_711 VPWR VGND sg13g2_decap_8
XFILLER_47_788 VPWR VGND sg13g2_decap_8
XFILLER_28_991 VPWR VGND sg13g2_fill_1
XFILLER_36_70 VPWR VGND sg13g2_decap_4
XFILLER_30_644 VPWR VGND sg13g2_decap_8
XFILLER_11_880 VPWR VGND sg13g2_fill_2
X_3530_ _1192_ _1193_ _1194_ VPWR VGND sg13g2_and2_1
X_3461_ _1125_ _1122_ _1124_ _1107_ _1096_ VPWR VGND sg13g2_a22oi_1
X_5200_ net328 VGND VPWR _0550_ videogen.test_lut_thingy.pixel_feeder_inst.row\[48\]\[2\]
+ _0179_ sg13g2_dfrbpq_1
X_3392_ _1056_ _1047_ _1055_ VPWR VGND sg13g2_xnor2_1
X_5131_ net209 VGND VPWR _0481_ videogen.test_lut_thingy.pixel_feeder_inst.row\[55\]\[1\]
+ _0118_ sg13g2_dfrbpq_1
X_5062_ net347 VGND VPWR _0412_ videogen.test_lut_thingy.pixel_feeder_inst.row\[33\]\[0\]
+ _0049_ sg13g2_dfrbpq_1
X_4013_ _1635_ _1657_ _1667_ _1670_ _1673_ VPWR VGND sg13g2_or4_1
XFILLER_37_221 VPWR VGND sg13g2_fill_1
XFILLER_26_906 VPWR VGND sg13g2_decap_8
XFILLER_25_405 VPWR VGND sg13g2_fill_1
XFILLER_26_928 VPWR VGND sg13g2_decap_8
X_5301__342 VPWR VGND net342 sg13g2_tiehi
XFILLER_19_991 VPWR VGND sg13g2_decap_4
XFILLER_34_950 VPWR VGND sg13g2_fill_2
X_4915_ net162 VGND VPWR _0269_ serialize.shift_reg_c\[0\] clknet_3_3_0_clk_regs sg13g2_dfrbpq_1
XFILLER_34_983 VPWR VGND sg13g2_fill_2
X_4846_ net687 net731 _0203_ VPWR VGND sg13g2_nor2_1
XFILLER_21_655 VPWR VGND sg13g2_decap_4
X_4777_ net701 net745 _0134_ VPWR VGND sg13g2_nor2_1
XFILLER_20_198 VPWR VGND sg13g2_fill_2
X_3728_ videogen.test_lut_thingy.pixel_feeder_inst.row\[24\]\[2\] net588 _1392_ VPWR
+ VGND sg13g2_nor2_1
X_3659_ videogen.test_lut_thingy.pixel_feeder_inst.row\[20\]\[3\] net595 _1323_ VPWR
+ VGND sg13g2_nor2_1
XFILLER_0_548 VPWR VGND sg13g2_decap_8
XFILLER_48_519 VPWR VGND sg13g2_decap_8
XFILLER_28_221 VPWR VGND sg13g2_decap_4
XFILLER_16_405 VPWR VGND sg13g2_decap_8
XFILLER_29_766 VPWR VGND sg13g2_decap_8
X_5122__227 VPWR VGND net227 sg13g2_tiehi
XFILLER_16_416 VPWR VGND sg13g2_fill_1
XFILLER_12_622 VPWR VGND sg13g2_decap_8
XFILLER_8_637 VPWR VGND sg13g2_decap_4
XFILLER_22_50 VPWR VGND sg13g2_decap_8
XFILLER_4_876 VPWR VGND sg13g2_decap_8
XFILLER_35_714 VPWR VGND sg13g2_fill_2
XFILLER_47_585 VPWR VGND sg13g2_decap_8
X_2961_ VGND VPWR _0670_ _0796_ _0442_ _0797_ sg13g2_a21oi_1
X_4700_ net683 net727 _0057_ VPWR VGND sg13g2_nor2_1
XFILLER_31_942 VPWR VGND sg13g2_decap_8
X_2892_ videogen.test_lut_thingy.pixel_feeder_inst.row\[54\]\[3\] net780 _0781_ _0495_
+ VPWR VGND sg13g2_mux2_1
X_4631_ VPWR _0655_ _2230_ VGND sg13g2_inv_1
X_4562_ _2188_ _2185_ _2187_ VPWR VGND sg13g2_xnor2_1
XFILLER_6_180 VPWR VGND sg13g2_fill_2
X_4493_ VGND VPWR green\[0\] net628 _0510_ net774 sg13g2_a21oi_1
X_3513_ _1173_ VPWR _1177_ VGND _1166_ _1176_ sg13g2_o21ai_1
X_3444_ VGND VPWR _1108_ _1107_ _1094_ sg13g2_or2_1
XFILLER_40_0 VPWR VGND sg13g2_decap_8
X_3375_ _1038_ VPWR _1039_ VGND _1018_ _1036_ sg13g2_o21ai_1
X_5114_ net243 VGND VPWR _0464_ videogen.test_lut_thingy.pixel_feeder_inst.row\[7\]\[0\]
+ _0101_ sg13g2_dfrbpq_1
X_5045_ net364 VGND VPWR _0399_ videogen.test_lut_thingy.pixel_feeder_inst.row\[14\]\[0\]
+ _0045_ sg13g2_dfrbpq_1
XFILLER_38_552 VPWR VGND sg13g2_decap_8
X_5248__51 VPWR VGND net51 sg13g2_tiehi
XFILLER_38_585 VPWR VGND sg13g2_fill_1
XFILLER_26_736 VPWR VGND sg13g2_fill_2
XFILLER_43_38 VPWR VGND sg13g2_decap_4
X_5232__200 VPWR VGND net200 sg13g2_tiehi
X_4939__126 VPWR VGND net126 sg13g2_tiehi
X_4829_ net714 net758 _0186_ VPWR VGND sg13g2_nor2_1
XFILLER_1_868 VPWR VGND sg13g2_decap_8
XFILLER_49_817 VPWR VGND sg13g2_decap_8
XFILLER_16_213 VPWR VGND sg13g2_decap_8
XFILLER_44_566 VPWR VGND sg13g2_decap_8
X_5157__109 VPWR VGND net109 sg13g2_tiehi
XFILLER_16_268 VPWR VGND sg13g2_fill_2
XFILLER_31_216 VPWR VGND sg13g2_decap_4
XFILLER_13_953 VPWR VGND sg13g2_decap_8
XFILLER_9_979 VPWR VGND sg13g2_decap_8
Xclkbuf_3_1_0_clk_regs clknet_0_clk_regs clknet_3_1_0_clk_regs VPWR VGND sg13g2_buf_8
XFILLER_4_673 VPWR VGND sg13g2_decap_8
XFILLER_3_161 VPWR VGND sg13g2_decap_8
X_5283__186 VPWR VGND net186 sg13g2_tiehi
X_3160_ _0830_ _0877_ _0292_ VPWR VGND sg13g2_nor2_1
XFILLER_12_4 VPWR VGND sg13g2_decap_4
X_3091_ VGND VPWR _0681_ net15 _0716_ _0701_ sg13g2_a21oi_2
Xhold1 clockdiv.q2 VPWR VGND net446 sg13g2_dlygate4sd3_1
XFILLER_48_883 VPWR VGND sg13g2_decap_8
XFILLER_35_544 VPWR VGND sg13g2_decap_8
X_5075__321 VPWR VGND net321 sg13g2_tiehi
X_3993_ VPWR VGND _1645_ _1642_ _1644_ _1638_ _1653_ _1640_ sg13g2_a221oi_1
XFILLER_16_780 VPWR VGND sg13g2_decap_8
X_2944_ net778 videogen.test_lut_thingy.pixel_feeder_inst.row\[60\]\[3\] _0793_ _0455_
+ VPWR VGND sg13g2_mux2_1
X_2875_ videogen.test_lut_thingy.pixel_feeder_inst.row\[36\]\[0\] net815 _0777_ _0516_
+ VPWR VGND sg13g2_mux2_1
X_4614_ _2222_ net671 net471 net677 green_tmds_par\[1\] VPWR VGND sg13g2_a22oi_1
X_4545_ _2143_ VPWR _2172_ VGND _0682_ _2142_ sg13g2_o21ai_1
X_4476_ _2052_ _2099_ _2111_ VPWR VGND sg13g2_nor2_1
X_3427_ _1088_ VPWR _1091_ VGND _1073_ _1075_ sg13g2_o21ai_1
X_3358_ VGND VPWR _1022_ videogen.fancy_shader.shader_counter_reg\[3\] videogen.fancy_shader.video_y\[3\]
+ sg13g2_or2_1
X_3289_ videogen.fancy_shader.video_y\[7\] videogen.fancy_shader.video_y\[6\] videogen.fancy_shader.video_y\[5\]
+ videogen.fancy_shader.video_y\[4\] _0966_ VPWR VGND sg13g2_nor4_1
X_5028_ net395 VGND VPWR _0382_ videogen.test_lut_thingy.pixel_feeder_inst.row\[12\]\[2\]
+ _0031_ sg13g2_dfrbpq_1
XFILLER_26_500 VPWR VGND sg13g2_fill_1
XFILLER_14_706 VPWR VGND sg13g2_decap_4
XFILLER_26_555 VPWR VGND sg13g2_decap_8
XFILLER_14_739 VPWR VGND sg13g2_fill_1
XFILLER_10_901 VPWR VGND sg13g2_fill_1
XFILLER_5_404 VPWR VGND sg13g2_fill_2
XFILLER_21_293 VPWR VGND sg13g2_decap_8
XFILLER_0_120 VPWR VGND sg13g2_decap_8
XFILLER_49_614 VPWR VGND sg13g2_decap_8
XFILLER_0_131 VPWR VGND sg13g2_fill_1
XFILLER_1_665 VPWR VGND sg13g2_decap_8
XFILLER_48_113 VPWR VGND sg13g2_decap_4
XFILLER_45_864 VPWR VGND sg13g2_decap_8
XFILLER_44_341 VPWR VGND sg13g2_fill_1
XFILLER_17_599 VPWR VGND sg13g2_fill_2
XFILLER_44_92 VPWR VGND sg13g2_fill_2
X_5252__406 VPWR VGND net406 sg13g2_tiehi
XFILLER_8_220 VPWR VGND sg13g2_decap_4
X_2660_ VPWR _0679_ videogen.test_lut_thingy.pixel_feeder_inst.v_pix\[1\] VGND sg13g2_inv_1
XFILLER_8_297 VPWR VGND sg13g2_decap_4
XFILLER_5_971 VPWR VGND sg13g2_decap_8
X_4330_ _1974_ tmds_red.dc_balancing_reg\[4\] _1981_ _1982_ VPWR VGND sg13g2_a21o_2
X_4261_ _1172_ VPWR _1918_ VGND _1826_ _1917_ sg13g2_o21ai_1
X_3212_ _0836_ _0912_ _0913_ _0308_ VPWR VGND sg13g2_nor3_1
XFILLER_39_113 VPWR VGND sg13g2_decap_8
X_4192_ _1849_ _1848_ _1845_ VPWR VGND sg13g2_nand2b_1
X_3143_ net451 net673 _0272_ VPWR VGND sg13g2_and2_1
XFILLER_48_680 VPWR VGND sg13g2_decap_8
X_3074_ net769 _0821_ _0354_ VPWR VGND sg13g2_nor2_2
XFILLER_36_875 VPWR VGND sg13g2_fill_1
X_3976_ _1053_ _1634_ _1636_ VPWR VGND sg13g2_and2_1
X_2927_ net810 videogen.test_lut_thingy.pixel_feeder_inst.row\[58\]\[0\] _0789_ _0468_
+ VPWR VGND sg13g2_mux2_1
X_4936__129 VPWR VGND net129 sg13g2_tiehi
X_2858_ videogen.test_lut_thingy.pixel_feeder_inst.row\[27\]\[2\] net788 _0774_ _0530_
+ VPWR VGND sg13g2_mux2_1
X_2789_ net607 net558 _0757_ _0759_ VPWR VGND sg13g2_nor3_2
X_4528_ VGND VPWR net624 _2134_ _2156_ _2155_ sg13g2_a21oi_1
Xfanout700 net704 net700 VPWR VGND sg13g2_buf_2
X_4459_ _2082_ VPWR _2094_ VGND _2066_ _2081_ sg13g2_o21ai_1
Xfanout711 net712 net711 VPWR VGND sg13g2_buf_8
Xfanout733 net735 net733 VPWR VGND sg13g2_buf_8
Xfanout722 net723 net722 VPWR VGND sg13g2_buf_2
Xfanout766 net767 net766 VPWR VGND sg13g2_buf_8
Xfanout755 net756 net755 VPWR VGND sg13g2_buf_8
Xfanout744 net748 net744 VPWR VGND sg13g2_buf_1
XFILLER_46_617 VPWR VGND sg13g2_decap_8
Xfanout788 net791 net788 VPWR VGND sg13g2_buf_1
Xfanout777 net781 net777 VPWR VGND sg13g2_buf_8
Xfanout799 net802 net799 VPWR VGND sg13g2_buf_8
XFILLER_27_831 VPWR VGND sg13g2_decap_8
XFILLER_27_864 VPWR VGND sg13g2_decap_8
XFILLER_42_845 VPWR VGND sg13g2_fill_2
XFILLER_41_311 VPWR VGND sg13g2_fill_1
XFILLER_41_300 VPWR VGND sg13g2_decap_4
XFILLER_26_385 VPWR VGND sg13g2_decap_8
XFILLER_14_62 VPWR VGND sg13g2_decap_8
XFILLER_14_73 VPWR VGND sg13g2_fill_2
XFILLER_10_775 VPWR VGND sg13g2_decap_4
XFILLER_30_50 VPWR VGND sg13g2_fill_1
XFILLER_5_289 VPWR VGND sg13g2_fill_2
XFILLER_2_930 VPWR VGND sg13g2_decap_8
XFILLER_7_1001 VPWR VGND sg13g2_decap_8
XFILLER_49_411 VPWR VGND sg13g2_decap_8
XFILLER_49_488 VPWR VGND sg13g2_decap_8
XFILLER_37_628 VPWR VGND sg13g2_decap_8
XFILLER_44_182 VPWR VGND sg13g2_decap_4
X_3830_ videogen.test_lut_thingy.pixel_feeder_inst.row\[61\]\[1\] net569 _1494_ VPWR
+ VGND sg13g2_nor2_1
XFILLER_32_344 VPWR VGND sg13g2_decap_8
X_3761_ net636 _1413_ _1424_ _1425_ VPWR VGND sg13g2_nor3_1
X_2712_ videogen.test_lut_thingy.pixel_feeder_inst.row\[22\]\[3\] net783 _0725_ _0637_
+ VPWR VGND sg13g2_mux2_1
X_3692_ videogen.test_lut_thingy.pixel_feeder_inst.row\[59\]\[2\] net579 _1356_ VPWR
+ VGND sg13g2_nor2_1
X_4313_ _1965_ tmds_red.dc_balancing_reg\[1\] _1964_ VPWR VGND sg13g2_nand2_1
X_5293_ net31 VGND VPWR _0643_ serialize.shift_reg_b\[5\] clknet_3_2_0_clk_regs sg13g2_dfrbpq_1
X_5263__310 VPWR VGND net310 sg13g2_tiehi
X_4244_ _1901_ _1874_ _1900_ VPWR VGND sg13g2_nand2_1
X_4175_ _1114_ _1831_ _1832_ VPWR VGND sg13g2_nor2_1
X_3126_ net818 videogen.test_lut_thingy.pixel_feeder_inst.state\[1\] _0821_ _0834_
+ _0001_ VPWR VGND sg13g2_and4_1
XFILLER_42_108 VPWR VGND sg13g2_decap_8
X_3057_ videogen.fancy_shader.video_x\[8\] videogen.fancy_shader.video_x\[9\] _0819_
+ VPWR VGND sg13g2_and2_1
XFILLER_36_672 VPWR VGND sg13g2_decap_8
XFILLER_24_856 VPWR VGND sg13g2_decap_8
X_3959_ _1621_ net635 _1622_ VPWR VGND sg13g2_nor2b_1
XFILLER_13_1028 VPWR VGND sg13g2_fill_1
XFILLER_3_727 VPWR VGND sg13g2_decap_8
XFILLER_2_204 VPWR VGND sg13g2_fill_1
Xfanout574 net575 net574 VPWR VGND sg13g2_buf_8
Xfanout563 _0888_ net563 VPWR VGND sg13g2_buf_8
Xfanout596 net598 net596 VPWR VGND sg13g2_buf_8
Xfanout585 net586 net585 VPWR VGND sg13g2_buf_8
XFILLER_42_653 VPWR VGND sg13g2_decap_8
XFILLER_15_856 VPWR VGND sg13g2_fill_1
XFILLER_25_94 VPWR VGND sg13g2_decap_8
XFILLER_30_826 VPWR VGND sg13g2_decap_4
XFILLER_30_859 VPWR VGND sg13g2_fill_1
X_5132__207 VPWR VGND net207 sg13g2_tiehi
XFILLER_6_543 VPWR VGND sg13g2_decap_4
XFILLER_10_594 VPWR VGND sg13g2_decap_8
XFILLER_6_587 VPWR VGND sg13g2_decap_8
XFILLER_49_252 VPWR VGND sg13g2_decap_8
XFILLER_37_414 VPWR VGND sg13g2_decap_8
XFILLER_46_981 VPWR VGND sg13g2_decap_8
X_4931_ net137 VGND VPWR _0285_ videogen.test_lut_thingy.pixel_feeder_inst.row\[18\]\[1\]
+ _0014_ sg13g2_dfrbpq_1
XFILLER_18_683 VPWR VGND sg13g2_decap_8
X_4862_ net700 net744 _0219_ VPWR VGND sg13g2_nor2_1
X_3813_ net611 VPWR _1477_ VGND videogen.test_lut_thingy.pixel_feeder_inst.row\[51\]\[1\]
+ net580 sg13g2_o21ai_1
XFILLER_32_152 VPWR VGND sg13g2_decap_8
X_4793_ net689 net733 _0150_ VPWR VGND sg13g2_nor2_1
X_3744_ net643 VPWR _1408_ VGND videogen.test_lut_thingy.pixel_feeder_inst.row\[15\]\[2\]
+ net578 sg13g2_o21ai_1
X_3675_ videogen.test_lut_thingy.pixel_feeder_inst.row\[32\]\[2\] net597 _1339_ VPWR
+ VGND sg13g2_nor2_1
X_4970__70 VPWR VGND net70 sg13g2_tiehi
X_5276_ net242 VGND VPWR _0626_ videogen.test_lut_thingy.pixel_feeder_inst.row\[24\]\[0\]
+ _0245_ sg13g2_dfrbpq_1
X_4227_ _1882_ _1864_ _1852_ _1884_ VPWR VGND sg13g2_a21o_1
XFILLER_29_915 VPWR VGND sg13g2_fill_2
XFILLER_29_926 VPWR VGND sg13g2_fill_1
XFILLER_28_447 VPWR VGND sg13g2_fill_1
XFILLER_28_458 VPWR VGND sg13g2_decap_4
X_4158_ _1809_ _1811_ _1815_ VPWR VGND sg13g2_nor2_1
X_3109_ _0859_ videogen.test_lut_thingy.pixel_feeder_inst.v_pix\[2\] _0856_ VPWR VGND
+ sg13g2_xnor2_1
X_4089_ _1746_ _1635_ _1745_ VPWR VGND sg13g2_xnor2_1
XFILLER_43_439 VPWR VGND sg13g2_fill_2
XFILLER_15_119 VPWR VGND sg13g2_decap_8
XFILLER_24_642 VPWR VGND sg13g2_decap_8
XFILLER_24_653 VPWR VGND sg13g2_fill_2
XFILLER_11_303 VPWR VGND sg13g2_decap_4
XFILLER_3_502 VPWR VGND sg13g2_fill_1
XFILLER_11_85 VPWR VGND sg13g2_fill_2
X_5207__300 VPWR VGND net300 sg13g2_tiehi
XFILLER_47_767 VPWR VGND sg13g2_decap_8
XFILLER_34_417 VPWR VGND sg13g2_fill_2
XFILLER_42_461 VPWR VGND sg13g2_decap_4
XFILLER_42_450 VPWR VGND sg13g2_decap_8
XFILLER_14_152 VPWR VGND sg13g2_decap_4
XFILLER_15_686 VPWR VGND sg13g2_decap_8
XFILLER_15_697 VPWR VGND sg13g2_fill_2
XFILLER_30_678 VPWR VGND sg13g2_fill_2
XFILLER_10_380 VPWR VGND sg13g2_decap_8
XFILLER_7_896 VPWR VGND sg13g2_fill_2
XFILLER_6_384 VPWR VGND sg13g2_decap_8
XFILLER_6_373 VPWR VGND sg13g2_decap_8
X_3460_ _1100_ VPWR _1124_ VGND _1094_ net557 sg13g2_o21ai_1
X_3391_ _1051_ VPWR _1055_ VGND _1026_ _1054_ sg13g2_o21ai_1
X_5130_ net211 VGND VPWR _0480_ videogen.test_lut_thingy.pixel_feeder_inst.row\[55\]\[0\]
+ _0117_ sg13g2_dfrbpq_1
X_5061_ net348 VGND VPWR _0411_ tmds_green.dc_balancing_reg\[4\] net662 sg13g2_dfrbpq_2
X_4012_ VGND VPWR _1672_ _1671_ _1635_ sg13g2_or2_1
XFILLER_37_255 VPWR VGND sg13g2_decap_4
XFILLER_37_277 VPWR VGND sg13g2_fill_1
X_5290__55 VPWR VGND net55 sg13g2_tiehi
X_4914_ net163 VGND VPWR _0268_ serialize.shift_reg_b\[9\] clknet_3_3_0_clk_regs sg13g2_dfrbpq_1
XFILLER_34_940 VPWR VGND sg13g2_fill_1
XFILLER_34_995 VPWR VGND sg13g2_decap_8
X_4845_ net688 net730 _0202_ VPWR VGND sg13g2_nor2_1
XFILLER_33_494 VPWR VGND sg13g2_decap_8
X_4776_ net703 net747 _0133_ VPWR VGND sg13g2_nor2_1
X_3727_ videogen.test_lut_thingy.pixel_feeder_inst.row\[25\]\[2\] net567 _1391_ VPWR
+ VGND sg13g2_nor2_1
X_3658_ videogen.test_lut_thingy.pixel_feeder_inst.row\[21\]\[3\] net573 _1322_ VPWR
+ VGND sg13g2_nor2_1
X_3589_ _1252_ VPWR _1253_ VGND videogen.test_lut_thingy.pixel_feeder_inst.row\[61\]\[3\]
+ net569 sg13g2_o21ai_1
XFILLER_0_527 VPWR VGND sg13g2_decap_8
X_5085__301 VPWR VGND net301 sg13g2_tiehi
X_5259_ net338 VGND VPWR _0609_ videogen.test_lut_thingy.pixel_feeder_inst.row\[29\]\[1\]
+ _0238_ sg13g2_dfrbpq_1
XFILLER_28_266 VPWR VGND sg13g2_fill_2
XFILLER_28_255 VPWR VGND sg13g2_fill_1
XFILLER_44_726 VPWR VGND sg13g2_fill_2
XFILLER_28_299 VPWR VGND sg13g2_decap_4
XFILLER_25_940 VPWR VGND sg13g2_fill_1
XFILLER_24_450 VPWR VGND sg13g2_fill_2
X_5179__37 VPWR VGND net37 sg13g2_tiehi
XFILLER_11_122 VPWR VGND sg13g2_fill_2
XFILLER_24_483 VPWR VGND sg13g2_decap_8
XFILLER_8_605 VPWR VGND sg13g2_decap_4
XFILLER_7_137 VPWR VGND sg13g2_decap_8
XFILLER_7_115 VPWR VGND sg13g2_decap_8
XFILLER_22_73 VPWR VGND sg13g2_decap_8
XFILLER_3_321 VPWR VGND sg13g2_decap_8
XFILLER_4_855 VPWR VGND sg13g2_decap_8
XFILLER_0_0 VPWR VGND sg13g2_decap_8
XFILLER_47_564 VPWR VGND sg13g2_decap_8
XFILLER_47_92 VPWR VGND sg13g2_fill_1
XFILLER_19_244 VPWR VGND sg13g2_decap_8
XFILLER_35_748 VPWR VGND sg13g2_decap_8
XFILLER_34_258 VPWR VGND sg13g2_decap_8
XFILLER_16_995 VPWR VGND sg13g2_decap_8
X_2960_ net790 _0796_ _0797_ VPWR VGND sg13g2_nor2_1
X_2891_ _0724_ _0745_ _0781_ VPWR VGND sg13g2_nor2_2
X_4630_ _2230_ net671 net462 net678 red_tmds_par\[1\] VPWR VGND sg13g2_a22oi_1
XFILLER_30_442 VPWR VGND sg13g2_fill_2
XFILLER_31_965 VPWR VGND sg13g2_decap_8
X_4561_ _2186_ tmds_blue.dc_balancing_reg\[4\] _2187_ VPWR VGND sg13g2_xor2_1
X_4492_ VGND VPWR net628 _2123_ _0509_ net773 sg13g2_a21oi_1
X_3512_ _1158_ _1175_ _1174_ _1176_ VPWR VGND sg13g2_mux2_1
X_3443_ _1099_ net557 _1107_ VPWR VGND sg13g2_nor2_2
X_3374_ _1038_ videogen.fancy_shader.video_x\[5\] net630 VPWR VGND sg13g2_nand2_1
X_5113_ net245 VGND VPWR _0463_ videogen.test_lut_thingy.pixel_feeder_inst.row\[8\]\[3\]
+ _0100_ sg13g2_dfrbpq_1
XFILLER_33_0 VPWR VGND sg13g2_decap_4
XFILLER_38_520 VPWR VGND sg13g2_fill_1
X_5044_ net366 VGND VPWR _0398_ videogen.test_lut_thingy.pixel_feeder_inst.row\[15\]\[3\]
+ _0044_ sg13g2_dfrbpq_1
XFILLER_25_258 VPWR VGND sg13g2_decap_8
XFILLER_43_17 VPWR VGND sg13g2_fill_2
X_4828_ net713 net757 _0185_ VPWR VGND sg13g2_nor2_1
XFILLER_5_619 VPWR VGND sg13g2_fill_1
XFILLER_5_608 VPWR VGND sg13g2_fill_1
X_4759_ net693 net737 _0116_ VPWR VGND sg13g2_nor2_1
XFILLER_4_118 VPWR VGND sg13g2_fill_1
XFILLER_4_107 VPWR VGND sg13g2_decap_8
XFILLER_49_1027 VPWR VGND sg13g2_fill_2
XFILLER_0_302 VPWR VGND sg13g2_fill_2
XFILLER_0_346 VPWR VGND sg13g2_decap_4
XFILLER_1_847 VPWR VGND sg13g2_decap_8
XFILLER_0_379 VPWR VGND sg13g2_decap_8
XFILLER_17_704 VPWR VGND sg13g2_decap_4
XFILLER_44_545 VPWR VGND sg13g2_decap_8
X_4922__153 VPWR VGND net153 sg13g2_tiehi
XFILLER_25_781 VPWR VGND sg13g2_decap_8
XFILLER_40_762 VPWR VGND sg13g2_decap_4
XFILLER_33_61 VPWR VGND sg13g2_decap_4
XFILLER_40_795 VPWR VGND sg13g2_decap_4
XFILLER_9_958 VPWR VGND sg13g2_decap_8
XFILLER_33_94 VPWR VGND sg13g2_decap_8
XFILLER_4_652 VPWR VGND sg13g2_decap_8
XFILLER_3_195 VPWR VGND sg13g2_decap_4
XFILLER_39_306 VPWR VGND sg13g2_decap_8
XFILLER_0_891 VPWR VGND sg13g2_decap_8
X_3090_ net14 _0705_ _0719_ VPWR VGND sg13g2_nand2_2
Xhold2 _0662_ VPWR VGND net447 sg13g2_dlygate4sd3_1
XFILLER_48_862 VPWR VGND sg13g2_decap_8
XFILLER_35_501 VPWR VGND sg13g2_fill_2
X_3992_ _1642_ _1648_ _1650_ _1652_ VPWR VGND sg13g2_nor3_1
X_2943_ _0704_ _0728_ net645 _0793_ VPWR VGND _0750_ sg13g2_nand4_1
XFILLER_31_762 VPWR VGND sg13g2_fill_2
XFILLER_30_250 VPWR VGND sg13g2_decap_4
X_2874_ videogen.test_lut_thingy.pixel_feeder_inst.row\[36\]\[1\] net805 _0777_ _0517_
+ VPWR VGND sg13g2_mux2_1
X_4613_ VPWR _0646_ _2221_ VGND sg13g2_inv_1
X_4544_ VGND VPWR _2145_ _2152_ _2171_ _2154_ sg13g2_a21oi_1
XFILLER_8_980 VPWR VGND sg13g2_decap_8
X_4475_ _2109_ VPWR _2110_ VGND _2100_ _2107_ sg13g2_o21ai_1
X_3426_ _1076_ _1089_ _1074_ _1090_ VPWR VGND sg13g2_nand3_1
XFILLER_38_17 VPWR VGND sg13g2_fill_1
X_3357_ _1021_ _1017_ _1020_ VPWR VGND sg13g2_xnor2_1
X_4945__120 VPWR VGND net120 sg13g2_tiehi
X_5027_ net397 VGND VPWR _0381_ videogen.test_lut_thingy.pixel_feeder_inst.row\[12\]\[1\]
+ _0030_ sg13g2_dfrbpq_1
X_3288_ _0964_ _0965_ _0340_ VPWR VGND sg13g2_nor2_1
XFILLER_38_372 VPWR VGND sg13g2_fill_1
XFILLER_26_534 VPWR VGND sg13g2_decap_8
X_4993__438 VPWR VGND net438 sg13g2_tiehi
XFILLER_10_979 VPWR VGND sg13g2_decap_8
XFILLER_6_939 VPWR VGND sg13g2_decap_8
XFILLER_5_416 VPWR VGND sg13g2_decap_8
XFILLER_1_644 VPWR VGND sg13g2_decap_8
X_5172__65 VPWR VGND net65 sg13g2_tiehi
XFILLER_0_187 VPWR VGND sg13g2_decap_8
XFILLER_0_198 VPWR VGND sg13g2_decap_4
XFILLER_17_501 VPWR VGND sg13g2_decap_4
XFILLER_28_83 VPWR VGND sg13g2_decap_8
XFILLER_29_361 VPWR VGND sg13g2_fill_2
XFILLER_45_843 VPWR VGND sg13g2_decap_8
XFILLER_44_386 VPWR VGND sg13g2_fill_1
XFILLER_32_526 VPWR VGND sg13g2_fill_1
XFILLER_13_795 VPWR VGND sg13g2_decap_8
XFILLER_9_766 VPWR VGND sg13g2_fill_1
XFILLER_8_265 VPWR VGND sg13g2_fill_1
XFILLER_5_950 VPWR VGND sg13g2_decap_8
XFILLER_5_54 VPWR VGND sg13g2_fill_2
XFILLER_5_43 VPWR VGND sg13g2_fill_1
X_4260_ VPWR VGND _1915_ _1894_ _1912_ _1899_ _1917_ _1909_ sg13g2_a221oi_1
X_3211_ net641 _0910_ _0913_ VPWR VGND sg13g2_and2_1
X_4191_ VPWR _1848_ _1847_ VGND sg13g2_inv_1
X_3142_ net449 net672 _0271_ VPWR VGND sg13g2_and2_1
X_3073_ _0820_ VPWR _0835_ VGND videogen.test_lut_thingy.pixel_feeder_inst.state\[0\]
+ _0834_ sg13g2_o21ai_1
X_3975_ _1635_ _1032_ _1634_ VPWR VGND sg13g2_xnor2_1
X_2926_ net800 videogen.test_lut_thingy.pixel_feeder_inst.row\[58\]\[1\] _0789_ _0469_
+ VPWR VGND sg13g2_mux2_1
X_2857_ videogen.test_lut_thingy.pixel_feeder_inst.row\[27\]\[3\] net776 _0774_ _0531_
+ VPWR VGND sg13g2_mux2_1
X_2788_ videogen.test_lut_thingy.pixel_feeder_inst.row\[40\]\[0\] net816 _0758_ _0584_
+ VPWR VGND sg13g2_mux2_1
XFILLER_3_909 VPWR VGND sg13g2_decap_8
X_4527_ _2155_ _2134_ _2153_ VPWR VGND sg13g2_xnor2_1
X_4458_ _2092_ _2090_ _2093_ VPWR VGND sg13g2_xor2_1
XFILLER_49_49 VPWR VGND sg13g2_decap_8
Xfanout723 net724 net723 VPWR VGND sg13g2_buf_8
Xfanout701 net703 net701 VPWR VGND sg13g2_buf_8
X_3409_ _1073_ _1060_ _1071_ _1072_ VPWR VGND sg13g2_and3_1
Xfanout712 net724 net712 VPWR VGND sg13g2_buf_8
Xfanout745 net747 net745 VPWR VGND sg13g2_buf_8
X_4389_ _2023_ VPWR _2038_ VGND _2012_ _2020_ sg13g2_o21ai_1
Xfanout734 net735 net734 VPWR VGND sg13g2_buf_1
Xfanout756 net768 net756 VPWR VGND sg13g2_buf_8
Xfanout767 net768 net767 VPWR VGND sg13g2_buf_8
Xfanout778 net780 net778 VPWR VGND sg13g2_buf_8
Xfanout789 net791 net789 VPWR VGND sg13g2_buf_8
XFILLER_27_898 VPWR VGND sg13g2_fill_1
XFILLER_41_345 VPWR VGND sg13g2_fill_1
XFILLER_41_334 VPWR VGND sg13g2_decap_8
XFILLER_14_52 VPWR VGND sg13g2_fill_1
X_5093__285 VPWR VGND net285 sg13g2_tiehi
XFILLER_5_246 VPWR VGND sg13g2_decap_4
XFILLER_10_798 VPWR VGND sg13g2_decap_8
XFILLER_5_268 VPWR VGND sg13g2_decap_4
XFILLER_39_60 VPWR VGND sg13g2_decap_8
XFILLER_2_986 VPWR VGND sg13g2_decap_8
XFILLER_49_467 VPWR VGND sg13g2_decap_8
XFILLER_39_93 VPWR VGND sg13g2_fill_2
XFILLER_37_607 VPWR VGND sg13g2_decap_8
XFILLER_18_810 VPWR VGND sg13g2_decap_8
XFILLER_36_117 VPWR VGND sg13g2_fill_2
XFILLER_17_353 VPWR VGND sg13g2_decap_8
XFILLER_18_876 VPWR VGND sg13g2_fill_2
XFILLER_45_684 VPWR VGND sg13g2_decap_8
XFILLER_44_161 VPWR VGND sg13g2_fill_1
XFILLER_18_898 VPWR VGND sg13g2_decap_8
XFILLER_20_529 VPWR VGND sg13g2_decap_4
X_3760_ net640 _1418_ _1423_ _1424_ VPWR VGND sg13g2_nor3_1
X_2711_ _0721_ _0724_ _0725_ VPWR VGND sg13g2_nor2_2
XFILLER_9_541 VPWR VGND sg13g2_decap_4
XFILLER_9_552 VPWR VGND sg13g2_fill_2
X_5139__193 VPWR VGND net193 sg13g2_tiehi
XFILLER_9_574 VPWR VGND sg13g2_fill_1
X_3691_ net639 VPWR _1355_ VGND videogen.test_lut_thingy.pixel_feeder_inst.row\[58\]\[2\]
+ net602 sg13g2_o21ai_1
X_4935__130 VPWR VGND net130 sg13g2_tiehi
X_5292_ net39 VGND VPWR _0642_ serialize.shift_reg_b\[4\] clknet_3_2_0_clk_regs sg13g2_dfrbpq_1
X_4312_ _1964_ red\[4\] red\[7\] VPWR VGND sg13g2_xnor2_1
X_4243_ _1900_ _1012_ _1898_ VPWR VGND sg13g2_xnor2_1
X_4174_ _1138_ _1827_ _1029_ _1831_ VPWR VGND sg13g2_nand3_1
X_3125_ clk_video _0005_ VPWR VGND sg13g2_inv_2
XFILLER_28_618 VPWR VGND sg13g2_decap_8
XFILLER_28_629 VPWR VGND sg13g2_fill_2
X_4942__123 VPWR VGND net123 sg13g2_tiehi
X_3056_ _0818_ net649 _0700_ VPWR VGND sg13g2_nand2_1
XFILLER_24_813 VPWR VGND sg13g2_decap_8
XFILLER_36_651 VPWR VGND sg13g2_decap_8
XFILLER_24_835 VPWR VGND sg13g2_decap_8
X_3958_ net637 _1609_ _1620_ _1621_ VPWR VGND sg13g2_nor3_1
X_2909_ net778 videogen.test_lut_thingy.pixel_feeder_inst.row\[55\]\[3\] _0786_ _0483_
+ VPWR VGND sg13g2_mux2_1
X_3889_ net610 VPWR _1552_ VGND videogen.test_lut_thingy.pixel_feeder_inst.row\[16\]\[0\]
+ net590 sg13g2_o21ai_1
XFILLER_3_706 VPWR VGND sg13g2_decap_8
Xfanout575 net576 net575 VPWR VGND sg13g2_buf_8
Xfanout564 _1966_ net564 VPWR VGND sg13g2_buf_8
XFILLER_47_949 VPWR VGND sg13g2_decap_8
Xfanout597 net598 net597 VPWR VGND sg13g2_buf_8
Xfanout586 net587 net586 VPWR VGND sg13g2_buf_8
XFILLER_15_835 VPWR VGND sg13g2_decap_4
XFILLER_26_172 VPWR VGND sg13g2_fill_2
XFILLER_42_632 VPWR VGND sg13g2_decap_8
XFILLER_41_164 VPWR VGND sg13g2_decap_8
XFILLER_14_378 VPWR VGND sg13g2_decap_8
X_4919__158 VPWR VGND net158 sg13g2_tiehi
XFILLER_41_50 VPWR VGND sg13g2_decap_8
XFILLER_6_522 VPWR VGND sg13g2_decap_8
XFILLER_29_1025 VPWR VGND sg13g2_decap_4
XFILLER_2_783 VPWR VGND sg13g2_decap_8
XFILLER_49_231 VPWR VGND sg13g2_fill_2
XFILLER_2_22 VPWR VGND sg13g2_decap_8
XFILLER_49_286 VPWR VGND sg13g2_decap_8
XFILLER_46_960 VPWR VGND sg13g2_decap_8
X_4930_ net139 VGND VPWR _0284_ videogen.test_lut_thingy.pixel_feeder_inst.row\[18\]\[0\]
+ _0013_ sg13g2_dfrbpq_1
XFILLER_45_492 VPWR VGND sg13g2_decap_8
X_4861_ net689 net733 _0218_ VPWR VGND sg13g2_nor2_1
X_3812_ net635 _1452_ _1475_ _1476_ VPWR VGND sg13g2_or3_1
XFILLER_21_849 VPWR VGND sg13g2_decap_4
X_4792_ net707 net751 _0149_ VPWR VGND sg13g2_nor2_1
X_3743_ _1403_ _1404_ _1405_ _1406_ _1407_ VPWR VGND sg13g2_nor4_1
X_3674_ videogen.test_lut_thingy.pixel_feeder_inst.row\[34\]\[2\] net608 _1338_ VPWR
+ VGND sg13g2_nor2_1
XFILLER_0_709 VPWR VGND sg13g2_decap_8
X_5275_ net250 VGND VPWR _0625_ videogen.test_lut_thingy.pixel_feeder_inst.row\[25\]\[3\]
+ _0244_ sg13g2_dfrbpq_1
X_4226_ _1864_ _1882_ _1852_ _1883_ VPWR VGND sg13g2_nand3_1
X_4157_ _1814_ _1742_ _1808_ _1813_ VPWR VGND sg13g2_and3_1
X_5293__31 VPWR VGND net31 sg13g2_tiehi
X_3108_ videogen.test_lut_thingy.pixel_feeder_inst.v_pix\[2\] _0856_ _0858_ VPWR VGND
+ sg13g2_and2_1
XFILLER_28_426 VPWR VGND sg13g2_fill_2
X_4088_ _1015_ _1743_ _1745_ VPWR VGND sg13g2_nor2_2
X_3039_ videogen.test_lut_thingy.pixel_feeder_inst.row\[34\]\[0\] net815 _0813_ _0319_
+ VPWR VGND sg13g2_mux2_1
XFILLER_36_470 VPWR VGND sg13g2_decap_8
XFILLER_12_816 VPWR VGND sg13g2_decap_8
XFILLER_12_827 VPWR VGND sg13g2_fill_2
XFILLER_23_142 VPWR VGND sg13g2_fill_1
XFILLER_24_676 VPWR VGND sg13g2_decap_8
XFILLER_24_698 VPWR VGND sg13g2_decap_4
XFILLER_23_186 VPWR VGND sg13g2_fill_2
XFILLER_3_514 VPWR VGND sg13g2_fill_2
XFILLER_3_569 VPWR VGND sg13g2_decap_8
XFILLER_4_1016 VPWR VGND sg13g2_decap_8
XFILLER_47_746 VPWR VGND sg13g2_decap_8
XFILLER_4_1027 VPWR VGND sg13g2_fill_2
XFILLER_14_120 VPWR VGND sg13g2_fill_1
XFILLER_15_643 VPWR VGND sg13g2_decap_8
XFILLER_43_974 VPWR VGND sg13g2_decap_8
XFILLER_15_665 VPWR VGND sg13g2_decap_8
XFILLER_30_613 VPWR VGND sg13g2_decap_8
X_5253__398 VPWR VGND net398 sg13g2_tiehi
XFILLER_7_831 VPWR VGND sg13g2_decap_8
XFILLER_11_882 VPWR VGND sg13g2_fill_1
XFILLER_7_875 VPWR VGND sg13g2_decap_8
XFILLER_6_330 VPWR VGND sg13g2_fill_2
X_5184__404 VPWR VGND net404 sg13g2_tiehi
X_3390_ VPWR _1054_ _1053_ VGND sg13g2_inv_1
X_5060_ net349 VGND VPWR _0410_ tmds_green.dc_balancing_reg\[3\] net662 sg13g2_dfrbpq_2
XFILLER_42_1022 VPWR VGND sg13g2_decap_8
X_4011_ VGND VPWR _1671_ _1670_ _1667_ sg13g2_or2_1
XFILLER_37_234 VPWR VGND sg13g2_fill_2
X_4913_ net164 VGND VPWR _0267_ serialize.shift_reg_b\[8\] clknet_3_2_0_clk_regs sg13g2_dfrbpq_1
XFILLER_18_481 VPWR VGND sg13g2_fill_2
XFILLER_18_492 VPWR VGND sg13g2_fill_2
XFILLER_34_952 VPWR VGND sg13g2_fill_1
X_4844_ net686 net730 _0201_ VPWR VGND sg13g2_nor2_1
X_4775_ net701 net745 _0132_ VPWR VGND sg13g2_nor2_1
X_3726_ net610 VPWR _1390_ VGND videogen.test_lut_thingy.pixel_feeder_inst.row\[26\]\[2\]
+ net600 sg13g2_o21ai_1
X_3657_ videogen.test_lut_thingy.pixel_feeder_inst.row\[23\]\[3\] net584 _1321_ VPWR
+ VGND sg13g2_nor2_1
X_3588_ VGND VPWR _0671_ _0706_ _1252_ _1251_ sg13g2_a21oi_1
XFILLER_0_506 VPWR VGND sg13g2_decap_8
X_5258_ net346 VGND VPWR _0608_ videogen.test_lut_thingy.pixel_feeder_inst.row\[29\]\[0\]
+ _0237_ sg13g2_dfrbpq_1
XFILLER_29_713 VPWR VGND sg13g2_decap_8
X_5189_ net381 VGND VPWR _0539_ videogen.test_lut_thingy.pixel_feeder_inst.row\[26\]\[3\]
+ _0168_ sg13g2_dfrbpq_1
X_4209_ _1844_ VPWR _1866_ VGND _1839_ _1841_ sg13g2_o21ai_1
X_4909__168 VPWR VGND net168 sg13g2_tiehi
XFILLER_28_278 VPWR VGND sg13g2_fill_2
XFILLER_25_930 VPWR VGND sg13g2_fill_1
XFILLER_25_952 VPWR VGND sg13g2_decap_8
XFILLER_40_988 VPWR VGND sg13g2_decap_4
X_4955__100 VPWR VGND net100 sg13g2_tiehi
XFILLER_20_690 VPWR VGND sg13g2_fill_2
XFILLER_4_834 VPWR VGND sg13g2_decap_8
XFILLER_3_399 VPWR VGND sg13g2_decap_8
XFILLER_26_1028 VPWR VGND sg13g2_fill_1
XFILLER_19_201 VPWR VGND sg13g2_decap_8
XFILLER_47_543 VPWR VGND sg13g2_decap_8
XFILLER_34_237 VPWR VGND sg13g2_decap_8
X_2890_ videogen.test_lut_thingy.pixel_feeder_inst.row\[53\]\[0\] net811 _0780_ _0496_
+ VPWR VGND sg13g2_mux2_1
XFILLER_30_410 VPWR VGND sg13g2_decap_4
XFILLER_30_454 VPWR VGND sg13g2_fill_2
X_4560_ _2186_ _2140_ _2164_ VPWR VGND sg13g2_nand2_1
XFILLER_8_65 VPWR VGND sg13g2_fill_2
XFILLER_8_54 VPWR VGND sg13g2_decap_8
XFILLER_8_43 VPWR VGND sg13g2_fill_1
XFILLER_8_98 VPWR VGND sg13g2_fill_1
XFILLER_8_87 VPWR VGND sg13g2_fill_1
X_4491_ _2123_ _2101_ _2052_ _2060_ _2054_ VPWR VGND sg13g2_a22oi_1
X_3511_ _1158_ _1171_ _1175_ VPWR VGND sg13g2_nor2_1
X_3442_ VPWR _1106_ net557 VGND sg13g2_inv_1
X_3373_ VGND VPWR _1037_ net630 videogen.fancy_shader.video_x\[5\] sg13g2_or2_1
X_5112_ net247 VGND VPWR _0462_ videogen.test_lut_thingy.pixel_feeder_inst.row\[8\]\[2\]
+ _0099_ sg13g2_dfrbpq_1
X_5043_ net368 VGND VPWR _0397_ videogen.test_lut_thingy.pixel_feeder_inst.row\[15\]\[2\]
+ _0043_ sg13g2_dfrbpq_1
XFILLER_38_576 VPWR VGND sg13g2_decap_8
XFILLER_26_738 VPWR VGND sg13g2_fill_1
XFILLER_22_900 VPWR VGND sg13g2_fill_2
XFILLER_33_270 VPWR VGND sg13g2_fill_1
XFILLER_21_443 VPWR VGND sg13g2_decap_8
XFILLER_21_454 VPWR VGND sg13g2_fill_2
X_4827_ net714 net758 _0184_ VPWR VGND sg13g2_nor2_1
XFILLER_21_487 VPWR VGND sg13g2_fill_2
X_4758_ net693 net737 _0115_ VPWR VGND sg13g2_nor2_1
XFILLER_49_1006 VPWR VGND sg13g2_decap_8
X_4689_ net706 net750 _0046_ VPWR VGND sg13g2_nor2_1
X_3709_ VGND VPWR _0670_ _0728_ _1373_ _1372_ sg13g2_a21oi_1
XFILLER_1_826 VPWR VGND sg13g2_decap_8
XFILLER_0_325 VPWR VGND sg13g2_decap_4
X_5024__403 VPWR VGND net403 sg13g2_tiehi
XFILLER_1_1008 VPWR VGND sg13g2_decap_8
XFILLER_29_565 VPWR VGND sg13g2_fill_1
XFILLER_44_535 VPWR VGND sg13g2_decap_4
XFILLER_9_937 VPWR VGND sg13g2_decap_8
XFILLER_3_152 VPWR VGND sg13g2_fill_1
XFILLER_3_141 VPWR VGND sg13g2_decap_8
Xhold3 serialize.shift_reg_c\[3\] VPWR VGND net448 sg13g2_dlygate4sd3_1
XFILLER_39_329 VPWR VGND sg13g2_decap_8
XFILLER_0_870 VPWR VGND sg13g2_decap_8
XFILLER_48_841 VPWR VGND sg13g2_decap_8
X_3991_ _1093_ _1647_ _1092_ _1651_ VPWR VGND sg13g2_nand3_1
XFILLER_22_207 VPWR VGND sg13g2_fill_1
X_2942_ videogen.test_lut_thingy.pixel_feeder_inst.row\[5\]\[0\] net813 _0792_ _0456_
+ VPWR VGND sg13g2_mux2_1
XFILLER_22_218 VPWR VGND sg13g2_decap_8
XFILLER_22_229 VPWR VGND sg13g2_fill_2
X_2873_ videogen.test_lut_thingy.pixel_feeder_inst.row\[36\]\[2\] net794 _0777_ _0518_
+ VPWR VGND sg13g2_mux2_1
X_4612_ _2221_ net671 net465 net677 green_tmds_par\[0\] VPWR VGND sg13g2_a22oi_1
X_4543_ _2131_ _2169_ _2170_ VPWR VGND sg13g2_nor2_1
XFILLER_7_480 VPWR VGND sg13g2_fill_1
X_4474_ _2059_ _2108_ _2109_ VPWR VGND sg13g2_and2_1
X_3425_ _1089_ _1086_ _1087_ VPWR VGND sg13g2_xnor2_1
X_3356_ net631 videogen.fancy_shader.video_x\[4\] _1020_ VPWR VGND sg13g2_xor2_1
XFILLER_38_29 VPWR VGND sg13g2_decap_8
X_3287_ net818 VPWR _0965_ VGND videogen.fancy_shader.video_y\[1\] _0962_ sg13g2_o21ai_1
XFILLER_38_340 VPWR VGND sg13g2_fill_1
X_5026_ net399 VGND VPWR _0380_ videogen.test_lut_thingy.pixel_feeder_inst.row\[12\]\[0\]
+ _0029_ sg13g2_dfrbpq_1
XFILLER_26_513 VPWR VGND sg13g2_decap_8
XFILLER_26_568 VPWR VGND sg13g2_decap_8
XFILLER_26_579 VPWR VGND sg13g2_fill_1
XFILLER_41_538 VPWR VGND sg13g2_decap_8
XFILLER_22_741 VPWR VGND sg13g2_decap_8
XFILLER_21_251 VPWR VGND sg13g2_fill_1
XFILLER_21_262 VPWR VGND sg13g2_decap_8
XFILLER_22_774 VPWR VGND sg13g2_decap_8
XFILLER_6_918 VPWR VGND sg13g2_decap_8
XFILLER_10_958 VPWR VGND sg13g2_decap_8
XFILLER_1_623 VPWR VGND sg13g2_decap_8
XFILLER_49_649 VPWR VGND sg13g2_decap_8
XFILLER_0_166 VPWR VGND sg13g2_decap_8
XFILLER_45_822 VPWR VGND sg13g2_decap_8
XFILLER_45_899 VPWR VGND sg13g2_decap_8
XFILLER_44_50 VPWR VGND sg13g2_fill_1
XFILLER_44_94 VPWR VGND sg13g2_fill_1
XFILLER_8_211 VPWR VGND sg13g2_decap_4
XFILLER_9_789 VPWR VGND sg13g2_decap_8
XFILLER_5_22 VPWR VGND sg13g2_fill_1
X_5035__384 VPWR VGND net384 sg13g2_tiehi
XFILLER_4_461 VPWR VGND sg13g2_decap_8
XFILLER_4_494 VPWR VGND sg13g2_fill_2
XFILLER_5_99 VPWR VGND sg13g2_decap_4
X_3210_ net641 _0910_ _0912_ VPWR VGND sg13g2_nor2_1
X_4190_ _1847_ _1099_ _1846_ VPWR VGND sg13g2_xnor2_1
X_3141_ net448 net672 _0270_ VPWR VGND sg13g2_and2_1
X_3072_ _0834_ _0832_ _0833_ _0825_ _0822_ VPWR VGND sg13g2_a22oi_1
XFILLER_47_181 VPWR VGND sg13g2_decap_4
XFILLER_36_844 VPWR VGND sg13g2_decap_8
XFILLER_23_527 VPWR VGND sg13g2_decap_4
X_3974_ _1634_ _0998_ _1025_ _1170_ VPWR VGND sg13g2_and3_2
X_2925_ net789 videogen.test_lut_thingy.pixel_feeder_inst.row\[58\]\[2\] _0789_ _0470_
+ VPWR VGND sg13g2_mux2_1
X_2856_ _0733_ _0747_ _0774_ VPWR VGND sg13g2_nor2_2
XFILLER_31_582 VPWR VGND sg13g2_decap_8
X_2787_ videogen.test_lut_thingy.pixel_feeder_inst.row\[40\]\[1\] net806 _0758_ _0585_
+ VPWR VGND sg13g2_mux2_1
X_4526_ _2134_ _2153_ _2154_ VPWR VGND sg13g2_and2_1
XFILLER_49_28 VPWR VGND sg13g2_decap_8
XFILLER_46_1009 VPWR VGND sg13g2_decap_8
X_4457_ _2091_ VPWR _2092_ VGND tmds_green.dc_balancing_reg\[2\] _2072_ sg13g2_o21ai_1
Xfanout724 clockdiv.q2temp net724 VPWR VGND sg13g2_buf_8
Xfanout702 net703 net702 VPWR VGND sg13g2_buf_8
X_3408_ _1072_ videogen.fancy_shader.video_x\[9\] videogen.fancy_shader.shader_counter_reg\[9\]
+ VPWR VGND sg13g2_xnor2_1
Xfanout713 net714 net713 VPWR VGND sg13g2_buf_8
Xfanout746 net747 net746 VPWR VGND sg13g2_buf_8
X_4388_ _2037_ _1982_ _2036_ VPWR VGND sg13g2_nand2_1
Xfanout735 net768 net735 VPWR VGND sg13g2_buf_8
Xfanout757 net758 net757 VPWR VGND sg13g2_buf_8
X_3339_ _1003_ videogen.fancy_shader.video_x\[2\] videogen.fancy_shader.shader_counter_reg\[2\]
+ VPWR VGND sg13g2_nand2_1
Xfanout768 clockdiv.q1 net768 VPWR VGND sg13g2_buf_8
Xfanout779 net781 net779 VPWR VGND sg13g2_buf_8
XFILLER_27_800 VPWR VGND sg13g2_decap_8
XFILLER_38_170 VPWR VGND sg13g2_fill_1
X_5009_ net420 VGND VPWR _0363_ red\[0\] net664 sg13g2_dfrbpq_2
XFILLER_26_310 VPWR VGND sg13g2_decap_8
XFILLER_14_31 VPWR VGND sg13g2_decap_8
X_5058__351 VPWR VGND net351 sg13g2_tiehi
X_5251__441 VPWR VGND net441 sg13g2_tiehi
XFILLER_30_41 VPWR VGND sg13g2_fill_1
XFILLER_2_965 VPWR VGND sg13g2_decap_8
XFILLER_49_446 VPWR VGND sg13g2_decap_8
XFILLER_1_497 VPWR VGND sg13g2_decap_8
XFILLER_36_107 VPWR VGND sg13g2_fill_2
XFILLER_17_310 VPWR VGND sg13g2_fill_2
XFILLER_45_663 VPWR VGND sg13g2_decap_8
XFILLER_17_332 VPWR VGND sg13g2_decap_8
XFILLER_33_803 VPWR VGND sg13g2_decap_8
XFILLER_44_173 VPWR VGND sg13g2_decap_4
XFILLER_40_390 VPWR VGND sg13g2_fill_1
XFILLER_9_520 VPWR VGND sg13g2_decap_8
XFILLER_13_593 VPWR VGND sg13g2_decap_4
X_2710_ videogen.test_lut_thingy.pixel_feeder_inst.h_pix\[1\] net648 net643 _0724_
+ VPWR VGND net562 sg13g2_nand4_1
X_3690_ net637 _1342_ _1353_ _1354_ VPWR VGND sg13g2_nor3_1
X_5291_ net47 VGND VPWR _0641_ serialize.shift_reg_b\[3\] clknet_3_0_0_clk_regs sg13g2_dfrbpq_1
X_4311_ _1960_ _1961_ _1963_ VPWR VGND sg13g2_nor2_1
X_4242_ _1899_ _1011_ _1898_ VPWR VGND sg13g2_xnor2_1
X_4173_ _1830_ _1032_ _1829_ VPWR VGND sg13g2_xnor2_1
X_3124_ net711 net755 _0005_ VPWR VGND sg13g2_nor2_1
X_3055_ net649 _0700_ _0817_ VPWR VGND sg13g2_and2_1
XFILLER_36_630 VPWR VGND sg13g2_decap_8
X_3957_ net646 _1614_ _1619_ _1620_ VPWR VGND sg13g2_nor3_1
X_5153__136 VPWR VGND net136 sg13g2_tiehi
XFILLER_32_891 VPWR VGND sg13g2_decap_4
Xclkbuf_0_clk_regs clk_regs clknet_0_clk_regs VPWR VGND sg13g2_buf_8
X_2908_ _0786_ net559 _0744_ VPWR VGND sg13g2_nand2_2
XFILLER_13_1019 VPWR VGND sg13g2_decap_8
X_3888_ net636 _1539_ _1550_ _1551_ VPWR VGND sg13g2_nor3_1
X_2839_ videogen.test_lut_thingy.pixel_feeder_inst.row\[4\]\[1\] net805 _0770_ _0545_
+ VPWR VGND sg13g2_mux2_1
X_4509_ _2137_ blue\[1\] net624 VPWR VGND sg13g2_nand2_1
Xfanout565 net566 net565 VPWR VGND sg13g2_buf_8
XFILLER_47_928 VPWR VGND sg13g2_decap_8
Xfanout598 net599 net598 VPWR VGND sg13g2_buf_8
Xfanout576 _0729_ net576 VPWR VGND sg13g2_buf_8
Xfanout587 _0723_ net587 VPWR VGND sg13g2_buf_8
XFILLER_27_652 VPWR VGND sg13g2_fill_2
XFILLER_42_611 VPWR VGND sg13g2_decap_8
XFILLER_15_814 VPWR VGND sg13g2_decap_8
XFILLER_27_685 VPWR VGND sg13g2_fill_1
XFILLER_41_121 VPWR VGND sg13g2_fill_1
XFILLER_14_324 VPWR VGND sg13g2_decap_8
XFILLER_14_335 VPWR VGND sg13g2_fill_1
XFILLER_42_688 VPWR VGND sg13g2_decap_8
XFILLER_41_154 VPWR VGND sg13g2_decap_4
XFILLER_41_176 VPWR VGND sg13g2_decap_8
XFILLER_23_880 VPWR VGND sg13g2_fill_1
XFILLER_6_501 VPWR VGND sg13g2_fill_2
XFILLER_2_762 VPWR VGND sg13g2_decap_8
XFILLER_18_630 VPWR VGND sg13g2_fill_1
XFILLER_18_652 VPWR VGND sg13g2_decap_8
X_4860_ net689 net734 _0217_ VPWR VGND sg13g2_nor2_1
XFILLER_33_633 VPWR VGND sg13g2_decap_8
X_3811_ _0676_ _1463_ _1474_ _1475_ VPWR VGND sg13g2_nor3_1
XFILLER_21_828 VPWR VGND sg13g2_decap_8
XFILLER_20_316 VPWR VGND sg13g2_decap_8
XFILLER_20_327 VPWR VGND sg13g2_decap_8
X_4791_ net718 net762 _0148_ VPWR VGND sg13g2_nor2_1
XFILLER_32_187 VPWR VGND sg13g2_fill_2
X_3742_ videogen.test_lut_thingy.pixel_feeder_inst.row\[9\]\[2\] net567 _1406_ VPWR
+ VGND sg13g2_nor2_1
X_3673_ net617 VPWR _1337_ VGND videogen.test_lut_thingy.pixel_feeder_inst.row\[35\]\[2\]
+ net585 sg13g2_o21ai_1
X_5274_ net258 VGND VPWR _0624_ videogen.test_lut_thingy.pixel_feeder_inst.row\[25\]\[2\]
+ _0243_ sg13g2_dfrbpq_1
X_4225_ _1870_ _1873_ _1830_ _1882_ VPWR VGND sg13g2_nand3_1
X_4156_ _1813_ _1744_ _1811_ VPWR VGND sg13g2_xnor2_1
X_3107_ VGND VPWR _0850_ _0857_ net17 _0852_ sg13g2_a21oi_1
XFILLER_28_438 VPWR VGND sg13g2_decap_8
X_4087_ _1743_ _1633_ _1744_ VPWR VGND sg13g2_xor2_1
X_3038_ videogen.test_lut_thingy.pixel_feeder_inst.row\[34\]\[1\] net805 _0813_ _0320_
+ VPWR VGND sg13g2_mux2_1
XFILLER_24_611 VPWR VGND sg13g2_decap_8
XFILLER_36_482 VPWR VGND sg13g2_decap_8
X_4989_ net32 VGND VPWR _0343_ videogen.fancy_shader.video_y\[4\] net656 sg13g2_dfrbpq_2
XFILLER_11_349 VPWR VGND sg13g2_decap_8
X_5055__354 VPWR VGND net354 sg13g2_tiehi
XFILLER_11_32 VPWR VGND sg13g2_decap_8
XFILLER_11_43 VPWR VGND sg13g2_fill_1
XFILLER_3_548 VPWR VGND sg13g2_decap_8
XFILLER_11_87 VPWR VGND sg13g2_fill_1
XFILLER_47_725 VPWR VGND sg13g2_decap_8
X_5062__347 VPWR VGND net347 sg13g2_tiehi
XFILLER_46_202 VPWR VGND sg13g2_decap_8
XFILLER_15_611 VPWR VGND sg13g2_fill_1
XFILLER_36_40 VPWR VGND sg13g2_decap_8
XFILLER_36_51 VPWR VGND sg13g2_fill_1
XFILLER_27_482 VPWR VGND sg13g2_fill_1
XFILLER_7_810 VPWR VGND sg13g2_decap_8
X_5051__79 VPWR VGND net79 sg13g2_tiehi
XFILLER_10_360 VPWR VGND sg13g2_fill_1
XFILLER_7_854 VPWR VGND sg13g2_decap_8
XFILLER_6_353 VPWR VGND sg13g2_decap_8
XFILLER_7_898 VPWR VGND sg13g2_fill_1
XFILLER_42_1001 VPWR VGND sg13g2_decap_8
XFILLER_2_581 VPWR VGND sg13g2_decap_8
X_4010_ _1659_ _1666_ _1670_ VPWR VGND sg13g2_nor2_1
XFILLER_28_4 VPWR VGND sg13g2_decap_4
X_5108__255 VPWR VGND net255 sg13g2_tiehi
X_4912_ net165 VGND VPWR _0266_ serialize.shift_reg_g\[9\] clknet_3_6_0_clk_regs sg13g2_dfrbpq_1
XFILLER_33_441 VPWR VGND sg13g2_fill_1
XFILLER_33_463 VPWR VGND sg13g2_fill_1
X_4843_ net702 net746 _0200_ VPWR VGND sg13g2_nor2_1
XFILLER_21_625 VPWR VGND sg13g2_fill_1
X_4774_ net701 net745 _0131_ VPWR VGND sg13g2_nor2_1
X_3725_ net640 _1383_ _1388_ _1389_ VPWR VGND sg13g2_nor3_1
XFILLER_20_179 VPWR VGND sg13g2_fill_2
X_3656_ net616 VPWR _1320_ VGND videogen.test_lut_thingy.pixel_feeder_inst.row\[22\]\[3\]
+ net605 sg13g2_o21ai_1
X_3587_ videogen.test_lut_thingy.pixel_feeder_inst.row\[63\]\[3\] net582 _1251_ VPWR
+ VGND sg13g2_nor2_1
X_5257_ net363 VGND VPWR _0607_ videogen.test_lut_thingy.pixel_feeder_inst.row\[39\]\[3\]
+ _0236_ sg13g2_dfrbpq_1
X_4208_ _1854_ _1863_ _1852_ _1865_ VPWR VGND sg13g2_nand3_1
X_5188_ net385 VGND VPWR _0538_ videogen.test_lut_thingy.pixel_feeder_inst.row\[26\]\[2\]
+ _0167_ sg13g2_dfrbpq_1
XFILLER_28_202 VPWR VGND sg13g2_fill_2
XFILLER_17_909 VPWR VGND sg13g2_decap_4
X_4139_ _1796_ _1788_ _1792_ VPWR VGND sg13g2_nand2_1
XFILLER_44_728 VPWR VGND sg13g2_fill_1
XFILLER_37_791 VPWR VGND sg13g2_decap_8
XFILLER_11_102 VPWR VGND sg13g2_fill_2
XFILLER_22_64 VPWR VGND sg13g2_decap_4
XFILLER_4_813 VPWR VGND sg13g2_decap_8
XFILLER_22_86 VPWR VGND sg13g2_decap_8
XFILLER_47_522 VPWR VGND sg13g2_decap_8
XFILLER_47_72 VPWR VGND sg13g2_decap_8
XFILLER_47_599 VPWR VGND sg13g2_decap_8
XFILLER_34_205 VPWR VGND sg13g2_fill_2
XFILLER_35_728 VPWR VGND sg13g2_decap_8
XFILLER_42_271 VPWR VGND sg13g2_decap_8
XFILLER_8_22 VPWR VGND sg13g2_decap_8
XFILLER_31_956 VPWR VGND sg13g2_decap_4
XFILLER_8_77 VPWR VGND sg13g2_fill_2
X_3510_ _1160_ _1161_ _1001_ _1174_ VPWR VGND _1163_ sg13g2_nand4_1
X_4490_ VGND VPWR _0685_ net627 _0508_ net773 sg13g2_a21oi_1
X_3441_ _1105_ _1102_ _1104_ VPWR VGND sg13g2_xnor2_1
X_3372_ videogen.fancy_shader.video_x\[5\] net630 _1036_ VPWR VGND sg13g2_nor2_1
X_5111_ net249 VGND VPWR _0461_ videogen.test_lut_thingy.pixel_feeder_inst.row\[8\]\[1\]
+ _0098_ sg13g2_dfrbpq_1
X_5042_ net370 VGND VPWR _0396_ videogen.test_lut_thingy.pixel_feeder_inst.row\[15\]\[1\]
+ _0042_ sg13g2_dfrbpq_1
X_5045__364 VPWR VGND net364 sg13g2_tiehi
XFILLER_38_599 VPWR VGND sg13g2_fill_2
XFILLER_38_566 VPWR VGND sg13g2_decap_4
XFILLER_25_205 VPWR VGND sg13g2_fill_1
XFILLER_43_19 VPWR VGND sg13g2_fill_1
X_4826_ net713 net757 _0183_ VPWR VGND sg13g2_nor2_1
X_4757_ net692 net736 _0114_ VPWR VGND sg13g2_nor2_1
X_4688_ net706 net750 _0045_ VPWR VGND sg13g2_nor2_1
X_3708_ videogen.test_lut_thingy.pixel_feeder_inst.row\[63\]\[2\] net581 _1372_ VPWR
+ VGND sg13g2_nor2_1
X_3639_ net636 _1291_ _1302_ _1303_ VPWR VGND sg13g2_nor3_1
X_4915__162 VPWR VGND net162 sg13g2_tiehi
XFILLER_1_805 VPWR VGND sg13g2_decap_8
X_5309_ net238 VGND VPWR _0659_ serialize.shift_reg_r\[5\] clknet_3_7_0_clk_regs sg13g2_dfrbpq_1
XFILLER_17_20 VPWR VGND sg13g2_fill_1
XFILLER_16_227 VPWR VGND sg13g2_decap_8
XFILLER_12_400 VPWR VGND sg13g2_fill_1
XFILLER_12_411 VPWR VGND sg13g2_fill_1
XFILLER_13_912 VPWR VGND sg13g2_decap_8
XFILLER_24_260 VPWR VGND sg13g2_fill_2
XFILLER_40_742 VPWR VGND sg13g2_fill_1
XFILLER_8_459 VPWR VGND sg13g2_fill_1
XFILLER_8_448 VPWR VGND sg13g2_fill_2
X_5175__53 VPWR VGND net53 sg13g2_tiehi
XFILLER_4_687 VPWR VGND sg13g2_decap_8
XFILLER_48_820 VPWR VGND sg13g2_decap_8
Xhold4 serialize.shift_reg_c\[4\] VPWR VGND net449 sg13g2_dlygate4sd3_1
XFILLER_47_330 VPWR VGND sg13g2_decap_8
XFILLER_48_897 VPWR VGND sg13g2_decap_8
XFILLER_35_503 VPWR VGND sg13g2_fill_1
X_3990_ VGND VPWR _1646_ _1650_ _1091_ _1090_ sg13g2_a21oi_2
XFILLER_35_569 VPWR VGND sg13g2_decap_8
XFILLER_15_260 VPWR VGND sg13g2_fill_1
X_2941_ videogen.test_lut_thingy.pixel_feeder_inst.row\[5\]\[1\] net804 _0792_ _0457_
+ VPWR VGND sg13g2_mux2_1
XFILLER_31_720 VPWR VGND sg13g2_decap_8
X_4611_ VPWR _0645_ _2220_ VGND sg13g2_inv_1
XFILLER_30_263 VPWR VGND sg13g2_decap_8
X_2872_ videogen.test_lut_thingy.pixel_feeder_inst.row\[36\]\[3\] net784 _0777_ _0519_
+ VPWR VGND sg13g2_mux2_1
XFILLER_31_764 VPWR VGND sg13g2_fill_1
XFILLER_31_786 VPWR VGND sg13g2_fill_2
X_4542_ _2167_ _2163_ _2169_ VPWR VGND sg13g2_xor2_1
X_4473_ _2108_ _2100_ _2107_ VPWR VGND sg13g2_nand2_1
X_3424_ _1087_ _1086_ _1088_ VPWR VGND sg13g2_xor2_1
X_3355_ videogen.fancy_shader.video_x\[4\] net631 _1019_ VPWR VGND sg13g2_nor2_1
X_3286_ videogen.fancy_shader.video_y\[1\] _0962_ _0964_ VPWR VGND sg13g2_and2_1
XFILLER_39_853 VPWR VGND sg13g2_fill_2
X_5025_ net401 VGND VPWR _0379_ videogen.test_lut_thingy.pixel_feeder_inst.row\[13\]\[3\]
+ _0028_ sg13g2_dfrbpq_1
XFILLER_22_731 VPWR VGND sg13g2_fill_2
XFILLER_10_937 VPWR VGND sg13g2_decap_8
XFILLER_16_1028 VPWR VGND sg13g2_fill_1
X_4809_ net683 net727 _0166_ VPWR VGND sg13g2_nor2_1
XFILLER_1_602 VPWR VGND sg13g2_decap_8
XFILLER_49_628 VPWR VGND sg13g2_decap_8
XFILLER_1_679 VPWR VGND sg13g2_decap_8
XFILLER_28_63 VPWR VGND sg13g2_decap_4
XFILLER_44_300 VPWR VGND sg13g2_fill_1
XFILLER_45_878 VPWR VGND sg13g2_decap_8
XFILLER_44_366 VPWR VGND sg13g2_decap_8
XFILLER_44_62 VPWR VGND sg13g2_decap_8
XFILLER_13_720 VPWR VGND sg13g2_fill_2
XFILLER_13_742 VPWR VGND sg13g2_fill_1
XFILLER_9_724 VPWR VGND sg13g2_decap_8
XFILLER_12_241 VPWR VGND sg13g2_fill_2
XFILLER_13_786 VPWR VGND sg13g2_decap_4
XFILLER_9_746 VPWR VGND sg13g2_decap_8
XFILLER_9_757 VPWR VGND sg13g2_decap_8
XFILLER_5_985 VPWR VGND sg13g2_decap_8
XFILLER_5_34 VPWR VGND sg13g2_decap_8
XFILLER_5_56 VPWR VGND sg13g2_fill_1
X_3140_ net450 net672 _0269_ VPWR VGND sg13g2_and2_1
XFILLER_39_105 VPWR VGND sg13g2_fill_2
XFILLER_39_127 VPWR VGND sg13g2_fill_2
X_3071_ _0680_ _0700_ _0833_ VPWR VGND sg13g2_and2_1
XFILLER_48_694 VPWR VGND sg13g2_decap_8
X_4977__56 VPWR VGND net56 sg13g2_tiehi
X_3973_ _1633_ _1631_ _1632_ VPWR VGND sg13g2_nand2_2
X_2924_ net779 videogen.test_lut_thingy.pixel_feeder_inst.row\[58\]\[3\] _0789_ _0471_
+ VPWR VGND sg13g2_mux2_1
X_2855_ videogen.test_lut_thingy.pixel_feeder_inst.row\[35\]\[0\] net815 _0773_ _0532_
+ VPWR VGND sg13g2_mux2_1
X_4992__440 VPWR VGND net440 sg13g2_tiehi
X_2786_ videogen.test_lut_thingy.pixel_feeder_inst.row\[40\]\[2\] net796 _0758_ _0586_
+ VPWR VGND sg13g2_mux2_1
X_4525_ _2153_ _2144_ _2152_ VPWR VGND sg13g2_xnor2_1
X_4456_ _0683_ VPWR _2091_ VGND green\[7\] green\[6\] sg13g2_o21ai_1
Xfanout703 net704 net703 VPWR VGND sg13g2_buf_2
Xfanout714 net723 net714 VPWR VGND sg13g2_buf_8
X_4387_ _2036_ _2018_ _2035_ VPWR VGND sg13g2_xnor2_1
X_3407_ _1067_ _1069_ _1061_ _1071_ VPWR VGND sg13g2_nand3_1
X_4912__165 VPWR VGND net165 sg13g2_tiehi
Xfanout747 net748 net747 VPWR VGND sg13g2_buf_2
Xfanout725 net729 net725 VPWR VGND sg13g2_buf_8
X_3338_ _0991_ VPWR _1002_ VGND _0990_ _0992_ sg13g2_o21ai_1
Xfanout736 net738 net736 VPWR VGND sg13g2_buf_8
Xfanout758 net767 net758 VPWR VGND sg13g2_buf_8
Xfanout769 net771 net769 VPWR VGND sg13g2_buf_8
Xclkbuf_3_0_0_clk_regs clknet_0_clk_regs clknet_3_0_0_clk_regs VPWR VGND sg13g2_buf_8
X_3269_ _0688_ _0951_ _0953_ VPWR VGND sg13g2_nor2_1
XFILLER_22_1021 VPWR VGND sg13g2_decap_8
XFILLER_39_683 VPWR VGND sg13g2_decap_8
X_5008_ net421 VGND VPWR _0362_ red\[2\] net664 sg13g2_dfrbpq_2
XFILLER_27_845 VPWR VGND sg13g2_decap_8
XFILLER_14_506 VPWR VGND sg13g2_decap_8
XFILLER_14_517 VPWR VGND sg13g2_fill_2
XFILLER_26_377 VPWR VGND sg13g2_fill_2
XFILLER_27_889 VPWR VGND sg13g2_decap_8
XFILLER_26_399 VPWR VGND sg13g2_fill_2
XFILLER_6_738 VPWR VGND sg13g2_decap_4
XFILLER_5_237 VPWR VGND sg13g2_fill_1
XFILLER_30_86 VPWR VGND sg13g2_fill_1
XFILLER_2_944 VPWR VGND sg13g2_decap_8
XFILLER_7_1015 VPWR VGND sg13g2_decap_8
XFILLER_1_454 VPWR VGND sg13g2_decap_8
XFILLER_49_425 VPWR VGND sg13g2_decap_8
XFILLER_18_845 VPWR VGND sg13g2_fill_2
XFILLER_45_642 VPWR VGND sg13g2_decap_8
XFILLER_17_344 VPWR VGND sg13g2_decap_4
XFILLER_32_303 VPWR VGND sg13g2_fill_1
XFILLER_17_399 VPWR VGND sg13g2_decap_4
XFILLER_33_848 VPWR VGND sg13g2_fill_1
XFILLER_13_561 VPWR VGND sg13g2_fill_2
XFILLER_32_358 VPWR VGND sg13g2_fill_2
X_5072__327 VPWR VGND net327 sg13g2_tiehi
XFILLER_9_554 VPWR VGND sg13g2_fill_1
X_5290_ net55 VGND VPWR _0640_ serialize.shift_reg_b\[2\] clknet_3_3_0_clk_regs sg13g2_dfrbpq_1
XFILLER_5_782 VPWR VGND sg13g2_decap_8
X_4310_ _1962_ _1960_ _1961_ VPWR VGND sg13g2_nand2_1
XFILLER_45_1010 VPWR VGND sg13g2_decap_8
X_4241_ _1743_ _0999_ _1898_ VPWR VGND sg13g2_xor2_1
X_4172_ _1828_ _1745_ _1829_ VPWR VGND sg13g2_xor2_1
XFILLER_28_609 VPWR VGND sg13g2_fill_1
X_3123_ serialize.shift_reg_r\[1\] serialize.shift_reg_r\[0\] clknet_1_1__leaf_clk
+ net6 VPWR VGND sg13g2_mux2_1
XFILLER_49_992 VPWR VGND sg13g2_decap_8
X_3054_ videogen.test_lut_thingy.pixel_feeder_inst.row\[20\]\[0\] net817 _0816_ _0274_
+ VPWR VGND sg13g2_mux2_1
XFILLER_48_491 VPWR VGND sg13g2_decap_8
XFILLER_36_686 VPWR VGND sg13g2_decap_8
X_3956_ _1615_ _1616_ _1617_ _1618_ _1619_ VPWR VGND sg13g2_nor4_1
XFILLER_23_358 VPWR VGND sg13g2_decap_8
X_5118__235 VPWR VGND net235 sg13g2_tiehi
X_2907_ net809 videogen.test_lut_thingy.pixel_feeder_inst.row\[0\]\[0\] _0785_ _0484_
+ VPWR VGND sg13g2_mux2_1
X_3887_ net616 _1544_ _1549_ _1550_ VPWR VGND sg13g2_nor3_1
X_2838_ videogen.test_lut_thingy.pixel_feeder_inst.row\[4\]\[2\] net794 _0770_ _0546_
+ VPWR VGND sg13g2_mux2_1
X_2769_ net810 videogen.test_lut_thingy.pixel_feeder_inst.row\[59\]\[0\] _0751_ _0596_
+ VPWR VGND sg13g2_mux2_1
X_4508_ VGND VPWR _2128_ _2135_ _0512_ _2136_ sg13g2_a21oi_1
X_4439_ _2056_ _2065_ _2074_ _2075_ VPWR VGND sg13g2_nor3_1
Xfanout555 _1958_ net555 VPWR VGND sg13g2_buf_8
Xfanout566 _0961_ net566 VPWR VGND sg13g2_buf_8
XFILLER_47_907 VPWR VGND sg13g2_decap_8
Xfanout577 net578 net577 VPWR VGND sg13g2_buf_8
Xfanout588 net589 net588 VPWR VGND sg13g2_buf_8
Xfanout599 _0709_ net599 VPWR VGND sg13g2_buf_8
XFILLER_27_620 VPWR VGND sg13g2_fill_2
XFILLER_26_141 VPWR VGND sg13g2_decap_8
XFILLER_42_667 VPWR VGND sg13g2_decap_8
XFILLER_41_133 VPWR VGND sg13g2_decap_8
XFILLER_10_575 VPWR VGND sg13g2_fill_2
XFILLER_41_85 VPWR VGND sg13g2_fill_2
XFILLER_6_579 VPWR VGND sg13g2_decap_4
XFILLER_2_741 VPWR VGND sg13g2_decap_8
XFILLER_49_233 VPWR VGND sg13g2_fill_1
XFILLER_49_211 VPWR VGND sg13g2_decap_8
XFILLER_49_266 VPWR VGND sg13g2_decap_4
XFILLER_37_439 VPWR VGND sg13g2_decap_8
XFILLER_37_428 VPWR VGND sg13g2_decap_4
XFILLER_46_995 VPWR VGND sg13g2_decap_8
XFILLER_17_141 VPWR VGND sg13g2_decap_4
XFILLER_45_483 VPWR VGND sg13g2_decap_4
X_3810_ net612 _1468_ _1473_ _1474_ VPWR VGND sg13g2_nor3_1
X_4790_ net718 net762 _0147_ VPWR VGND sg13g2_nor2_1
X_3741_ videogen.test_lut_thingy.pixel_feeder_inst.row\[10\]\[2\] net600 _1405_ VPWR
+ VGND sg13g2_nor2_1
XFILLER_32_166 VPWR VGND sg13g2_decap_8
XFILLER_9_351 VPWR VGND sg13g2_fill_1
X_3672_ _1332_ _1333_ _1334_ _1335_ _1336_ VPWR VGND sg13g2_nor4_1
XFILLER_49_0 VPWR VGND sg13g2_decap_8
X_5273_ net266 VGND VPWR _0623_ videogen.test_lut_thingy.pixel_feeder_inst.row\[25\]\[1\]
+ _0242_ sg13g2_dfrbpq_1
X_4224_ VPWR _1881_ _1880_ VGND sg13g2_inv_1
X_4155_ _1811_ _1744_ _1812_ VPWR VGND sg13g2_nor2b_1
X_3106_ _0857_ _0679_ _0853_ VPWR VGND sg13g2_xnor2_1
XFILLER_28_428 VPWR VGND sg13g2_fill_1
X_4086_ _1743_ _0993_ _1169_ VPWR VGND sg13g2_nand2_2
X_3037_ videogen.test_lut_thingy.pixel_feeder_inst.row\[34\]\[2\] net795 _0813_ _0321_
+ VPWR VGND sg13g2_mux2_1
XFILLER_37_995 VPWR VGND sg13g2_fill_2
XFILLER_37_973 VPWR VGND sg13g2_decap_8
XFILLER_23_111 VPWR VGND sg13g2_fill_1
XFILLER_23_122 VPWR VGND sg13g2_fill_2
XFILLER_23_133 VPWR VGND sg13g2_decap_8
X_4988_ net34 VGND VPWR _0342_ videogen.fancy_shader.video_y\[3\] net656 sg13g2_dfrbpq_2
X_3939_ videogen.test_lut_thingy.pixel_feeder_inst.row\[38\]\[0\] net606 _1602_ VPWR
+ VGND sg13g2_nor2_1
XFILLER_3_527 VPWR VGND sg13g2_decap_8
XFILLER_47_704 VPWR VGND sg13g2_decap_8
XFILLER_19_428 VPWR VGND sg13g2_fill_1
XFILLER_19_439 VPWR VGND sg13g2_decap_4
XFILLER_27_450 VPWR VGND sg13g2_fill_1
XFILLER_36_63 VPWR VGND sg13g2_decap_8
XFILLER_43_954 VPWR VGND sg13g2_fill_2
XFILLER_36_74 VPWR VGND sg13g2_fill_2
XFILLER_11_873 VPWR VGND sg13g2_decap_8
X_4932__135 VPWR VGND net135 sg13g2_tiehi
XFILLER_2_560 VPWR VGND sg13g2_decap_8
XFILLER_38_737 VPWR VGND sg13g2_fill_2
XFILLER_37_236 VPWR VGND sg13g2_fill_1
XFILLER_19_984 VPWR VGND sg13g2_decap_8
XFILLER_46_792 VPWR VGND sg13g2_decap_8
XFILLER_18_483 VPWR VGND sg13g2_fill_1
X_4911_ net166 VGND VPWR _0265_ serialize.shift_reg_g\[8\] clknet_3_5_0_clk_regs sg13g2_dfrbpq_1
X_4842_ net715 net759 _0199_ VPWR VGND sg13g2_nor2_1
X_4773_ net697 net741 _0130_ VPWR VGND sg13g2_nor2_1
XFILLER_21_648 VPWR VGND sg13g2_decap_8
XFILLER_21_659 VPWR VGND sg13g2_fill_2
X_3724_ _1384_ _1385_ _1386_ _1387_ _1388_ VPWR VGND sg13g2_nor4_1
XFILLER_20_169 VPWR VGND sg13g2_decap_4
X_3655_ _1315_ _1316_ _1317_ _1318_ _1319_ VPWR VGND sg13g2_nor4_1
X_3586_ net644 VPWR _1250_ VGND videogen.test_lut_thingy.pixel_feeder_inst.row\[60\]\[3\]
+ net592 sg13g2_o21ai_1
X_5256_ net371 VGND VPWR _0606_ videogen.test_lut_thingy.pixel_feeder_inst.row\[39\]\[2\]
+ _0235_ sg13g2_dfrbpq_1
X_4207_ _1864_ _1854_ _1863_ VPWR VGND sg13g2_nand2_1
X_5187_ net392 VGND VPWR _0537_ videogen.test_lut_thingy.pixel_feeder_inst.row\[26\]\[1\]
+ _0166_ sg13g2_dfrbpq_1
XFILLER_28_214 VPWR VGND sg13g2_decap_8
X_4138_ _1794_ _1792_ _1795_ VPWR VGND sg13g2_nor2b_1
XFILLER_28_225 VPWR VGND sg13g2_fill_2
XFILLER_29_759 VPWR VGND sg13g2_decap_8
X_4069_ VGND VPWR _1712_ _1727_ _1729_ _1702_ sg13g2_a21oi_1
XFILLER_24_497 VPWR VGND sg13g2_decap_4
X_5313__206 VPWR VGND net206 sg13g2_tiehi
XFILLER_7_129 VPWR VGND sg13g2_decap_4
XFILLER_22_43 VPWR VGND sg13g2_decap_8
XFILLER_3_302 VPWR VGND sg13g2_decap_4
XFILLER_4_869 VPWR VGND sg13g2_decap_8
XFILLER_3_335 VPWR VGND sg13g2_decap_8
XFILLER_47_501 VPWR VGND sg13g2_decap_8
XFILLER_47_578 VPWR VGND sg13g2_decap_8
XFILLER_19_269 VPWR VGND sg13g2_fill_1
XFILLER_35_707 VPWR VGND sg13g2_decap_8
XFILLER_16_921 VPWR VGND sg13g2_decap_8
XFILLER_15_442 VPWR VGND sg13g2_fill_2
XFILLER_30_401 VPWR VGND sg13g2_decap_4
X_3440_ _1103_ _1065_ _1104_ VPWR VGND sg13g2_xor2_1
X_3371_ _1035_ _1034_ _1033_ VPWR VGND sg13g2_nand2b_1
X_5110_ net251 VGND VPWR _0460_ videogen.test_lut_thingy.pixel_feeder_inst.row\[8\]\[0\]
+ _0097_ sg13g2_dfrbpq_1
X_5041_ net372 VGND VPWR _0395_ videogen.test_lut_thingy.pixel_feeder_inst.row\[15\]\[0\]
+ _0041_ sg13g2_dfrbpq_1
XFILLER_38_545 VPWR VGND sg13g2_decap_8
XFILLER_26_729 VPWR VGND sg13g2_decap_8
X_5299__367 VPWR VGND net367 sg13g2_tiehi
XFILLER_19_781 VPWR VGND sg13g2_decap_8
XFILLER_22_902 VPWR VGND sg13g2_fill_1
XFILLER_34_740 VPWR VGND sg13g2_fill_2
X_4825_ net714 net758 _0182_ VPWR VGND sg13g2_nor2_1
XFILLER_21_489 VPWR VGND sg13g2_fill_1
X_5017__412 VPWR VGND net412 sg13g2_tiehi
X_4756_ net693 net737 _0113_ VPWR VGND sg13g2_nor2_1
X_3707_ net638 VPWR _1371_ VGND videogen.test_lut_thingy.pixel_feeder_inst.row\[60\]\[2\]
+ net592 sg13g2_o21ai_1
X_5052__358 VPWR VGND net358 sg13g2_tiehi
X_4687_ net707 net751 _0044_ VPWR VGND sg13g2_nor2_1
X_3638_ net612 _1296_ _1301_ _1302_ VPWR VGND sg13g2_nor3_1
X_3569_ net1 VPWR _1233_ VGND _1177_ _1232_ sg13g2_o21ai_1
X_5308_ net246 VGND VPWR _0658_ serialize.shift_reg_r\[4\] clknet_3_7_0_clk_regs sg13g2_dfrbpq_1
X_5239_ net152 VGND VPWR _0589_ videogen.test_lut_thingy.pixel_feeder_inst.row\[3\]\[1\]
+ _0218_ sg13g2_dfrbpq_1
XFILLER_44_559 VPWR VGND sg13g2_decap_8
XFILLER_40_721 VPWR VGND sg13g2_fill_2
XFILLER_31_209 VPWR VGND sg13g2_decap_8
XFILLER_40_732 VPWR VGND sg13g2_fill_2
XFILLER_13_946 VPWR VGND sg13g2_decap_8
XFILLER_13_968 VPWR VGND sg13g2_fill_1
XFILLER_33_31 VPWR VGND sg13g2_fill_2
XFILLER_8_427 VPWR VGND sg13g2_fill_1
XFILLER_8_416 VPWR VGND sg13g2_fill_1
XFILLER_4_666 VPWR VGND sg13g2_decap_8
Xhold5 serialize.shift_reg_c\[2\] VPWR VGND net450 sg13g2_dlygate4sd3_1
XFILLER_48_876 VPWR VGND sg13g2_decap_8
XFILLER_47_397 VPWR VGND sg13g2_decap_4
XFILLER_47_375 VPWR VGND sg13g2_decap_8
X_4989__32 VPWR VGND net32 sg13g2_tiehi
XFILLER_35_537 VPWR VGND sg13g2_decap_8
XFILLER_16_762 VPWR VGND sg13g2_fill_2
XFILLER_16_773 VPWR VGND sg13g2_decap_8
X_2940_ videogen.test_lut_thingy.pixel_feeder_inst.row\[5\]\[2\] net793 _0792_ _0458_
+ VPWR VGND sg13g2_mux2_1
X_2871_ _0740_ _0764_ _0777_ VPWR VGND sg13g2_nor2_2
X_4610_ _2220_ net670 net461 net675 serialize.tmds_parallel_b\[7\] VPWR VGND sg13g2_a22oi_1
X_4541_ _2163_ _2167_ _2168_ VPWR VGND sg13g2_nor2b_1
XFILLER_8_994 VPWR VGND sg13g2_decap_8
X_4472_ _2107_ _2105_ _2106_ VPWR VGND sg13g2_xnor2_1
X_3423_ _1087_ videogen.fancy_shader.video_y\[9\] videogen.fancy_shader.shader_counter_reg\[9\]
+ VPWR VGND sg13g2_xnor2_1
X_3354_ _1018_ videogen.fancy_shader.video_x\[4\] net631 VPWR VGND sg13g2_nand2_1
XFILLER_31_0 VPWR VGND sg13g2_decap_4
X_3285_ _0962_ _0963_ _0339_ VPWR VGND sg13g2_nor2_1
X_5082__307 VPWR VGND net307 sg13g2_tiehi
X_5024_ net403 VGND VPWR _0378_ videogen.test_lut_thingy.pixel_feeder_inst.row\[13\]\[2\]
+ _0027_ sg13g2_dfrbpq_1
XFILLER_38_386 VPWR VGND sg13g2_decap_4
XFILLER_0_1010 VPWR VGND sg13g2_decap_8
XFILLER_26_548 VPWR VGND sg13g2_decap_8
X_5156__113 VPWR VGND net113 sg13g2_tiehi
XFILLER_34_581 VPWR VGND sg13g2_decap_8
XFILLER_21_242 VPWR VGND sg13g2_decap_8
X_4808_ net682 net726 _0165_ VPWR VGND sg13g2_nor2_1
XFILLER_21_286 VPWR VGND sg13g2_decap_8
X_4739_ net712 net756 _0096_ VPWR VGND sg13g2_nor2_1
XFILLER_49_607 VPWR VGND sg13g2_decap_8
XFILLER_0_113 VPWR VGND sg13g2_decap_8
XFILLER_1_658 VPWR VGND sg13g2_decap_8
X_5128__215 VPWR VGND net215 sg13g2_tiehi
XFILLER_48_117 VPWR VGND sg13g2_fill_2
XFILLER_48_106 VPWR VGND sg13g2_decap_8
XFILLER_28_42 VPWR VGND sg13g2_decap_8
X_5278__226 VPWR VGND net226 sg13g2_tiehi
XFILLER_29_386 VPWR VGND sg13g2_decap_4
XFILLER_45_857 VPWR VGND sg13g2_decap_8
XFILLER_40_595 VPWR VGND sg13g2_fill_1
XFILLER_8_224 VPWR VGND sg13g2_fill_1
XFILLER_5_964 VPWR VGND sg13g2_decap_8
X_3070_ videogen.fancy_shader.video_x\[6\] _0831_ _0832_ VPWR VGND sg13g2_and2_1
X_5007__422 VPWR VGND net422 sg13g2_tiehi
XFILLER_36_802 VPWR VGND sg13g2_decap_8
XFILLER_48_673 VPWR VGND sg13g2_decap_8
X_3972_ _1632_ _1012_ _1630_ VPWR VGND sg13g2_nand2_2
X_2923_ _0789_ _0750_ _0760_ VPWR VGND sg13g2_nand2_2
X_2854_ videogen.test_lut_thingy.pixel_feeder_inst.row\[35\]\[1\] net805 _0773_ _0533_
+ VPWR VGND sg13g2_mux2_1
X_2785_ videogen.test_lut_thingy.pixel_feeder_inst.row\[40\]\[3\] net778 _0758_ _0587_
+ VPWR VGND sg13g2_mux2_1
X_4524_ VGND VPWR _2132_ _2141_ _2152_ _2133_ sg13g2_a21oi_1
X_5014__415 VPWR VGND net415 sg13g2_tiehi
X_4455_ _2090_ tmds_green.dc_balancing_reg\[3\] _2072_ VPWR VGND sg13g2_xnor2_1
Xfanout715 net717 net715 VPWR VGND sg13g2_buf_8
Xfanout704 net724 net704 VPWR VGND sg13g2_buf_8
X_4386_ _2035_ _2032_ _2034_ VPWR VGND sg13g2_xnor2_1
X_3406_ _1070_ _1067_ _1069_ VPWR VGND sg13g2_nand2_1
Xfanout726 net729 net726 VPWR VGND sg13g2_buf_1
X_3337_ _1001_ _0994_ _0999_ VPWR VGND sg13g2_xnor2_1
Xfanout737 net738 net737 VPWR VGND sg13g2_buf_1
Xfanout748 net768 net748 VPWR VGND sg13g2_buf_8
Xfanout759 net761 net759 VPWR VGND sg13g2_buf_8
XFILLER_22_1000 VPWR VGND sg13g2_decap_8
XFILLER_39_662 VPWR VGND sg13g2_decap_8
X_3268_ VGND VPWR _0689_ _0949_ _0333_ _0952_ sg13g2_a21oi_1
X_3199_ _0904_ videogen.test_lut_thingy.pixel_feeder_inst.h_counter\[3\] _0820_ VPWR
+ VGND sg13g2_nand2_1
X_5007_ net422 VGND VPWR _0361_ green\[7\] net664 sg13g2_dfrbpq_2
XFILLER_42_805 VPWR VGND sg13g2_decap_4
XFILLER_38_183 VPWR VGND sg13g2_decap_4
X_5021__408 VPWR VGND net408 sg13g2_tiehi
XFILLER_27_857 VPWR VGND sg13g2_decap_8
XFILLER_41_304 VPWR VGND sg13g2_fill_1
XFILLER_22_551 VPWR VGND sg13g2_fill_1
XFILLER_10_735 VPWR VGND sg13g2_fill_2
XFILLER_22_584 VPWR VGND sg13g2_decap_4
XFILLER_30_32 VPWR VGND sg13g2_fill_2
XFILLER_2_923 VPWR VGND sg13g2_decap_8
XFILLER_30_98 VPWR VGND sg13g2_fill_2
XFILLER_39_74 VPWR VGND sg13g2_decap_4
XFILLER_45_621 VPWR VGND sg13g2_decap_8
XFILLER_17_312 VPWR VGND sg13g2_fill_1
XFILLER_29_172 VPWR VGND sg13g2_fill_1
XFILLER_44_131 VPWR VGND sg13g2_fill_1
XFILLER_45_698 VPWR VGND sg13g2_decap_8
XFILLER_17_367 VPWR VGND sg13g2_fill_1
XFILLER_44_197 VPWR VGND sg13g2_fill_1
XFILLER_44_186 VPWR VGND sg13g2_fill_2
XFILLER_32_337 VPWR VGND sg13g2_decap_8
XFILLER_41_871 VPWR VGND sg13g2_decap_8
XFILLER_13_540 VPWR VGND sg13g2_decap_8
XFILLER_9_511 VPWR VGND sg13g2_decap_4
XFILLER_5_761 VPWR VGND sg13g2_decap_8
X_4240_ _1889_ _1886_ _1896_ _1897_ VPWR VGND sg13g2_a21o_1
X_4171_ _1828_ _1138_ _1827_ VPWR VGND sg13g2_nand2_1
X_3122_ serialize.shift_reg_g\[1\] serialize.shift_reg_g\[0\] clknet_1_1__leaf_clk
+ net5 VPWR VGND sg13g2_mux2_1
XFILLER_49_971 VPWR VGND sg13g2_decap_8
XFILLER_48_470 VPWR VGND sg13g2_decap_8
X_3053_ videogen.test_lut_thingy.pixel_feeder_inst.row\[20\]\[1\] net804 _0816_ _0275_
+ VPWR VGND sg13g2_mux2_1
XFILLER_35_131 VPWR VGND sg13g2_decap_4
XFILLER_36_665 VPWR VGND sg13g2_decap_8
XFILLER_24_849 VPWR VGND sg13g2_decap_8
XFILLER_35_197 VPWR VGND sg13g2_decap_4
X_3955_ videogen.test_lut_thingy.pixel_feeder_inst.row\[35\]\[0\] net586 _1618_ VPWR
+ VGND sg13g2_nor2_1
X_2906_ net799 videogen.test_lut_thingy.pixel_feeder_inst.row\[0\]\[1\] _0785_ _0485_
+ VPWR VGND sg13g2_mux2_1
X_3886_ _1545_ _1546_ _1547_ _1548_ _1549_ VPWR VGND sg13g2_nor4_1
X_2837_ videogen.test_lut_thingy.pixel_feeder_inst.row\[4\]\[3\] net784 _0770_ _0547_
+ VPWR VGND sg13g2_mux2_1
X_2768_ net800 videogen.test_lut_thingy.pixel_feeder_inst.row\[59\]\[1\] _0751_ _0597_
+ VPWR VGND sg13g2_mux2_1
X_4507_ _0960_ VPWR _2136_ VGND _2128_ _2135_ sg13g2_o21ai_1
X_2699_ _0717_ net562 _0716_ VPWR VGND sg13g2_nand2_1
X_4438_ _2072_ tmds_green.dc_balancing_reg\[2\] _2074_ VPWR VGND sg13g2_xor2_1
X_4369_ _2019_ _2005_ _2017_ VPWR VGND sg13g2_xnor2_1
Xfanout556 _1958_ net556 VPWR VGND sg13g2_buf_1
Xfanout589 net599 net589 VPWR VGND sg13g2_buf_8
Xfanout578 net582 net578 VPWR VGND sg13g2_buf_8
Xfanout567 net568 net567 VPWR VGND sg13g2_buf_8
X_5240__144 VPWR VGND net144 sg13g2_tiehi
XFILLER_27_654 VPWR VGND sg13g2_fill_1
XFILLER_42_646 VPWR VGND sg13g2_decap_8
XFILLER_26_186 VPWR VGND sg13g2_fill_1
XFILLER_25_87 VPWR VGND sg13g2_decap_8
XFILLER_6_536 VPWR VGND sg13g2_decap_8
XFILLER_6_503 VPWR VGND sg13g2_fill_1
X_4964__82 VPWR VGND net82 sg13g2_tiehi
XFILLER_2_720 VPWR VGND sg13g2_decap_8
X_5032__389 VPWR VGND net389 sg13g2_tiehi
XFILLER_1_230 VPWR VGND sg13g2_fill_2
XFILLER_2_797 VPWR VGND sg13g2_decap_8
XFILLER_49_245 VPWR VGND sg13g2_decap_8
XFILLER_2_36 VPWR VGND sg13g2_decap_4
XFILLER_46_974 VPWR VGND sg13g2_decap_8
XFILLER_33_602 VPWR VGND sg13g2_decap_8
X_5004__425 VPWR VGND net425 sg13g2_tiehi
XFILLER_21_819 VPWR VGND sg13g2_decap_4
XFILLER_33_668 VPWR VGND sg13g2_decap_4
X_3740_ videogen.test_lut_thingy.pixel_feeder_inst.row\[11\]\[2\] net577 _1404_ VPWR
+ VGND sg13g2_nor2_1
XFILLER_9_330 VPWR VGND sg13g2_decap_8
X_3671_ videogen.test_lut_thingy.pixel_feeder_inst.row\[41\]\[2\] net575 _1335_ VPWR
+ VGND sg13g2_nor2_1
XFILLER_12_1010 VPWR VGND sg13g2_decap_8
X_5011__418 VPWR VGND net418 sg13g2_tiehi
X_5272_ net274 VGND VPWR _0622_ videogen.test_lut_thingy.pixel_feeder_inst.row\[25\]\[0\]
+ _0241_ sg13g2_dfrbpq_1
X_4223_ _1874_ _1870_ _1880_ VPWR VGND _1879_ sg13g2_nand3b_1
X_4154_ VGND VPWR _1808_ _1810_ _1811_ _1806_ sg13g2_a21oi_1
X_3105_ _0679_ _0853_ _0856_ VPWR VGND sg13g2_nor2_1
X_4085_ _1742_ _1001_ _1172_ VPWR VGND sg13g2_xnor2_1
X_3036_ videogen.test_lut_thingy.pixel_feeder_inst.row\[34\]\[3\] net784 _0813_ _0322_
+ VPWR VGND sg13g2_mux2_1
XFILLER_36_495 VPWR VGND sg13g2_decap_8
XFILLER_23_156 VPWR VGND sg13g2_decap_4
XFILLER_11_318 VPWR VGND sg13g2_decap_4
X_4987_ net36 VGND VPWR _0341_ videogen.fancy_shader.video_y\[2\] net656 sg13g2_dfrbpq_2
XFILLER_23_167 VPWR VGND sg13g2_fill_2
XFILLER_32_690 VPWR VGND sg13g2_decap_4
X_3938_ videogen.test_lut_thingy.pixel_feeder_inst.row\[36\]\[0\] net597 _1601_ VPWR
+ VGND sg13g2_nor2_1
X_3869_ videogen.test_lut_thingy.pixel_feeder_inst.row\[4\]\[0\] net596 _1532_ VPWR
+ VGND sg13g2_nor2_1
XFILLER_14_101 VPWR VGND sg13g2_fill_1
XFILLER_15_679 VPWR VGND sg13g2_decap_8
XFILLER_11_863 VPWR VGND sg13g2_decap_4
XFILLER_7_845 VPWR VGND sg13g2_decap_4
X_5136__199 VPWR VGND net199 sg13g2_tiehi
XFILLER_7_889 VPWR VGND sg13g2_decap_8
XFILLER_35_7 VPWR VGND sg13g2_fill_2
XFILLER_38_705 VPWR VGND sg13g2_decap_4
XFILLER_37_248 VPWR VGND sg13g2_decap_8
XFILLER_46_771 VPWR VGND sg13g2_decap_8
XFILLER_19_974 VPWR VGND sg13g2_fill_2
XFILLER_45_281 VPWR VGND sg13g2_fill_2
X_4910_ net167 VGND VPWR _0264_ serialize.shift_reg_r\[9\] clknet_3_5_0_clk_regs sg13g2_dfrbpq_1
X_4841_ net715 net759 _0198_ VPWR VGND sg13g2_nor2_1
XFILLER_33_487 VPWR VGND sg13g2_decap_8
X_4772_ net701 net745 _0129_ VPWR VGND sg13g2_nor2_1
X_3723_ videogen.test_lut_thingy.pixel_feeder_inst.row\[19\]\[2\] net578 _1387_ VPWR
+ VGND sg13g2_nor2_1
X_3654_ videogen.test_lut_thingy.pixel_feeder_inst.row\[28\]\[3\] net594 _1318_ VPWR
+ VGND sg13g2_nor2_1
X_3585_ _1245_ _1246_ _1247_ _1248_ _1249_ VPWR VGND sg13g2_nor4_1
X_5255_ net379 VGND VPWR _0605_ videogen.test_lut_thingy.pixel_feeder_inst.row\[39\]\[1\]
+ _0234_ sg13g2_dfrbpq_1
X_4206_ _1859_ VPWR _1863_ VGND _1849_ _1856_ sg13g2_o21ai_1
X_5186_ net396 VGND VPWR _0536_ videogen.test_lut_thingy.pixel_feeder_inst.row\[26\]\[0\]
+ _0165_ sg13g2_dfrbpq_1
XFILLER_29_727 VPWR VGND sg13g2_decap_4
X_4137_ _1794_ _1685_ _1793_ VPWR VGND sg13g2_xnor2_1
X_4068_ _1728_ _1702_ _1712_ _1727_ VPWR VGND sg13g2_and3_1
X_3019_ net809 videogen.test_lut_thingy.pixel_feeder_inst.row\[17\]\[0\] _0809_ _0387_
+ VPWR VGND sg13g2_mux2_1
XFILLER_8_609 VPWR VGND sg13g2_fill_2
XFILLER_22_11 VPWR VGND sg13g2_fill_1
XFILLER_4_848 VPWR VGND sg13g2_decap_8
XFILLER_19_237 VPWR VGND sg13g2_decap_8
XFILLER_47_557 VPWR VGND sg13g2_decap_8
XFILLER_28_793 VPWR VGND sg13g2_decap_8
XFILLER_34_218 VPWR VGND sg13g2_fill_2
X_5001__428 VPWR VGND net428 sg13g2_tiehi
XFILLER_43_785 VPWR VGND sg13g2_fill_2
X_5178__41 VPWR VGND net41 sg13g2_tiehi
XFILLER_7_686 VPWR VGND sg13g2_decap_4
X_3370_ VGND VPWR _1034_ videogen.fancy_shader.shader_counter_reg\[6\] videogen.fancy_shader.video_x\[6\]
+ sg13g2_or2_1
XFILLER_3_881 VPWR VGND sg13g2_decap_8
X_5040_ net374 VGND VPWR _0394_ videogen.test_lut_thingy.pixel_feeder_inst.row\[16\]\[3\]
+ _0040_ sg13g2_dfrbpq_1
XFILLER_2_380 VPWR VGND sg13g2_fill_1
XFILLER_33_251 VPWR VGND sg13g2_fill_2
X_4824_ net713 net757 _0181_ VPWR VGND sg13g2_nor2_1
X_4755_ net694 net738 _0112_ VPWR VGND sg13g2_nor2_1
X_3706_ _1366_ _1367_ _1368_ _1369_ _1370_ VPWR VGND sg13g2_nor4_1
X_4686_ net690 net733 _0043_ VPWR VGND sg13g2_nor2_1
X_3637_ _1297_ _1298_ _1299_ _1300_ _1301_ VPWR VGND sg13g2_nor4_1
X_3568_ _1226_ _1228_ _1229_ _1231_ _1232_ VPWR VGND sg13g2_or4_1
X_5307_ net254 VGND VPWR _0657_ serialize.shift_reg_r\[3\] clknet_3_7_0_clk_regs sg13g2_dfrbpq_1
X_5089__293 VPWR VGND net293 sg13g2_tiehi
X_3499_ _1157_ _1162_ _1156_ _1163_ VPWR VGND sg13g2_nand3_1
XFILLER_25_1020 VPWR VGND sg13g2_decap_8
X_5238_ net172 VGND VPWR _0588_ videogen.test_lut_thingy.pixel_feeder_inst.row\[3\]\[0\]
+ _0217_ sg13g2_dfrbpq_1
XFILLER_29_502 VPWR VGND sg13g2_decap_8
X_5169_ net77 VGND VPWR _0519_ videogen.test_lut_thingy.pixel_feeder_inst.row\[36\]\[3\]
+ _0148_ sg13g2_dfrbpq_1
XFILLER_17_708 VPWR VGND sg13g2_fill_2
XFILLER_40_700 VPWR VGND sg13g2_decap_8
XFILLER_24_262 VPWR VGND sg13g2_fill_1
XFILLER_25_774 VPWR VGND sg13g2_decap_8
XFILLER_40_755 VPWR VGND sg13g2_decap_8
XFILLER_40_788 VPWR VGND sg13g2_decap_8
XFILLER_40_766 VPWR VGND sg13g2_fill_2
XFILLER_40_799 VPWR VGND sg13g2_fill_2
XFILLER_4_645 VPWR VGND sg13g2_decap_8
XFILLER_3_188 VPWR VGND sg13g2_decap_8
XFILLER_0_884 VPWR VGND sg13g2_decap_8
XFILLER_48_855 VPWR VGND sg13g2_decap_8
Xhold6 serialize.shift_reg_c\[5\] VPWR VGND net451 sg13g2_dlygate4sd3_1
XFILLER_16_741 VPWR VGND sg13g2_decap_8
XFILLER_43_593 VPWR VGND sg13g2_decap_8
X_2870_ net814 videogen.test_lut_thingy.pixel_feeder_inst.row\[2\]\[0\] _0776_ _0520_
+ VPWR VGND sg13g2_mux2_1
XFILLER_30_243 VPWR VGND sg13g2_decap_8
XFILLER_31_755 VPWR VGND sg13g2_decap_8
XFILLER_31_788 VPWR VGND sg13g2_fill_1
XFILLER_12_980 VPWR VGND sg13g2_decap_4
XFILLER_31_799 VPWR VGND sg13g2_fill_1
X_4540_ _2166_ _2165_ _2167_ VPWR VGND sg13g2_xor2_1
XFILLER_8_973 VPWR VGND sg13g2_decap_8
XFILLER_7_450 VPWR VGND sg13g2_fill_2
XFILLER_11_490 VPWR VGND sg13g2_decap_8
XFILLER_7_494 VPWR VGND sg13g2_decap_8
X_4471_ _2076_ VPWR _2106_ VGND _2066_ _2075_ sg13g2_o21ai_1
X_3422_ VGND VPWR _1078_ _1085_ _1086_ _1077_ sg13g2_a21oi_1
X_5149__154 VPWR VGND net154 sg13g2_tiehi
X_3353_ VPWR VGND _1014_ _1016_ _1002_ videogen.fancy_shader.video_x\[3\] _1017_ videogen.fancy_shader.shader_counter_reg\[3\]
+ sg13g2_a221oi_1
XFILLER_39_811 VPWR VGND sg13g2_decap_4
X_3284_ net818 VPWR _0963_ VGND net629 _0872_ sg13g2_o21ai_1
X_5023_ net405 VGND VPWR _0377_ videogen.test_lut_thingy.pixel_feeder_inst.row\[13\]\[1\]
+ _0026_ sg13g2_dfrbpq_1
XFILLER_39_877 VPWR VGND sg13g2_decap_4
XFILLER_39_855 VPWR VGND sg13g2_fill_1
XFILLER_26_527 VPWR VGND sg13g2_decap_8
XFILLER_0_91 VPWR VGND sg13g2_decap_8
XFILLER_22_711 VPWR VGND sg13g2_fill_2
X_4807_ net721 net766 _0164_ VPWR VGND sg13g2_nor2_1
X_2999_ videogen.test_lut_thingy.pixel_feeder_inst.row\[33\]\[0\] net815 _0805_ _0412_
+ VPWR VGND sg13g2_mux2_1
XFILLER_22_788 VPWR VGND sg13g2_fill_1
X_4952__106 VPWR VGND net106 sg13g2_tiehi
X_4738_ net708 net752 _0095_ VPWR VGND sg13g2_nor2_1
X_4669_ net707 net751 _0027_ VPWR VGND sg13g2_nor2_1
Xclkbuf_1_1__f_clk clknet_0_clk clknet_1_1__leaf_clk VPWR VGND sg13g2_buf_8
XFILLER_1_637 VPWR VGND sg13g2_decap_8
XFILLER_45_803 VPWR VGND sg13g2_fill_1
XFILLER_29_354 VPWR VGND sg13g2_decap_8
XFILLER_45_836 VPWR VGND sg13g2_decap_8
XFILLER_17_505 VPWR VGND sg13g2_fill_1
XFILLER_44_346 VPWR VGND sg13g2_fill_2
XFILLER_13_700 VPWR VGND sg13g2_decap_8
XFILLER_40_563 VPWR VGND sg13g2_fill_1
XFILLER_9_704 VPWR VGND sg13g2_decap_4
XFILLER_12_243 VPWR VGND sg13g2_fill_1
XFILLER_5_943 VPWR VGND sg13g2_decap_8
XFILLER_5_47 VPWR VGND sg13g2_decap_8
XFILLER_39_107 VPWR VGND sg13g2_fill_1
XFILLER_0_681 VPWR VGND sg13g2_decap_8
XFILLER_48_652 VPWR VGND sg13g2_decap_8
XFILLER_36_814 VPWR VGND sg13g2_fill_2
XFILLER_35_346 VPWR VGND sg13g2_fill_2
X_3971_ VGND VPWR _1631_ _1630_ _1012_ sg13g2_or2_1
X_2922_ net810 videogen.test_lut_thingy.pixel_feeder_inst.row\[57\]\[0\] _0788_ _0472_
+ VPWR VGND sg13g2_mux2_1
X_2853_ videogen.test_lut_thingy.pixel_feeder_inst.row\[35\]\[2\] net795 _0773_ _0534_
+ VPWR VGND sg13g2_mux2_1
X_5192__369 VPWR VGND net369 sg13g2_tiehi
XFILLER_31_596 VPWR VGND sg13g2_decap_8
X_2784_ net569 net558 _0757_ _0758_ VPWR VGND sg13g2_nor3_2
X_4523_ _2149_ net625 _2150_ _2151_ VPWR VGND sg13g2_a21o_1
X_4454_ _2066_ _2083_ net623 _2089_ VPWR VGND sg13g2_nand3_1
Xfanout705 net706 net705 VPWR VGND sg13g2_buf_8
X_4385_ _2034_ tmds_red.dc_balancing_reg\[4\] _2033_ VPWR VGND sg13g2_xnor2_1
X_3405_ _1068_ VPWR _1069_ VGND _1017_ _1042_ sg13g2_o21ai_1
Xfanout716 net717 net716 VPWR VGND sg13g2_buf_8
Xfanout749 net750 net749 VPWR VGND sg13g2_buf_8
Xfanout727 net728 net727 VPWR VGND sg13g2_buf_8
X_3336_ VPWR _1000_ _0999_ VGND sg13g2_inv_1
Xfanout738 net742 net738 VPWR VGND sg13g2_buf_8
XFILLER_39_641 VPWR VGND sg13g2_decap_8
X_3267_ _0952_ _0936_ _0951_ _0934_ videogen.fancy_shader.shader_counter_reg\[6\]
+ VPWR VGND sg13g2_a22oi_1
X_5006_ net423 VGND VPWR _0360_ green\[6\] net665 sg13g2_dfrbpq_2
X_3198_ videogen.test_lut_thingy.pixel_feeder_inst.h_counter\[2\] videogen.test_lut_thingy.pixel_feeder_inst.h_counter\[1\]
+ videogen.test_lut_thingy.pixel_feeder_inst.h_counter\[0\] _0903_ VPWR VGND sg13g2_nor3_1
XFILLER_6_707 VPWR VGND sg13g2_fill_2
XFILLER_10_758 VPWR VGND sg13g2_decap_4
XFILLER_2_902 VPWR VGND sg13g2_decap_8
XFILLER_2_979 VPWR VGND sg13g2_decap_8
XFILLER_39_53 VPWR VGND sg13g2_decap_8
XFILLER_39_86 VPWR VGND sg13g2_fill_1
X_4928__141 VPWR VGND net141 sg13g2_tiehi
XFILLER_45_600 VPWR VGND sg13g2_decap_8
XFILLER_44_110 VPWR VGND sg13g2_fill_2
XFILLER_18_847 VPWR VGND sg13g2_fill_1
XFILLER_45_677 VPWR VGND sg13g2_decap_8
XFILLER_33_817 VPWR VGND sg13g2_fill_1
XFILLER_9_534 VPWR VGND sg13g2_decap_8
XFILLER_9_545 VPWR VGND sg13g2_fill_2
XFILLER_9_567 VPWR VGND sg13g2_decap_8
XFILLER_5_740 VPWR VGND sg13g2_decap_8
XFILLER_4_272 VPWR VGND sg13g2_fill_2
X_4170_ _1000_ _1010_ _1827_ VPWR VGND sg13g2_nor2_2
X_3121_ serialize.shift_reg_b\[1\] serialize.shift_reg_b\[0\] clknet_1_0__leaf_clk
+ net3 VPWR VGND sg13g2_mux2_1
XFILLER_49_950 VPWR VGND sg13g2_decap_8
X_5146__179 VPWR VGND net179 sg13g2_tiehi
X_3052_ videogen.test_lut_thingy.pixel_feeder_inst.row\[20\]\[2\] net797 _0816_ _0276_
+ VPWR VGND sg13g2_mux2_1
XFILLER_36_644 VPWR VGND sg13g2_decap_8
XFILLER_24_806 VPWR VGND sg13g2_decap_8
X_3954_ videogen.test_lut_thingy.pixel_feeder_inst.row\[33\]\[0\] net574 _1617_ VPWR
+ VGND sg13g2_nor2_1
XFILLER_32_850 VPWR VGND sg13g2_fill_2
X_3885_ videogen.test_lut_thingy.pixel_feeder_inst.row\[13\]\[0\] net572 _1548_ VPWR
+ VGND sg13g2_nor2_1
X_2905_ net793 videogen.test_lut_thingy.pixel_feeder_inst.row\[0\]\[2\] _0785_ _0486_
+ VPWR VGND sg13g2_mux2_1
X_2836_ _0755_ _0764_ _0770_ VPWR VGND sg13g2_nor2_2
X_5233__196 VPWR VGND net196 sg13g2_tiehi
X_2767_ net789 videogen.test_lut_thingy.pixel_feeder_inst.row\[59\]\[2\] _0751_ _0598_
+ VPWR VGND sg13g2_mux2_1
X_4506_ _2134_ _2131_ _2135_ VPWR VGND sg13g2_xor2_1
X_2698_ _0716_ net634 _0714_ VPWR VGND sg13g2_xnor2_1
X_4437_ tmds_green.dc_balancing_reg\[2\] _2072_ _2073_ VPWR VGND sg13g2_nor2_1
X_4368_ _2018_ _2005_ _2017_ VPWR VGND sg13g2_nand2_1
Xfanout557 _1105_ net557 VPWR VGND sg13g2_buf_8
Xfanout568 net571 net568 VPWR VGND sg13g2_buf_8
X_4299_ _1944_ VPWR _1951_ VGND _1949_ _1950_ sg13g2_o21ai_1
X_3319_ _0986_ videogen.test_lut_thingy.gol_counter_reg\[0\] videogen.test_lut_thingy.gol_counter_reg\[1\]
+ videogen.test_lut_thingy.gol_counter_reg\[2\] VPWR VGND sg13g2_and3_1
Xfanout579 net581 net579 VPWR VGND sg13g2_buf_8
XFILLER_15_828 VPWR VGND sg13g2_decap_8
XFILLER_25_11 VPWR VGND sg13g2_fill_1
XFILLER_27_666 VPWR VGND sg13g2_fill_1
XFILLER_42_625 VPWR VGND sg13g2_decap_8
XFILLER_41_43 VPWR VGND sg13g2_decap_8
XFILLER_6_515 VPWR VGND sg13g2_decap_8
XFILLER_41_98 VPWR VGND sg13g2_decap_4
XFILLER_29_1018 VPWR VGND sg13g2_decap_8
XFILLER_2_776 VPWR VGND sg13g2_decap_8
XFILLER_2_15 VPWR VGND sg13g2_decap_8
XFILLER_49_279 VPWR VGND sg13g2_decap_8
X_5287__87 VPWR VGND net87 sg13g2_tiehi
XFILLER_46_953 VPWR VGND sg13g2_decap_8
XFILLER_45_452 VPWR VGND sg13g2_decap_4
XFILLER_32_135 VPWR VGND sg13g2_decap_8
XFILLER_9_342 VPWR VGND sg13g2_decap_8
X_3670_ videogen.test_lut_thingy.pixel_feeder_inst.row\[42\]\[2\] net607 _1334_ VPWR
+ VGND sg13g2_nor2_1
XFILLER_9_386 VPWR VGND sg13g2_fill_2
X_5271_ net278 VGND VPWR net484 serialize.bit_cnt\[2\] clknet_3_4_0_clk_regs sg13g2_dfrbpq_1
X_4222_ _1877_ _1878_ _1879_ VPWR VGND sg13g2_and2_1
X_4153_ _1744_ _1792_ _1810_ VPWR VGND sg13g2_and2_1
X_3104_ VGND VPWR _0850_ _0855_ net16 _0852_ sg13g2_a21oi_1
XFILLER_28_419 VPWR VGND sg13g2_decap_8
X_4084_ _1733_ VPWR _0361_ VGND _1740_ _1741_ sg13g2_o21ai_1
X_3035_ net585 _0730_ _0740_ _0813_ VPWR VGND sg13g2_nor3_2
XFILLER_36_441 VPWR VGND sg13g2_fill_1
XFILLER_12_809 VPWR VGND sg13g2_decap_8
X_4986_ net38 VGND VPWR _0340_ videogen.fancy_shader.video_y\[1\] net656 sg13g2_dfrbpq_2
X_3937_ videogen.test_lut_thingy.pixel_feeder_inst.row\[37\]\[0\] net574 _1600_ VPWR
+ VGND sg13g2_nor2_1
XFILLER_20_875 VPWR VGND sg13g2_fill_2
X_3868_ videogen.test_lut_thingy.pixel_feeder_inst.row\[6\]\[0\] net605 _1531_ VPWR
+ VGND sg13g2_nor2_1
X_2819_ videogen.test_lut_thingy.pixel_feeder_inst.row\[45\]\[1\] net806 _0766_ _0561_
+ VPWR VGND sg13g2_mux2_1
X_3799_ net643 _1457_ _1462_ _1463_ VPWR VGND sg13g2_nor3_1
XFILLER_2_8 VPWR VGND sg13g2_decap_8
X_5031__390 VPWR VGND net390 sg13g2_tiehi
XFILLER_47_739 VPWR VGND sg13g2_decap_8
XFILLER_4_1009 VPWR VGND sg13g2_decap_8
XFILLER_14_113 VPWR VGND sg13g2_decap_8
XFILLER_15_636 VPWR VGND sg13g2_decap_8
X_5099__273 VPWR VGND net273 sg13g2_tiehi
XFILLER_42_499 VPWR VGND sg13g2_decap_8
XFILLER_7_824 VPWR VGND sg13g2_decap_8
XFILLER_7_868 VPWR VGND sg13g2_decap_8
XFILLER_11_897 VPWR VGND sg13g2_decap_8
XFILLER_6_367 VPWR VGND sg13g2_fill_2
XFILLER_42_1015 VPWR VGND sg13g2_decap_8
XFILLER_2_595 VPWR VGND sg13g2_decap_8
XFILLER_38_739 VPWR VGND sg13g2_fill_1
XFILLER_37_227 VPWR VGND sg13g2_fill_1
XFILLER_46_750 VPWR VGND sg13g2_decap_8
XFILLER_18_452 VPWR VGND sg13g2_fill_2
XFILLER_19_953 VPWR VGND sg13g2_decap_4
X_4840_ net715 net759 _0197_ VPWR VGND sg13g2_nor2_1
X_4771_ net684 net728 _0128_ VPWR VGND sg13g2_nor2_1
XFILLER_20_138 VPWR VGND sg13g2_decap_4
X_3722_ videogen.test_lut_thingy.pixel_feeder_inst.row\[16\]\[2\] net589 _1386_ VPWR
+ VGND sg13g2_nor2_1
XFILLER_9_161 VPWR VGND sg13g2_fill_1
X_3653_ videogen.test_lut_thingy.pixel_feeder_inst.row\[29\]\[3\] net572 _1317_ VPWR
+ VGND sg13g2_nor2_1
XFILLER_6_890 VPWR VGND sg13g2_decap_8
X_3584_ videogen.test_lut_thingy.pixel_feeder_inst.row\[57\]\[3\] net570 _1248_ VPWR
+ VGND sg13g2_nor2_1
X_5254_ net387 VGND VPWR _0604_ videogen.test_lut_thingy.pixel_feeder_inst.row\[39\]\[0\]
+ _0233_ sg13g2_dfrbpq_1
X_5185_ net400 VGND VPWR _0535_ videogen.test_lut_thingy.pixel_feeder_inst.row\[35\]\[3\]
+ _0164_ sg13g2_dfrbpq_1
X_4205_ VPWR _1862_ _1861_ VGND sg13g2_inv_1
X_4136_ _1006_ _1743_ _1793_ VPWR VGND sg13g2_nor2_1
X_4067_ _1715_ _1725_ _1713_ _1727_ VPWR VGND sg13g2_nand3_1
X_3018_ net799 videogen.test_lut_thingy.pixel_feeder_inst.row\[17\]\[1\] _0809_ _0388_
+ VPWR VGND sg13g2_mux2_1
XFILLER_36_260 VPWR VGND sg13g2_decap_8
XFILLER_36_271 VPWR VGND sg13g2_fill_1
XFILLER_24_433 VPWR VGND sg13g2_decap_8
XFILLER_25_945 VPWR VGND sg13g2_decap_8
X_4969_ net72 VGND VPWR _0323_ videogen.test_lut_thingy.pixel_feeder_inst.row\[37\]\[0\]
+ _0021_ sg13g2_dfrbpq_1
XFILLER_22_23 VPWR VGND sg13g2_decap_4
XFILLER_20_683 VPWR VGND sg13g2_decap_8
XFILLER_4_827 VPWR VGND sg13g2_decap_8
XFILLER_47_536 VPWR VGND sg13g2_decap_8
XFILLER_47_53 VPWR VGND sg13g2_fill_1
XFILLER_42_241 VPWR VGND sg13g2_decap_8
XFILLER_43_797 VPWR VGND sg13g2_fill_2
XFILLER_30_414 VPWR VGND sg13g2_fill_1
XFILLER_8_36 VPWR VGND sg13g2_fill_2
XFILLER_7_610 VPWR VGND sg13g2_fill_1
XFILLER_3_860 VPWR VGND sg13g2_decap_8
X_5188__385 VPWR VGND net385 sg13g2_tiehi
XFILLER_26_4 VPWR VGND sg13g2_decap_8
X_5305__270 VPWR VGND net270 sg13g2_tiehi
X_4823_ net696 net740 _0180_ VPWR VGND sg13g2_nor2_1
X_4754_ net694 net738 _0111_ VPWR VGND sg13g2_nor2_1
X_3705_ videogen.test_lut_thingy.pixel_feeder_inst.row\[54\]\[2\] net603 _1369_ VPWR
+ VGND sg13g2_nor2_1
X_4685_ net705 net749 _0042_ VPWR VGND sg13g2_nor2_1
X_3636_ videogen.test_lut_thingy.pixel_feeder_inst.row\[5\]\[3\] net573 _1300_ VPWR
+ VGND sg13g2_nor2_1
X_3567_ _1230_ VPWR _1231_ VGND _1220_ _1222_ sg13g2_o21ai_1
XFILLER_1_819 VPWR VGND sg13g2_decap_8
X_5306_ net262 VGND VPWR _0656_ serialize.shift_reg_r\[2\] clknet_3_6_0_clk_regs sg13g2_dfrbpq_1
X_5237_ net180 VGND VPWR _0587_ videogen.test_lut_thingy.pixel_feeder_inst.row\[40\]\[3\]
+ _0216_ sg13g2_dfrbpq_1
XFILLER_0_329 VPWR VGND sg13g2_fill_2
X_3498_ _1001_ _1153_ _1162_ VPWR VGND sg13g2_nor2_1
X_5168_ net81 VGND VPWR _0518_ videogen.test_lut_thingy.pixel_feeder_inst.row\[36\]\[2\]
+ _0147_ sg13g2_dfrbpq_1
X_4119_ _1767_ _1775_ _1765_ _1776_ VPWR VGND sg13g2_nand3_1
X_5099_ net273 VGND VPWR _0449_ videogen.test_lut_thingy.pixel_feeder_inst.row\[63\]\[1\]
+ _0086_ sg13g2_dfrbpq_1
XFILLER_44_539 VPWR VGND sg13g2_fill_2
XFILLER_17_78 VPWR VGND sg13g2_decap_4
XFILLER_25_731 VPWR VGND sg13g2_decap_8
XFILLER_40_734 VPWR VGND sg13g2_fill_1
XFILLER_9_908 VPWR VGND sg13g2_fill_2
XFILLER_24_274 VPWR VGND sg13g2_fill_2
XFILLER_33_33 VPWR VGND sg13g2_fill_1
XFILLER_21_981 VPWR VGND sg13g2_decap_8
XFILLER_20_491 VPWR VGND sg13g2_decap_8
XFILLER_3_134 VPWR VGND sg13g2_decap_8
XFILLER_0_863 VPWR VGND sg13g2_decap_8
XFILLER_48_834 VPWR VGND sg13g2_decap_8
XFILLER_47_300 VPWR VGND sg13g2_decap_4
Xhold7 serialize.bit_cnt\[0\] VPWR VGND net452 sg13g2_dlygate4sd3_1
XFILLER_47_355 VPWR VGND sg13g2_fill_1
XFILLER_47_344 VPWR VGND sg13g2_fill_1
XFILLER_43_572 VPWR VGND sg13g2_decap_8
XFILLER_31_734 VPWR VGND sg13g2_fill_1
XFILLER_8_952 VPWR VGND sg13g2_decap_8
X_4470_ _2105_ _2090_ _2102_ VPWR VGND sg13g2_xnor2_1
X_3421_ _1083_ VPWR _1085_ VGND _1026_ _1084_ sg13g2_o21ai_1
X_5166__89 VPWR VGND net89 sg13g2_tiehi
X_3352_ _1003_ _1013_ _1016_ VPWR VGND sg13g2_nor2_1
X_3283_ net629 _0872_ _0962_ VPWR VGND sg13g2_and2_1
X_5022_ net407 VGND VPWR _0376_ videogen.test_lut_thingy.pixel_feeder_inst.row\[13\]\[0\]
+ _0025_ sg13g2_dfrbpq_1
XFILLER_17_0 VPWR VGND sg13g2_decap_8
XFILLER_26_506 VPWR VGND sg13g2_decap_8
XFILLER_0_70 VPWR VGND sg13g2_decap_8
X_4806_ net716 net760 _0163_ VPWR VGND sg13g2_nor2_1
XFILLER_22_767 VPWR VGND sg13g2_decap_8
X_2998_ videogen.test_lut_thingy.pixel_feeder_inst.row\[33\]\[1\] net807 _0805_ _0413_
+ VPWR VGND sg13g2_mux2_1
X_4737_ net712 net756 _0094_ VPWR VGND sg13g2_nor2_1
X_4668_ net708 net752 _0026_ VPWR VGND sg13g2_nor2_1
X_3619_ videogen.test_lut_thingy.pixel_feeder_inst.row\[11\]\[3\] net577 _1283_ VPWR
+ VGND sg13g2_nor2_1
X_4599_ VPWR _0639_ _2214_ VGND sg13g2_inv_1
XFILLER_1_616 VPWR VGND sg13g2_decap_8
XFILLER_0_159 VPWR VGND sg13g2_decap_8
XFILLER_29_344 VPWR VGND sg13g2_decap_4
X_5208__296 VPWR VGND net296 sg13g2_tiehi
XFILLER_45_815 VPWR VGND sg13g2_decap_8
X_5028__395 VPWR VGND net395 sg13g2_tiehi
XFILLER_12_211 VPWR VGND sg13g2_decap_4
XFILLER_40_542 VPWR VGND sg13g2_decap_8
XFILLER_13_767 VPWR VGND sg13g2_decap_4
XFILLER_8_215 VPWR VGND sg13g2_fill_1
XFILLER_9_738 VPWR VGND sg13g2_fill_2
XFILLER_5_922 VPWR VGND sg13g2_decap_8
XFILLER_5_15 VPWR VGND sg13g2_fill_2
XFILLER_5_999 VPWR VGND sg13g2_decap_8
XFILLER_4_487 VPWR VGND sg13g2_fill_2
XFILLER_0_660 VPWR VGND sg13g2_decap_8
XFILLER_48_631 VPWR VGND sg13g2_decap_8
XFILLER_16_561 VPWR VGND sg13g2_fill_2
X_3970_ _1630_ _0998_ _1170_ VPWR VGND sg13g2_nand2_2
XFILLER_35_369 VPWR VGND sg13g2_fill_1
X_2921_ net800 videogen.test_lut_thingy.pixel_feeder_inst.row\[57\]\[1\] _0788_ _0473_
+ VPWR VGND sg13g2_mux2_1
X_2852_ videogen.test_lut_thingy.pixel_feeder_inst.row\[35\]\[3\] net784 _0773_ _0535_
+ VPWR VGND sg13g2_mux2_1
XFILLER_31_575 VPWR VGND sg13g2_decap_8
X_2783_ _0738_ _0748_ net634 _0757_ VPWR VGND sg13g2_nand3_1
X_4522_ net624 _2147_ _2150_ VPWR VGND sg13g2_nor2_1
XFILLER_8_782 VPWR VGND sg13g2_decap_8
X_4453_ net565 _2088_ _0409_ VPWR VGND sg13g2_nor2_1
X_3404_ _1039_ _1064_ _1068_ VPWR VGND sg13g2_nor2_1
Xfanout706 net709 net706 VPWR VGND sg13g2_buf_8
X_4384_ _2033_ _1977_ _2011_ VPWR VGND sg13g2_nand2_1
Xfanout717 net723 net717 VPWR VGND sg13g2_buf_8
Xfanout739 net741 net739 VPWR VGND sg13g2_buf_8
Xfanout728 net729 net728 VPWR VGND sg13g2_buf_8
X_3335_ _0999_ _0995_ _0998_ VPWR VGND sg13g2_xnor2_1
XFILLER_39_620 VPWR VGND sg13g2_decap_8
X_3266_ VGND VPWR _0951_ _0949_ _0689_ sg13g2_or2_1
X_5005_ net424 VGND VPWR _0359_ green\[0\] net664 sg13g2_dfrbpq_1
X_3197_ net563 _0901_ _0902_ _0304_ VPWR VGND sg13g2_nor3_1
XFILLER_26_303 VPWR VGND sg13g2_decap_8
XFILLER_39_697 VPWR VGND sg13g2_decap_8
XFILLER_22_564 VPWR VGND sg13g2_fill_2
XFILLER_10_737 VPWR VGND sg13g2_fill_1
XFILLER_30_34 VPWR VGND sg13g2_fill_1
XFILLER_2_958 VPWR VGND sg13g2_decap_8
XFILLER_49_406 VPWR VGND sg13g2_fill_1
XFILLER_49_439 VPWR VGND sg13g2_decap_8
XFILLER_17_325 VPWR VGND sg13g2_decap_8
XFILLER_45_656 VPWR VGND sg13g2_decap_8
XFILLER_44_177 VPWR VGND sg13g2_fill_1
XFILLER_44_166 VPWR VGND sg13g2_fill_2
XFILLER_40_372 VPWR VGND sg13g2_decap_8
XFILLER_13_586 VPWR VGND sg13g2_decap_8
XFILLER_13_597 VPWR VGND sg13g2_fill_2
XFILLER_4_240 VPWR VGND sg13g2_decap_4
XFILLER_5_796 VPWR VGND sg13g2_decap_8
XFILLER_45_1024 VPWR VGND sg13g2_fill_1
X_3120_ serialize.shift_reg_c\[1\] serialize.shift_reg_c\[0\] clknet_1_0__leaf_clk
+ net4 VPWR VGND sg13g2_mux2_1
XFILLER_1_980 VPWR VGND sg13g2_decap_8
X_3051_ videogen.test_lut_thingy.pixel_feeder_inst.row\[20\]\[3\] net783 _0816_ _0277_
+ VPWR VGND sg13g2_mux2_1
XFILLER_36_623 VPWR VGND sg13g2_decap_8
XFILLER_24_829 VPWR VGND sg13g2_fill_2
XFILLER_23_339 VPWR VGND sg13g2_decap_8
X_3953_ videogen.test_lut_thingy.pixel_feeder_inst.row\[34\]\[0\] net608 _1616_ VPWR
+ VGND sg13g2_nor2_1
X_3884_ videogen.test_lut_thingy.pixel_feeder_inst.row\[14\]\[0\] net604 _1547_ VPWR
+ VGND sg13g2_nor2_1
X_2904_ net777 videogen.test_lut_thingy.pixel_feeder_inst.row\[0\]\[3\] _0785_ _0487_
+ VPWR VGND sg13g2_mux2_1
XFILLER_32_895 VPWR VGND sg13g2_fill_2
X_2835_ net810 videogen.test_lut_thingy.pixel_feeder_inst.row\[48\]\[0\] _0769_ _0548_
+ VPWR VGND sg13g2_mux2_1
X_2766_ net779 videogen.test_lut_thingy.pixel_feeder_inst.row\[59\]\[3\] _0751_ _0599_
+ VPWR VGND sg13g2_mux2_1
X_4505_ _2134_ tmds_blue.dc_balancing_reg\[1\] _2132_ VPWR VGND sg13g2_xnor2_1
X_2697_ _0715_ _0714_ VPWR VGND net634 sg13g2_nand2b_2
XFILLER_6_80 VPWR VGND sg13g2_fill_2
X_4436_ _2070_ _2071_ _2072_ VPWR VGND sg13g2_nor2_2
X_4367_ _2016_ _2008_ _2017_ VPWR VGND sg13g2_xor2_1
X_3318_ VGND VPWR videogen.test_lut_thingy.gol_counter_reg\[0\] videogen.test_lut_thingy.gol_counter_reg\[1\]
+ _0985_ videogen.test_lut_thingy.gol_counter_reg\[2\] sg13g2_a21oi_1
Xfanout569 net571 net569 VPWR VGND sg13g2_buf_8
Xfanout558 _0730_ net558 VPWR VGND sg13g2_buf_8
X_4298_ _1940_ red\[7\] _1950_ VPWR VGND sg13g2_xor2_1
X_3249_ net818 _0820_ _0939_ VPWR VGND sg13g2_nor2_1
XFILLER_27_601 VPWR VGND sg13g2_fill_2
XFILLER_26_111 VPWR VGND sg13g2_fill_1
XFILLER_42_604 VPWR VGND sg13g2_decap_8
XFILLER_15_807 VPWR VGND sg13g2_decap_8
XFILLER_26_122 VPWR VGND sg13g2_fill_1
XFILLER_14_317 VPWR VGND sg13g2_decap_8
XFILLER_41_147 VPWR VGND sg13g2_decap_8
XFILLER_41_158 VPWR VGND sg13g2_fill_2
XFILLER_41_11 VPWR VGND sg13g2_fill_1
XFILLER_41_33 VPWR VGND sg13g2_decap_4
XFILLER_2_755 VPWR VGND sg13g2_decap_8
XFILLER_1_232 VPWR VGND sg13g2_fill_1
XFILLER_49_225 VPWR VGND sg13g2_fill_2
XFILLER_46_932 VPWR VGND sg13g2_decap_8
XFILLER_17_111 VPWR VGND sg13g2_fill_2
XFILLER_17_122 VPWR VGND sg13g2_fill_1
XFILLER_17_133 VPWR VGND sg13g2_decap_4
XFILLER_14_851 VPWR VGND sg13g2_decap_8
XFILLER_17_199 VPWR VGND sg13g2_decap_4
XFILLER_14_884 VPWR VGND sg13g2_fill_2
XFILLER_20_309 VPWR VGND sg13g2_decap_8
XFILLER_13_394 VPWR VGND sg13g2_fill_2
X_5270_ net282 VGND VPWR _0620_ serialize.tmds_parallel_b\[9\] net663 sg13g2_dfrbpq_1
X_4221_ _1878_ net561 _1876_ VPWR VGND sg13g2_nand2_1
X_4152_ _1809_ _1744_ _1808_ VPWR VGND sg13g2_nand2_1
X_3103_ _0855_ _0853_ _0854_ VPWR VGND sg13g2_nand2_1
X_4083_ _1734_ VPWR _1741_ VGND _1330_ _1527_ sg13g2_o21ai_1
X_3034_ videogen.test_lut_thingy.pixel_feeder_inst.row\[37\]\[0\] net815 _0812_ _0323_
+ VPWR VGND sg13g2_mux2_1
XFILLER_36_431 VPWR VGND sg13g2_fill_1
XFILLER_24_604 VPWR VGND sg13g2_decap_8
X_4985_ net40 VGND VPWR _0339_ videogen.fancy_shader.video_y\[0\] net659 sg13g2_dfrbpq_2
XFILLER_23_169 VPWR VGND sg13g2_fill_1
X_3936_ net617 VPWR _1599_ VGND videogen.test_lut_thingy.pixel_feeder_inst.row\[39\]\[0\]
+ net586 sg13g2_o21ai_1
X_3867_ videogen.test_lut_thingy.pixel_feeder_inst.row\[5\]\[0\] net572 _1530_ VPWR
+ VGND sg13g2_nor2_1
X_2818_ videogen.test_lut_thingy.pixel_feeder_inst.row\[45\]\[2\] net794 _0766_ _0562_
+ VPWR VGND sg13g2_mux2_1
X_3798_ _1458_ _1459_ _1460_ _1461_ _1462_ VPWR VGND sg13g2_nor4_1
X_2749_ videogen.test_lut_thingy.pixel_feeder_inst.row\[39\]\[2\] net795 _0741_ _0606_
+ VPWR VGND sg13g2_mux2_1
X_5281__202 VPWR VGND net202 sg13g2_tiehi
X_4419_ VGND VPWR _2057_ _2060_ _0386_ _2061_ sg13g2_a21oi_1
XFILLER_47_718 VPWR VGND sg13g2_decap_8
XFILLER_39_291 VPWR VGND sg13g2_decap_4
XFILLER_15_626 VPWR VGND sg13g2_fill_1
XFILLER_42_434 VPWR VGND sg13g2_fill_2
XFILLER_10_353 VPWR VGND sg13g2_decap_8
XFILLER_7_803 VPWR VGND sg13g2_decap_8
XFILLER_22_180 VPWR VGND sg13g2_decap_8
XFILLER_10_397 VPWR VGND sg13g2_fill_1
XFILLER_6_346 VPWR VGND sg13g2_decap_8
XFILLER_2_574 VPWR VGND sg13g2_decap_8
XFILLER_45_294 VPWR VGND sg13g2_fill_2
XFILLER_45_283 VPWR VGND sg13g2_fill_1
XFILLER_34_979 VPWR VGND sg13g2_decap_4
XFILLER_21_618 VPWR VGND sg13g2_decap_8
X_4770_ net684 net728 _0127_ VPWR VGND sg13g2_nor2_1
XFILLER_9_140 VPWR VGND sg13g2_decap_8
X_3721_ videogen.test_lut_thingy.pixel_feeder_inst.row\[18\]\[2\] net601 _1385_ VPWR
+ VGND sg13g2_nor2_1
XFILLER_13_191 VPWR VGND sg13g2_fill_2
X_3652_ videogen.test_lut_thingy.pixel_feeder_inst.row\[30\]\[3\] net604 _1316_ VPWR
+ VGND sg13g2_nor2_1
X_3583_ videogen.test_lut_thingy.pixel_feeder_inst.row\[59\]\[3\] net579 _1247_ VPWR
+ VGND sg13g2_nor2_1
XFILLER_47_0 VPWR VGND sg13g2_decap_8
X_5253_ net398 VGND VPWR _0603_ videogen.test_lut_thingy.pixel_feeder_inst.row\[49\]\[3\]
+ _0232_ sg13g2_dfrbpq_1
X_5184_ net404 VGND VPWR _0534_ videogen.test_lut_thingy.pixel_feeder_inst.row\[35\]\[2\]
+ _0163_ sg13g2_dfrbpq_1
X_4204_ _1857_ _1860_ _1861_ VPWR VGND sg13g2_nor2b_1
X_4135_ VPWR VGND _1789_ _1791_ _1788_ _1746_ _1792_ _1786_ sg13g2_a221oi_1
XFILLER_3_1021 VPWR VGND sg13g2_decap_8
X_4066_ _1726_ _1715_ _1725_ VPWR VGND sg13g2_xnor2_1
XFILLER_37_773 VPWR VGND sg13g2_decap_4
X_3017_ net788 videogen.test_lut_thingy.pixel_feeder_inst.row\[17\]\[2\] _0809_ _0389_
+ VPWR VGND sg13g2_mux2_1
XFILLER_24_401 VPWR VGND sg13g2_fill_2
XFILLER_36_250 VPWR VGND sg13g2_decap_4
X_4968_ net74 VGND VPWR _0322_ videogen.test_lut_thingy.pixel_feeder_inst.row\[34\]\[3\]
+ _0020_ sg13g2_dfrbpq_1
XFILLER_12_629 VPWR VGND sg13g2_decap_4
X_3919_ videogen.test_lut_thingy.pixel_feeder_inst.row\[49\]\[0\] net570 _1582_ VPWR
+ VGND sg13g2_nor2_1
X_4899_ net710 net755 _0254_ VPWR VGND sg13g2_nor2_1
XFILLER_22_57 VPWR VGND sg13g2_decap_8
XFILLER_4_806 VPWR VGND sg13g2_decap_8
XFILLER_22_68 VPWR VGND sg13g2_fill_1
XFILLER_47_21 VPWR VGND sg13g2_decap_8
XFILLER_47_515 VPWR VGND sg13g2_decap_8
XFILLER_47_98 VPWR VGND sg13g2_decap_8
XFILLER_47_65 VPWR VGND sg13g2_decap_8
XFILLER_16_935 VPWR VGND sg13g2_decap_4
XFILLER_27_250 VPWR VGND sg13g2_fill_1
XFILLER_42_220 VPWR VGND sg13g2_fill_1
X_5294__437 VPWR VGND net437 sg13g2_tiehi
XFILLER_16_968 VPWR VGND sg13g2_fill_1
XFILLER_43_787 VPWR VGND sg13g2_fill_1
XFILLER_43_765 VPWR VGND sg13g2_decap_4
XFILLER_31_949 VPWR VGND sg13g2_decap_8
XFILLER_7_600 VPWR VGND sg13g2_decap_4
XFILLER_10_161 VPWR VGND sg13g2_decap_8
XFILLER_6_165 VPWR VGND sg13g2_fill_1
XFILLER_19_4 VPWR VGND sg13g2_fill_1
XFILLER_38_559 VPWR VGND sg13g2_decap_8
XFILLER_19_740 VPWR VGND sg13g2_fill_1
XFILLER_18_283 VPWR VGND sg13g2_decap_4
XFILLER_33_220 VPWR VGND sg13g2_fill_1
X_5195__357 VPWR VGND net357 sg13g2_tiehi
XFILLER_33_253 VPWR VGND sg13g2_fill_1
X_4822_ net695 net739 _0179_ VPWR VGND sg13g2_nor2_1
XFILLER_15_990 VPWR VGND sg13g2_decap_8
X_4753_ net692 net736 _0110_ VPWR VGND sg13g2_nor2_1
X_3704_ videogen.test_lut_thingy.pixel_feeder_inst.row\[53\]\[2\] net569 _1368_ VPWR
+ VGND sg13g2_nor2_1
X_5271__278 VPWR VGND net278 sg13g2_tiehi
X_4684_ net687 net731 _0041_ VPWR VGND sg13g2_nor2_1
X_3635_ videogen.test_lut_thingy.pixel_feeder_inst.row\[7\]\[3\] net583 _1299_ VPWR
+ VGND sg13g2_nor2_1
X_3566_ _1219_ _1223_ _1171_ _1230_ VPWR VGND sg13g2_nand3_1
X_5305_ net270 VGND VPWR _0655_ serialize.shift_reg_r\[1\] clknet_3_7_0_clk_regs sg13g2_dfrbpq_1
X_3497_ _1136_ _1150_ _1159_ _1161_ VPWR VGND sg13g2_or3_1
X_5236_ net184 VGND VPWR _0586_ videogen.test_lut_thingy.pixel_feeder_inst.row\[40\]\[2\]
+ _0215_ sg13g2_dfrbpq_1
X_5167_ net85 VGND VPWR _0517_ videogen.test_lut_thingy.pixel_feeder_inst.row\[36\]\[1\]
+ _0146_ sg13g2_dfrbpq_1
XFILLER_17_13 VPWR VGND sg13g2_decap_8
X_4118_ _1750_ _1762_ _1773_ _1775_ VPWR VGND sg13g2_nor3_2
X_5098_ net275 VGND VPWR _0448_ videogen.test_lut_thingy.pixel_feeder_inst.row\[63\]\[0\]
+ _0085_ sg13g2_dfrbpq_1
XFILLER_44_518 VPWR VGND sg13g2_fill_2
X_4049_ _1709_ _1707_ _1708_ VPWR VGND sg13g2_nand2_1
XFILLER_33_45 VPWR VGND sg13g2_decap_4
XFILLER_3_168 VPWR VGND sg13g2_fill_2
X_5068__335 VPWR VGND net335 sg13g2_tiehi
XFILLER_0_842 VPWR VGND sg13g2_decap_8
XFILLER_48_813 VPWR VGND sg13g2_decap_8
Xhold8 serialize.shift_reg_c\[6\] VPWR VGND net453 sg13g2_dlygate4sd3_1
XFILLER_31_713 VPWR VGND sg13g2_decap_8
XFILLER_8_931 VPWR VGND sg13g2_decap_8
XFILLER_30_278 VPWR VGND sg13g2_fill_2
XFILLER_30_289 VPWR VGND sg13g2_decap_8
XFILLER_7_430 VPWR VGND sg13g2_fill_2
XFILLER_7_452 VPWR VGND sg13g2_fill_1
X_3420_ _1084_ _1053_ _1082_ VPWR VGND sg13g2_nand2_1
X_3351_ VGND VPWR _1015_ _1013_ _1004_ sg13g2_or2_1
X_3282_ tmds_green.dc_balancing_reg\[0\] _0960_ _0338_ VPWR VGND sg13g2_and2_1
X_5021_ net408 VGND VPWR _0375_ red_tmds_par\[7\] net662 sg13g2_dfrbpq_1
XFILLER_0_1024 VPWR VGND sg13g2_decap_4
XFILLER_19_592 VPWR VGND sg13g2_decap_4
X_5244__83 VPWR VGND net83 sg13g2_tiehi
X_4805_ net721 net766 _0162_ VPWR VGND sg13g2_nor2_1
XFILLER_21_223 VPWR VGND sg13g2_fill_1
X_2997_ videogen.test_lut_thingy.pixel_feeder_inst.row\[33\]\[2\] net795 _0805_ _0414_
+ VPWR VGND sg13g2_mux2_1
X_5236__184 VPWR VGND net184 sg13g2_tiehi
XFILLER_21_256 VPWR VGND sg13g2_fill_2
X_4736_ net708 net751 _0093_ VPWR VGND sg13g2_nor2_1
X_4667_ net708 net752 _0025_ VPWR VGND sg13g2_nor2_1
X_3618_ videogen.test_lut_thingy.pixel_feeder_inst.row\[10\]\[3\] net600 _1282_ VPWR
+ VGND sg13g2_nor2_1
X_4598_ _2214_ net672 net460 net679 blue_tmds_par\[1\] VPWR VGND sg13g2_a22oi_1
XFILLER_0_127 VPWR VGND sg13g2_decap_4
X_3549_ _1213_ _1194_ _1212_ VPWR VGND sg13g2_xnor2_1
X_5219_ net252 VGND VPWR _0569_ videogen.test_lut_thingy.pixel_feeder_inst.row\[43\]\[1\]
+ _0198_ sg13g2_dfrbpq_1
XFILLER_17_518 VPWR VGND sg13g2_fill_2
XFILLER_28_67 VPWR VGND sg13g2_fill_2
XFILLER_29_367 VPWR VGND sg13g2_fill_2
XFILLER_44_348 VPWR VGND sg13g2_fill_1
XFILLER_44_359 VPWR VGND sg13g2_fill_2
XFILLER_25_540 VPWR VGND sg13g2_decap_8
XFILLER_44_55 VPWR VGND sg13g2_decap_8
X_4986__38 VPWR VGND net38 sg13g2_tiehi
XFILLER_25_584 VPWR VGND sg13g2_fill_1
X_5215__268 VPWR VGND net268 sg13g2_tiehi
XFILLER_5_901 VPWR VGND sg13g2_decap_8
XFILLER_5_27 VPWR VGND sg13g2_decap_8
XFILLER_5_978 VPWR VGND sg13g2_decap_8
XFILLER_48_610 VPWR VGND sg13g2_decap_8
XFILLER_48_687 VPWR VGND sg13g2_decap_8
XFILLER_47_153 VPWR VGND sg13g2_fill_1
XFILLER_36_816 VPWR VGND sg13g2_fill_1
XFILLER_16_540 VPWR VGND sg13g2_decap_8
X_2920_ net789 videogen.test_lut_thingy.pixel_feeder_inst.row\[57\]\[2\] _0788_ _0474_
+ VPWR VGND sg13g2_mux2_1
XFILLER_31_521 VPWR VGND sg13g2_decap_4
X_2851_ _0740_ _0747_ _0773_ VPWR VGND sg13g2_nor2_2
XFILLER_15_1021 VPWR VGND sg13g2_decap_8
XFILLER_31_565 VPWR VGND sg13g2_fill_2
X_2782_ videogen.test_lut_thingy.pixel_feeder_inst.row\[3\]\[0\] net809 _0756_ _0588_
+ VPWR VGND sg13g2_mux2_1
X_4521_ _2147_ _2134_ _2149_ VPWR VGND sg13g2_xor2_1
X_4452_ _2088_ _2054_ _2087_ VPWR VGND sg13g2_xnor2_1
X_3403_ VGND VPWR _1067_ _1066_ _1064_ sg13g2_or2_1
X_4383_ _2015_ VPWR _2032_ VGND _2008_ _2016_ sg13g2_o21ai_1
Xfanout729 net735 net729 VPWR VGND sg13g2_buf_2
Xfanout707 net709 net707 VPWR VGND sg13g2_buf_8
X_3334_ videogen.fancy_shader.shader_counter_reg\[1\] videogen.fancy_shader.video_y\[1\]
+ _0998_ VPWR VGND sg13g2_xor2_1
Xfanout718 net722 net718 VPWR VGND sg13g2_buf_8
X_3265_ _0948_ _0950_ _0332_ VPWR VGND sg13g2_nor2_1
XFILLER_22_1014 VPWR VGND sg13g2_decap_8
X_5004_ net425 VGND VPWR _0358_ blue\[7\] net663 sg13g2_dfrbpq_1
XFILLER_39_676 VPWR VGND sg13g2_decap_8
XFILLER_38_142 VPWR VGND sg13g2_fill_1
XFILLER_38_131 VPWR VGND sg13g2_fill_1
X_3196_ videogen.test_lut_thingy.pixel_feeder_inst.v_pix\[5\] _0900_ _0902_ VPWR VGND
+ sg13g2_and2_1
XFILLER_27_838 VPWR VGND sg13g2_decap_8
XFILLER_26_348 VPWR VGND sg13g2_decap_4
XFILLER_14_25 VPWR VGND sg13g2_fill_1
XFILLER_22_521 VPWR VGND sg13g2_decap_8
XFILLER_14_69 VPWR VGND sg13g2_decap_4
XFILLER_6_709 VPWR VGND sg13g2_fill_1
X_4719_ net700 net744 _0076_ VPWR VGND sg13g2_nor2_1
XFILLER_2_937 VPWR VGND sg13g2_decap_8
XFILLER_1_425 VPWR VGND sg13g2_fill_2
XFILLER_7_1008 VPWR VGND sg13g2_decap_8
XFILLER_49_418 VPWR VGND sg13g2_decap_8
XFILLER_29_131 VPWR VGND sg13g2_fill_1
XFILLER_29_142 VPWR VGND sg13g2_fill_2
XFILLER_45_635 VPWR VGND sg13g2_decap_8
XFILLER_44_112 VPWR VGND sg13g2_fill_1
XFILLER_17_348 VPWR VGND sg13g2_fill_1
XFILLER_13_510 VPWR VGND sg13g2_decap_8
XFILLER_41_863 VPWR VGND sg13g2_decap_4
XFILLER_13_554 VPWR VGND sg13g2_decap_8
XFILLER_5_775 VPWR VGND sg13g2_decap_8
XFILLER_4_274 VPWR VGND sg13g2_fill_1
XFILLER_45_1003 VPWR VGND sg13g2_decap_8
X_3050_ _0721_ _0764_ _0816_ VPWR VGND sg13g2_nor2_2
XFILLER_49_985 VPWR VGND sg13g2_decap_8
XFILLER_48_484 VPWR VGND sg13g2_decap_8
XFILLER_36_679 VPWR VGND sg13g2_decap_8
XFILLER_35_167 VPWR VGND sg13g2_fill_2
X_3952_ net617 VPWR _1615_ VGND videogen.test_lut_thingy.pixel_feeder_inst.row\[32\]\[0\]
+ net597 sg13g2_o21ai_1
X_3883_ videogen.test_lut_thingy.pixel_feeder_inst.row\[15\]\[0\] net583 _1546_ VPWR
+ VGND sg13g2_nor2_1
X_2903_ _0785_ _0731_ _0754_ VPWR VGND sg13g2_nand2_2
X_2834_ net800 videogen.test_lut_thingy.pixel_feeder_inst.row\[48\]\[1\] _0769_ _0549_
+ VPWR VGND sg13g2_mux2_1
XFILLER_31_384 VPWR VGND sg13g2_fill_1
X_4504_ tmds_blue.dc_balancing_reg\[1\] _2132_ _2133_ VPWR VGND sg13g2_nor2_1
X_2765_ _0751_ _0750_ VPWR VGND _0747_ sg13g2_nand2b_2
X_2696_ _0676_ _0710_ _0714_ VPWR VGND sg13g2_and2_1
X_4435_ net623 green\[7\] green\[6\] _2071_ VPWR VGND sg13g2_nor3_1
X_4366_ _2014_ _2012_ _2016_ VPWR VGND sg13g2_xor2_1
X_3317_ VGND VPWR videogen.test_lut_thingy.gol_counter_reg\[0\] videogen.test_lut_thingy.gol_counter_reg\[1\]
+ _0350_ _0984_ sg13g2_a21oi_1
X_4297_ _1949_ _1946_ _1948_ VPWR VGND sg13g2_nand2_1
Xfanout559 _0726_ net559 VPWR VGND sg13g2_buf_8
X_3248_ _0938_ net633 net632 _0933_ VPWR VGND sg13g2_and3_1
X_3179_ videogen.test_lut_thingy.pixel_feeder_inst.v_counter\[3\] VPWR _0890_ VGND
+ videogen.test_lut_thingy.pixel_feeder_inst.v_counter\[2\] _0889_ sg13g2_o21ai_1
XFILLER_26_134 VPWR VGND sg13g2_decap_8
XFILLER_41_126 VPWR VGND sg13g2_decap_8
XFILLER_25_46 VPWR VGND sg13g2_decap_8
XFILLER_23_863 VPWR VGND sg13g2_fill_2
XFILLER_22_373 VPWR VGND sg13g2_fill_1
XFILLER_22_395 VPWR VGND sg13g2_decap_4
XFILLER_10_568 VPWR VGND sg13g2_decap_8
XFILLER_2_734 VPWR VGND sg13g2_decap_8
XFILLER_49_204 VPWR VGND sg13g2_decap_8
XFILLER_49_259 VPWR VGND sg13g2_decap_8
XFILLER_46_911 VPWR VGND sg13g2_decap_8
X_5145__181 VPWR VGND net181 sg13g2_tiehi
XFILLER_17_145 VPWR VGND sg13g2_fill_1
XFILLER_46_988 VPWR VGND sg13g2_decap_8
XFILLER_45_487 VPWR VGND sg13g2_fill_1
XFILLER_33_616 VPWR VGND sg13g2_decap_8
XFILLER_32_115 VPWR VGND sg13g2_fill_2
XFILLER_9_300 VPWR VGND sg13g2_fill_1
XFILLER_32_159 VPWR VGND sg13g2_fill_2
XFILLER_41_682 VPWR VGND sg13g2_decap_8
XFILLER_9_388 VPWR VGND sg13g2_fill_1
XFILLER_12_1024 VPWR VGND sg13g2_decap_4
XFILLER_5_561 VPWR VGND sg13g2_decap_8
X_4220_ VGND VPWR _1877_ _1876_ net561 sg13g2_or2_1
X_5267__294 VPWR VGND net294 sg13g2_tiehi
X_4151_ _1802_ _1807_ _1808_ VPWR VGND sg13g2_and2_1
X_3102_ _0715_ _0701_ videogen.test_lut_thingy.pixel_feeder_inst.v_pix\[0\] _0854_
+ VPWR VGND sg13g2_a21o_1
X_4082_ _1627_ _1735_ _1740_ VPWR VGND sg13g2_and2_1
XFILLER_49_782 VPWR VGND sg13g2_decap_8
X_3033_ videogen.test_lut_thingy.pixel_feeder_inst.row\[37\]\[1\] net807 _0812_ _0324_
+ VPWR VGND sg13g2_mux2_1
X_4984_ net42 VGND VPWR _0338_ tmds_green.dc_balancing_reg\[0\] net661 sg13g2_dfrbpq_1
XFILLER_24_649 VPWR VGND sg13g2_decap_4
X_3935_ net637 _1586_ _1598_ VPWR VGND _1597_ sg13g2_nand3b_1
XFILLER_20_877 VPWR VGND sg13g2_fill_1
X_3866_ net646 VPWR _1529_ VGND videogen.test_lut_thingy.pixel_feeder_inst.row\[7\]\[0\]
+ net583 sg13g2_o21ai_1
X_2817_ videogen.test_lut_thingy.pixel_feeder_inst.row\[45\]\[3\] net785 _0766_ _0563_
+ VPWR VGND sg13g2_mux2_1
X_3797_ videogen.test_lut_thingy.pixel_feeder_inst.row\[18\]\[1\] net601 _1461_ VPWR
+ VGND sg13g2_nor2_1
XFILLER_20_899 VPWR VGND sg13g2_fill_2
X_2748_ videogen.test_lut_thingy.pixel_feeder_inst.row\[39\]\[3\] net784 _0741_ _0607_
+ VPWR VGND sg13g2_mux2_1
X_4961__88 VPWR VGND net88 sg13g2_tiehi
X_2679_ videogen.fancy_shader.video_x\[6\] videogen.fancy_shader.video_x\[5\] videogen.fancy_shader.video_x\[4\]
+ _0697_ VPWR VGND sg13g2_nor3_1
X_4418_ _0960_ VPWR _2061_ VGND _2057_ _2060_ sg13g2_o21ai_1
X_4349_ VPWR _2000_ _1999_ VGND sg13g2_inv_1
XFILLER_27_487 VPWR VGND sg13g2_decap_8
XFILLER_36_56 VPWR VGND sg13g2_decap_8
XFILLER_23_682 VPWR VGND sg13g2_fill_1
XFILLER_10_365 VPWR VGND sg13g2_fill_2
XFILLER_11_888 VPWR VGND sg13g2_decap_4
XFILLER_2_553 VPWR VGND sg13g2_decap_8
XFILLER_19_900 VPWR VGND sg13g2_decap_8
XFILLER_46_785 VPWR VGND sg13g2_decap_8
XFILLER_18_454 VPWR VGND sg13g2_fill_1
X_5078__315 VPWR VGND net315 sg13g2_tiehi
XFILLER_33_413 VPWR VGND sg13g2_fill_1
XFILLER_33_468 VPWR VGND sg13g2_fill_2
X_3720_ net610 VPWR _1384_ VGND videogen.test_lut_thingy.pixel_feeder_inst.row\[17\]\[2\]
+ net568 sg13g2_o21ai_1
X_3651_ net640 VPWR _1315_ VGND videogen.test_lut_thingy.pixel_feeder_inst.row\[31\]\[3\]
+ net583 sg13g2_o21ai_1
X_3582_ videogen.test_lut_thingy.pixel_feeder_inst.row\[56\]\[3\] net591 _1246_ VPWR
+ VGND sg13g2_nor2_1
XFILLER_5_391 VPWR VGND sg13g2_fill_1
XFILLER_5_380 VPWR VGND sg13g2_decap_8
X_5252_ net406 VGND VPWR _0602_ videogen.test_lut_thingy.pixel_feeder_inst.row\[49\]\[2\]
+ _0231_ sg13g2_dfrbpq_1
X_5183_ net435 VGND VPWR _0533_ videogen.test_lut_thingy.pixel_feeder_inst.row\[35\]\[1\]
+ _0162_ sg13g2_dfrbpq_1
X_4203_ _1849_ VPWR _1860_ VGND _1854_ _1859_ sg13g2_o21ai_1
X_4134_ VPWR VGND _1785_ _1746_ _1783_ _1768_ _1791_ _1775_ sg13g2_a221oi_1
XFILLER_3_1000 VPWR VGND sg13g2_decap_8
XFILLER_37_741 VPWR VGND sg13g2_fill_1
X_4065_ _1724_ _1718_ _1721_ _1725_ VPWR VGND sg13g2_a21o_1
X_3016_ net777 videogen.test_lut_thingy.pixel_feeder_inst.row\[17\]\[3\] _0809_ _0390_
+ VPWR VGND sg13g2_mux2_1
X_5159__103 VPWR VGND net103 sg13g2_tiehi
X_4967_ net76 VGND VPWR _0321_ videogen.test_lut_thingy.pixel_feeder_inst.row\[34\]\[2\]
+ _0019_ sg13g2_dfrbpq_1
X_3918_ videogen.test_lut_thingy.pixel_feeder_inst.row\[48\]\[0\] net591 _1581_ VPWR
+ VGND sg13g2_nor2_1
X_4898_ net710 net754 _0253_ VPWR VGND sg13g2_nor2_1
X_3849_ videogen.test_lut_thingy.pixel_feeder_inst.row\[38\]\[1\] net606 _1513_ VPWR
+ VGND sg13g2_nor2_1
XFILLER_3_306 VPWR VGND sg13g2_fill_1
XFILLER_3_328 VPWR VGND sg13g2_decap_8
XFILLER_0_7 VPWR VGND sg13g2_decap_8
XFILLER_28_730 VPWR VGND sg13g2_decap_8
XFILLER_16_914 VPWR VGND sg13g2_decap_8
XFILLER_43_777 VPWR VGND sg13g2_fill_2
XFILLER_43_799 VPWR VGND sg13g2_fill_1
XFILLER_30_405 VPWR VGND sg13g2_fill_1
XFILLER_30_438 VPWR VGND sg13g2_decap_4
XFILLER_8_38 VPWR VGND sg13g2_fill_1
XFILLER_7_656 VPWR VGND sg13g2_fill_2
XFILLER_3_895 VPWR VGND sg13g2_decap_8
XFILLER_38_538 VPWR VGND sg13g2_fill_2
XFILLER_38_505 VPWR VGND sg13g2_fill_2
XFILLER_19_774 VPWR VGND sg13g2_decap_8
XFILLER_46_582 VPWR VGND sg13g2_decap_8
X_4821_ net695 net739 _0178_ VPWR VGND sg13g2_nor2_1
XFILLER_34_755 VPWR VGND sg13g2_fill_2
X_4752_ net692 net736 _0109_ VPWR VGND sg13g2_nor2_1
XFILLER_33_298 VPWR VGND sg13g2_decap_8
X_3703_ videogen.test_lut_thingy.pixel_feeder_inst.row\[55\]\[2\] net581 _1367_ VPWR
+ VGND sg13g2_nor2_1
X_4683_ net686 net730 _0040_ VPWR VGND sg13g2_nor2_1
XFILLER_30_983 VPWR VGND sg13g2_fill_2
X_3634_ videogen.test_lut_thingy.pixel_feeder_inst.row\[6\]\[3\] net605 _1298_ VPWR
+ VGND sg13g2_nor2_1
X_5169__77 VPWR VGND net77 sg13g2_tiehi
X_3565_ _1225_ _1222_ _1229_ VPWR VGND sg13g2_nor2b_1
X_5304_ net318 VGND VPWR _0654_ serialize.shift_reg_r\[0\] clknet_3_6_0_clk_regs sg13g2_dfrbpq_1
X_3496_ _1136_ VPWR _1160_ VGND _1150_ _1159_ sg13g2_o21ai_1
X_5235_ net188 VGND VPWR _0585_ videogen.test_lut_thingy.pixel_feeder_inst.row\[40\]\[1\]
+ _0214_ sg13g2_dfrbpq_1
X_5166_ net89 VGND VPWR _0516_ videogen.test_lut_thingy.pixel_feeder_inst.row\[36\]\[0\]
+ _0145_ sg13g2_dfrbpq_1
X_5097_ net277 VGND VPWR _0447_ videogen.test_lut_thingy.pixel_feeder_inst.row\[11\]\[3\]
+ _0084_ sg13g2_dfrbpq_1
X_4117_ _1750_ _1762_ _1774_ VPWR VGND sg13g2_nor2_1
X_4048_ _1687_ _1695_ _1682_ _1708_ VPWR VGND sg13g2_nand3_1
XFILLER_17_58 VPWR VGND sg13g2_decap_8
XFILLER_24_221 VPWR VGND sg13g2_decap_8
XFILLER_40_714 VPWR VGND sg13g2_decap_8
XFILLER_13_939 VPWR VGND sg13g2_decap_8
XFILLER_24_276 VPWR VGND sg13g2_fill_1
XFILLER_25_788 VPWR VGND sg13g2_fill_2
XFILLER_8_409 VPWR VGND sg13g2_decap_8
X_5317__198 VPWR VGND net198 sg13g2_tiehi
XFILLER_4_626 VPWR VGND sg13g2_fill_2
XFILLER_4_659 VPWR VGND sg13g2_decap_8
XFILLER_4_637 VPWR VGND sg13g2_fill_1
XFILLER_0_821 VPWR VGND sg13g2_decap_8
XFILLER_0_898 VPWR VGND sg13g2_decap_8
Xhold9 serialize.shift_reg_r\[9\] VPWR VGND net454 sg13g2_dlygate4sd3_1
XFILLER_48_869 VPWR VGND sg13g2_decap_8
XFILLER_16_700 VPWR VGND sg13g2_fill_1
XFILLER_16_755 VPWR VGND sg13g2_decap_8
XFILLER_43_563 VPWR VGND sg13g2_decap_4
XFILLER_15_265 VPWR VGND sg13g2_decap_4
XFILLER_8_987 VPWR VGND sg13g2_decap_8
XFILLER_7_464 VPWR VGND sg13g2_fill_1
XFILLER_48_1023 VPWR VGND sg13g2_decap_4
X_3350_ _1004_ _1013_ _1014_ VPWR VGND sg13g2_nor2_1
X_3281_ tmds_blue.dc_balancing_reg\[0\] _0960_ _0337_ VPWR VGND sg13g2_and2_1
XFILLER_3_692 VPWR VGND sg13g2_decap_8
X_5020_ net409 VGND VPWR _0374_ red_tmds_par\[5\] net666 sg13g2_dfrbpq_1
XFILLER_39_825 VPWR VGND sg13g2_fill_1
XFILLER_0_1003 VPWR VGND sg13g2_decap_8
XFILLER_34_574 VPWR VGND sg13g2_fill_2
X_4804_ net719 net764 _0161_ VPWR VGND sg13g2_nor2_1
XFILLER_21_235 VPWR VGND sg13g2_decap_8
XFILLER_34_596 VPWR VGND sg13g2_fill_1
X_2996_ videogen.test_lut_thingy.pixel_feeder_inst.row\[33\]\[3\] net784 _0805_ _0415_
+ VPWR VGND sg13g2_mux2_1
X_4735_ net700 net744 _0092_ VPWR VGND sg13g2_nor2_1
XFILLER_30_780 VPWR VGND sg13g2_fill_2
X_4666_ net565 _2049_ _0374_ VPWR VGND sg13g2_nor2_1
X_4597_ VPWR _0638_ _2213_ VGND sg13g2_inv_1
X_3617_ net638 VPWR _1281_ VGND videogen.test_lut_thingy.pixel_feeder_inst.row\[8\]\[3\]
+ net588 sg13g2_o21ai_1
X_5165__91 VPWR VGND net91 sg13g2_tiehi
X_3548_ _1208_ _1200_ _1199_ _1212_ VPWR VGND sg13g2_a21o_1
XFILLER_0_106 VPWR VGND sg13g2_decap_8
X_3479_ _1132_ net561 _1143_ VPWR VGND sg13g2_nor2_1
X_5218_ net256 VGND VPWR _0568_ videogen.test_lut_thingy.pixel_feeder_inst.row\[43\]\[0\]
+ _0197_ sg13g2_dfrbpq_1
X_5282__194 VPWR VGND net194 sg13g2_tiehi
X_5149_ net154 VGND VPWR _0499_ videogen.test_lut_thingy.pixel_feeder_inst.row\[53\]\[3\]
+ _0136_ sg13g2_dfrbpq_1
XFILLER_28_35 VPWR VGND sg13g2_decap_8
XFILLER_44_305 VPWR VGND sg13g2_decap_4
XFILLER_29_379 VPWR VGND sg13g2_decap_8
XFILLER_44_327 VPWR VGND sg13g2_fill_1
XFILLER_44_316 VPWR VGND sg13g2_decap_8
X_5104__263 VPWR VGND net263 sg13g2_tiehi
XFILLER_25_552 VPWR VGND sg13g2_decap_8
XFILLER_13_714 VPWR VGND sg13g2_fill_2
XFILLER_9_718 VPWR VGND sg13g2_fill_1
XFILLER_5_957 VPWR VGND sg13g2_decap_8
XFILLER_4_456 VPWR VGND sg13g2_fill_1
XFILLER_0_695 VPWR VGND sg13g2_decap_8
XFILLER_48_666 VPWR VGND sg13g2_decap_8
XFILLER_29_880 VPWR VGND sg13g2_decap_8
XFILLER_43_371 VPWR VGND sg13g2_decap_4
XFILLER_16_563 VPWR VGND sg13g2_fill_1
X_2850_ net808 videogen.test_lut_thingy.pixel_feeder_inst.row\[26\]\[0\] _0772_ _0536_
+ VPWR VGND sg13g2_mux2_1
X_2781_ videogen.test_lut_thingy.pixel_feeder_inst.row\[3\]\[1\] net799 _0756_ _0589_
+ VPWR VGND sg13g2_mux2_1
X_4520_ _2147_ _2134_ _2148_ VPWR VGND sg13g2_nor2b_1
X_4451_ _2087_ _2085_ _2086_ _2079_ _2059_ VPWR VGND sg13g2_a22oi_1
X_3402_ _1035_ _1065_ _1066_ VPWR VGND sg13g2_nor2_1
X_4382_ VGND VPWR _2029_ _2031_ _0369_ net565 sg13g2_a21oi_1
Xfanout719 net721 net719 VPWR VGND sg13g2_buf_8
Xfanout708 net709 net708 VPWR VGND sg13g2_buf_8
X_3333_ videogen.fancy_shader.video_y\[1\] net632 _0997_ VPWR VGND sg13g2_nor2_1
X_3264_ _0950_ _0936_ _0949_ _0934_ net630 VPWR VGND sg13g2_a22oi_1
X_5086__299 VPWR VGND net299 sg13g2_tiehi
X_5003_ net426 VGND VPWR _0357_ blue\[6\] net660 sg13g2_dfrbpq_2
XFILLER_39_655 VPWR VGND sg13g2_decap_8
X_3195_ videogen.test_lut_thingy.pixel_feeder_inst.v_pix\[5\] _0900_ _0901_ VPWR VGND
+ sg13g2_nor2_1
X_2979_ videogen.test_lut_thingy.pixel_feeder_inst.row\[30\]\[0\] net813 _0801_ _0428_
+ VPWR VGND sg13g2_mux2_1
XFILLER_10_728 VPWR VGND sg13g2_decap_8
X_4718_ net700 net744 _0075_ VPWR VGND sg13g2_nor2_1
X_4649_ net711 net755 _0008_ VPWR VGND sg13g2_nor2_1
XFILLER_2_916 VPWR VGND sg13g2_decap_8
XFILLER_39_67 VPWR VGND sg13g2_decap_8
XFILLER_29_110 VPWR VGND sg13g2_decap_8
XFILLER_29_121 VPWR VGND sg13g2_fill_2
XFILLER_45_614 VPWR VGND sg13g2_decap_8
XFILLER_29_165 VPWR VGND sg13g2_decap_8
XFILLER_44_124 VPWR VGND sg13g2_decap_8
XFILLER_44_168 VPWR VGND sg13g2_fill_1
X_5041__372 VPWR VGND net372 sg13g2_tiehi
XFILLER_13_500 VPWR VGND sg13g2_fill_2
XFILLER_25_360 VPWR VGND sg13g2_fill_2
XFILLER_13_533 VPWR VGND sg13g2_decap_8
XFILLER_41_886 VPWR VGND sg13g2_fill_1
XFILLER_40_352 VPWR VGND sg13g2_decap_4
XFILLER_9_515 VPWR VGND sg13g2_fill_1
XFILLER_5_754 VPWR VGND sg13g2_decap_8
XFILLER_49_964 VPWR VGND sg13g2_decap_8
XFILLER_48_430 VPWR VGND sg13g2_fill_1
XFILLER_0_492 VPWR VGND sg13g2_decap_8
XFILLER_36_658 VPWR VGND sg13g2_decap_8
X_3951_ _1610_ _1611_ _1612_ _1613_ _1614_ VPWR VGND sg13g2_nor4_1
X_2902_ net808 videogen.test_lut_thingy.pixel_feeder_inst.row\[10\]\[0\] _0784_ _0488_
+ VPWR VGND sg13g2_mux2_1
X_3882_ net646 VPWR _1545_ VGND videogen.test_lut_thingy.pixel_feeder_inst.row\[12\]\[0\]
+ net594 sg13g2_o21ai_1
XFILLER_31_352 VPWR VGND sg13g2_decap_4
X_2833_ net789 videogen.test_lut_thingy.pixel_feeder_inst.row\[48\]\[2\] _0769_ _0550_
+ VPWR VGND sg13g2_mux2_1
X_4958__94 VPWR VGND net94 sg13g2_tiehi
XFILLER_31_396 VPWR VGND sg13g2_fill_2
X_4973__64 VPWR VGND net64 sg13g2_tiehi
X_2764_ _0681_ net560 _0743_ _0750_ VPWR VGND sg13g2_nor3_2
X_4503_ blue\[7\] blue\[1\] _2132_ VPWR VGND sg13g2_xor2_1
X_2695_ net562 _0712_ _0713_ VPWR VGND sg13g2_and2_1
XFILLER_6_82 VPWR VGND sg13g2_fill_1
X_4434_ VPWR _2070_ _2069_ VGND sg13g2_inv_1
X_4365_ _2015_ _2014_ _2012_ VPWR VGND sg13g2_nand2b_1
X_3316_ net818 VPWR _0984_ VGND videogen.test_lut_thingy.gol_counter_reg\[0\] videogen.test_lut_thingy.gol_counter_reg\[1\]
+ sg13g2_o21ai_1
X_4296_ _1948_ red\[6\] _1947_ VPWR VGND sg13g2_nand2_1
X_3247_ VPWR _0327_ _0937_ VGND sg13g2_inv_1
X_3178_ VGND VPWR _0889_ videogen.test_lut_thingy.pixel_feeder_inst.v_counter\[0\]
+ videogen.test_lut_thingy.pixel_feeder_inst.v_counter\[1\] sg13g2_or2_1
XFILLER_26_168 VPWR VGND sg13g2_decap_4
XFILLER_26_179 VPWR VGND sg13g2_decap_8
XFILLER_42_639 VPWR VGND sg13g2_decap_8
XFILLER_10_503 VPWR VGND sg13g2_fill_2
XFILLER_41_57 VPWR VGND sg13g2_fill_1
XFILLER_6_529 VPWR VGND sg13g2_decap_8
XFILLER_2_713 VPWR VGND sg13g2_decap_8
XFILLER_9_4 VPWR VGND sg13g2_fill_2
XFILLER_1_223 VPWR VGND sg13g2_decap_8
XFILLER_49_238 VPWR VGND sg13g2_decap_8
XFILLER_2_29 VPWR VGND sg13g2_decap_8
XFILLER_46_967 VPWR VGND sg13g2_decap_8
XFILLER_45_433 VPWR VGND sg13g2_decap_4
XFILLER_17_113 VPWR VGND sg13g2_fill_1
XFILLER_45_499 VPWR VGND sg13g2_decap_8
XFILLER_26_691 VPWR VGND sg13g2_decap_8
XFILLER_41_661 VPWR VGND sg13g2_decap_8
XFILLER_9_323 VPWR VGND sg13g2_decap_8
XFILLER_14_886 VPWR VGND sg13g2_fill_1
XFILLER_15_91 VPWR VGND sg13g2_fill_1
XFILLER_40_182 VPWR VGND sg13g2_fill_1
XFILLER_9_356 VPWR VGND sg13g2_fill_2
XFILLER_12_1003 VPWR VGND sg13g2_decap_8
XFILLER_13_396 VPWR VGND sg13g2_fill_1
X_5152__142 VPWR VGND net142 sg13g2_tiehi
XFILLER_5_540 VPWR VGND sg13g2_decap_8
X_4150_ _1807_ _1794_ _1801_ VPWR VGND sg13g2_nand2_1
X_3101_ _0701_ _0715_ videogen.test_lut_thingy.pixel_feeder_inst.v_pix\[0\] _0853_
+ VPWR VGND sg13g2_nand3_1
XFILLER_49_761 VPWR VGND sg13g2_decap_8
X_4081_ _1737_ _1739_ _1733_ _0359_ VPWR VGND sg13g2_nand3_1
XFILLER_36_400 VPWR VGND sg13g2_decap_8
X_3032_ videogen.test_lut_thingy.pixel_feeder_inst.row\[37\]\[2\] net795 _0812_ _0325_
+ VPWR VGND sg13g2_mux2_1
XFILLER_36_422 VPWR VGND sg13g2_fill_2
XFILLER_36_455 VPWR VGND sg13g2_fill_1
XFILLER_36_477 VPWR VGND sg13g2_fill_1
X_4983_ net44 VGND VPWR _0337_ tmds_blue.dc_balancing_reg\[0\] net663 sg13g2_dfrbpq_1
X_3934_ net611 _1591_ _1596_ _1597_ VPWR VGND sg13g2_nor3_1
X_3865_ VGND VPWR _1233_ _1528_ _0355_ net775 sg13g2_a21oi_1
XFILLER_32_694 VPWR VGND sg13g2_fill_1
X_2816_ _0708_ _0757_ _0766_ VPWR VGND sg13g2_nor2_2
X_3796_ videogen.test_lut_thingy.pixel_feeder_inst.row\[17\]\[1\] net571 _1460_ VPWR
+ VGND sg13g2_nor2_1
X_2747_ _0740_ net559 _0741_ VPWR VGND sg13g2_nor2b_2
X_2678_ _0694_ _0695_ _0696_ VPWR VGND sg13g2_and2_1
X_4417_ _2059_ green\[6\] _2060_ VPWR VGND sg13g2_xor2_1
X_4348_ _1999_ _1988_ _1997_ VPWR VGND sg13g2_xnor2_1
X_4279_ _0363_ _1931_ _1932_ VPWR VGND sg13g2_nand2_1
XFILLER_39_271 VPWR VGND sg13g2_decap_8
X_4925__147 VPWR VGND net147 sg13g2_tiehi
XFILLER_36_24 VPWR VGND sg13g2_fill_2
XFILLER_11_823 VPWR VGND sg13g2_decap_4
XFILLER_23_661 VPWR VGND sg13g2_fill_2
XFILLER_11_856 VPWR VGND sg13g2_decap_8
XFILLER_11_867 VPWR VGND sg13g2_fill_1
XFILLER_22_193 VPWR VGND sg13g2_decap_4
XFILLER_7_849 VPWR VGND sg13g2_fill_1
XFILLER_7_838 VPWR VGND sg13g2_decap_8
XFILLER_2_532 VPWR VGND sg13g2_decap_8
XFILLER_38_709 VPWR VGND sg13g2_fill_1
XFILLER_37_219 VPWR VGND sg13g2_fill_2
XFILLER_19_967 VPWR VGND sg13g2_fill_2
XFILLER_46_764 VPWR VGND sg13g2_decap_8
XFILLER_45_252 VPWR VGND sg13g2_decap_8
XFILLER_18_488 VPWR VGND sg13g2_decap_4
X_3650_ net643 _1308_ _1313_ _1314_ VPWR VGND sg13g2_nor3_1
X_3581_ net611 VPWR _1245_ VGND videogen.test_lut_thingy.pixel_feeder_inst.row\[58\]\[3\]
+ net602 sg13g2_o21ai_1
X_5251_ net441 VGND VPWR _0601_ videogen.test_lut_thingy.pixel_feeder_inst.row\[49\]\[1\]
+ _0230_ sg13g2_dfrbpq_1
X_4202_ _1859_ _1845_ _1847_ VPWR VGND sg13g2_nand2_1
X_5182_ net439 VGND VPWR _0532_ videogen.test_lut_thingy.pixel_feeder_inst.row\[35\]\[0\]
+ _0161_ sg13g2_dfrbpq_1
X_4948__114 VPWR VGND net114 sg13g2_tiehi
X_5048__175 VPWR VGND net175 sg13g2_tiehi
XFILLER_3_72 VPWR VGND sg13g2_decap_4
X_4133_ _1788_ _1789_ _1790_ VPWR VGND sg13g2_and2_1
X_4064_ _1712_ _1713_ _1702_ _1724_ VPWR VGND _1715_ sg13g2_nand4_1
X_3015_ _0720_ _0735_ net560 _0809_ VPWR VGND sg13g2_nand3_1
XFILLER_25_959 VPWR VGND sg13g2_fill_1
X_4966_ net78 VGND VPWR _0320_ videogen.test_lut_thingy.pixel_feeder_inst.row\[34\]\[1\]
+ _0018_ sg13g2_dfrbpq_1
XFILLER_33_992 VPWR VGND sg13g2_decap_8
X_4897_ net711 net755 _0252_ VPWR VGND sg13g2_nor2_1
X_3917_ _1576_ _1577_ _1578_ _1579_ _1580_ VPWR VGND sg13g2_nor4_1
X_3848_ videogen.test_lut_thingy.pixel_feeder_inst.row\[37\]\[1\] net574 _1512_ VPWR
+ VGND sg13g2_nor2_1
X_3779_ videogen.test_lut_thingy.pixel_feeder_inst.row\[13\]\[1\] net573 _1443_ VPWR
+ VGND sg13g2_nor2_1
XFILLER_19_208 VPWR VGND sg13g2_fill_2
XFILLER_27_230 VPWR VGND sg13g2_fill_1
XFILLER_28_775 VPWR VGND sg13g2_decap_8
XFILLER_43_756 VPWR VGND sg13g2_fill_1
X_5218__256 VPWR VGND net256 sg13g2_tiehi
XFILLER_11_642 VPWR VGND sg13g2_decap_8
XFILLER_23_480 VPWR VGND sg13g2_decap_8
XFILLER_11_664 VPWR VGND sg13g2_fill_1
XFILLER_11_675 VPWR VGND sg13g2_fill_1
XFILLER_10_185 VPWR VGND sg13g2_fill_2
XFILLER_6_123 VPWR VGND sg13g2_decap_4
XFILLER_11_697 VPWR VGND sg13g2_decap_4
X_5114__243 VPWR VGND net243 sg13g2_tiehi
XFILLER_3_874 VPWR VGND sg13g2_decap_8
XFILLER_2_340 VPWR VGND sg13g2_decap_4
XFILLER_2_362 VPWR VGND sg13g2_decap_8
XFILLER_46_561 VPWR VGND sg13g2_decap_8
X_4820_ net695 net739 _0177_ VPWR VGND sg13g2_nor2_1
X_4751_ net692 net736 _0108_ VPWR VGND sg13g2_nor2_1
X_3702_ net615 VPWR _1366_ VGND videogen.test_lut_thingy.pixel_feeder_inst.row\[52\]\[2\]
+ net592 sg13g2_o21ai_1
X_4682_ net687 net731 _0039_ VPWR VGND sg13g2_nor2_1
X_3633_ net616 VPWR _1297_ VGND videogen.test_lut_thingy.pixel_feeder_inst.row\[4\]\[3\]
+ net597 sg13g2_o21ai_1
X_3564_ VGND VPWR _1211_ _1213_ _1228_ _1227_ sg13g2_a21oi_1
X_5303_ net326 VGND VPWR _0653_ serialize.shift_reg_g\[7\] clknet_3_6_0_clk_regs sg13g2_dfrbpq_1
X_3495_ VGND VPWR _1136_ _1152_ _1159_ _1155_ sg13g2_a21oi_1
X_5234_ net192 VGND VPWR _0584_ videogen.test_lut_thingy.pixel_feeder_inst.row\[40\]\[0\]
+ _0213_ sg13g2_dfrbpq_1
X_5165_ net91 VGND VPWR _0515_ tmds_blue.dc_balancing_reg\[4\] net663 sg13g2_dfrbpq_2
X_4116_ _1771_ _1772_ _1773_ VPWR VGND sg13g2_and2_1
X_5096_ net279 VGND VPWR _0446_ videogen.test_lut_thingy.pixel_feeder_inst.row\[11\]\[2\]
+ _0083_ sg13g2_dfrbpq_1
X_4047_ _1706_ VPWR _1707_ VGND _1683_ _1699_ sg13g2_o21ai_1
XFILLER_24_244 VPWR VGND sg13g2_decap_4
XFILLER_25_745 VPWR VGND sg13g2_fill_2
X_4949_ net112 VGND VPWR _0303_ videogen.test_lut_thingy.pixel_feeder_inst.v_pix\[4\]
+ net653 sg13g2_dfrbpq_1
X_5096__279 VPWR VGND net279 sg13g2_tiehi
XFILLER_21_962 VPWR VGND sg13g2_decap_8
XFILLER_32_1028 VPWR VGND sg13g2_fill_1
XFILLER_21_995 VPWR VGND sg13g2_decap_8
XFILLER_3_148 VPWR VGND sg13g2_decap_4
XFILLER_0_800 VPWR VGND sg13g2_decap_8
XFILLER_0_877 VPWR VGND sg13g2_decap_8
XFILLER_48_848 VPWR VGND sg13g2_decap_8
XFILLER_47_369 VPWR VGND sg13g2_fill_2
XFILLER_16_734 VPWR VGND sg13g2_decap_8
XFILLER_28_572 VPWR VGND sg13g2_decap_8
XFILLER_28_583 VPWR VGND sg13g2_fill_2
XFILLER_43_586 VPWR VGND sg13g2_decap_8
XFILLER_31_748 VPWR VGND sg13g2_decap_8
XFILLER_12_973 VPWR VGND sg13g2_decap_8
XFILLER_8_966 VPWR VGND sg13g2_decap_8
XFILLER_7_432 VPWR VGND sg13g2_fill_1
XFILLER_11_483 VPWR VGND sg13g2_decap_8
XFILLER_12_984 VPWR VGND sg13g2_fill_2
XFILLER_7_476 VPWR VGND sg13g2_decap_4
XFILLER_7_443 VPWR VGND sg13g2_decap_8
XFILLER_48_1002 VPWR VGND sg13g2_decap_8
XFILLER_3_671 VPWR VGND sg13g2_decap_8
X_3280_ _0961_ net820 net627 VPWR VGND sg13g2_nand2_1
XFILLER_24_4 VPWR VGND sg13g2_decap_8
XFILLER_0_84 VPWR VGND sg13g2_decap_8
XFILLER_22_704 VPWR VGND sg13g2_decap_8
X_4803_ net682 net726 _0160_ VPWR VGND sg13g2_nor2_1
XFILLER_22_748 VPWR VGND sg13g2_fill_2
X_4734_ net702 net746 _0091_ VPWR VGND sg13g2_nor2_1
X_2995_ net606 net558 _0740_ _0805_ VPWR VGND sg13g2_nor3_2
XFILLER_21_269 VPWR VGND sg13g2_fill_1
X_4665_ net720 net765 _0024_ VPWR VGND sg13g2_nor2_1
X_4596_ _2213_ net673 net469 net679 blue_tmds_par\[0\] VPWR VGND sg13g2_a22oi_1
X_3616_ _1279_ VPWR _1280_ VGND _1244_ _1255_ sg13g2_o21ai_1
X_3547_ _1200_ _1210_ _1012_ _1211_ VPWR VGND sg13g2_nand3_1
X_3478_ VPWR _1142_ net561 VGND sg13g2_inv_1
X_5217_ net260 VGND VPWR _0567_ videogen.test_lut_thingy.pixel_feeder_inst.row\[44\]\[3\]
+ _0196_ sg13g2_dfrbpq_1
X_5148_ net171 VGND VPWR _0498_ videogen.test_lut_thingy.pixel_feeder_inst.row\[53\]\[2\]
+ _0135_ sg13g2_dfrbpq_1
XFILLER_45_829 VPWR VGND sg13g2_decap_8
X_5079_ net313 VGND VPWR _0429_ videogen.test_lut_thingy.pixel_feeder_inst.row\[30\]\[1\]
+ _0066_ sg13g2_dfrbpq_1
XFILLER_29_369 VPWR VGND sg13g2_fill_1
XFILLER_38_892 VPWR VGND sg13g2_decap_4
XFILLER_44_35 VPWR VGND sg13g2_decap_4
XFILLER_9_708 VPWR VGND sg13g2_fill_1
XFILLER_8_229 VPWR VGND sg13g2_decap_8
XFILLER_21_770 VPWR VGND sg13g2_decap_8
XFILLER_21_781 VPWR VGND sg13g2_fill_2
XFILLER_5_936 VPWR VGND sg13g2_decap_8
XFILLER_4_413 VPWR VGND sg13g2_fill_2
XFILLER_4_468 VPWR VGND sg13g2_decap_4
XFILLER_0_674 VPWR VGND sg13g2_decap_8
XFILLER_48_645 VPWR VGND sg13g2_decap_8
XFILLER_47_199 VPWR VGND sg13g2_fill_1
XFILLER_28_391 VPWR VGND sg13g2_fill_1
XFILLER_35_339 VPWR VGND sg13g2_decap_8
XFILLER_44_862 VPWR VGND sg13g2_decap_8
XFILLER_31_501 VPWR VGND sg13g2_fill_1
XFILLER_31_512 VPWR VGND sg13g2_fill_1
X_4985__40 VPWR VGND net40 sg13g2_tiehi
XFILLER_15_1001 VPWR VGND sg13g2_fill_2
X_2780_ videogen.test_lut_thingy.pixel_feeder_inst.row\[3\]\[2\] net796 _0756_ _0590_
+ VPWR VGND sg13g2_mux2_1
XFILLER_31_589 VPWR VGND sg13g2_decap_8
XFILLER_11_280 VPWR VGND sg13g2_fill_2
XFILLER_8_796 VPWR VGND sg13g2_decap_8
XFILLER_7_262 VPWR VGND sg13g2_fill_2
XFILLER_7_251 VPWR VGND sg13g2_fill_1
X_4450_ VGND VPWR _2083_ _2084_ _2086_ _2059_ sg13g2_a21oi_1
X_4381_ _2031_ _2030_ _2017_ _2028_ _1983_ VPWR VGND sg13g2_a22oi_1
X_3401_ _1065_ _1063_ _1062_ VPWR VGND sg13g2_nand2b_1
X_3332_ _0996_ videogen.fancy_shader.video_y\[1\] net632 VPWR VGND sg13g2_nand2_1
Xfanout709 net724 net709 VPWR VGND sg13g2_buf_8
X_3263_ net631 _0943_ net630 _0949_ VPWR VGND sg13g2_nand3_1
XFILLER_39_634 VPWR VGND sg13g2_decap_8
X_3194_ net563 _0899_ _0900_ _0303_ VPWR VGND sg13g2_nor3_1
X_5002_ net427 VGND VPWR _0356_ blue\[0\] net660 sg13g2_dfrbpq_1
XFILLER_27_807 VPWR VGND sg13g2_decap_4
XFILLER_38_177 VPWR VGND sg13g2_fill_2
XFILLER_26_317 VPWR VGND sg13g2_decap_4
XFILLER_35_840 VPWR VGND sg13g2_fill_2
XFILLER_41_309 VPWR VGND sg13g2_fill_2
XFILLER_34_350 VPWR VGND sg13g2_fill_1
XFILLER_14_38 VPWR VGND sg13g2_fill_1
X_2978_ videogen.test_lut_thingy.pixel_feeder_inst.row\[30\]\[1\] net803 _0801_ _0429_
+ VPWR VGND sg13g2_mux2_1
X_4717_ net699 net743 _0074_ VPWR VGND sg13g2_nor2_1
X_4648_ net711 net755 _0007_ VPWR VGND sg13g2_nor2_1
XFILLER_30_48 VPWR VGND sg13g2_fill_2
X_4579_ _2202_ net820 _2196_ VPWR VGND sg13g2_nand2_1
XFILLER_39_46 VPWR VGND sg13g2_decap_8
XFILLER_39_35 VPWR VGND sg13g2_fill_1
XFILLER_40_386 VPWR VGND sg13g2_decap_4
XFILLER_9_527 VPWR VGND sg13g2_decap_8
X_5191__373 VPWR VGND net373 sg13g2_tiehi
XFILLER_5_733 VPWR VGND sg13g2_decap_8
XFILLER_20_81 VPWR VGND sg13g2_fill_1
XFILLER_49_943 VPWR VGND sg13g2_decap_8
XFILLER_0_471 VPWR VGND sg13g2_decap_8
XFILLER_1_994 VPWR VGND sg13g2_decap_8
XFILLER_36_637 VPWR VGND sg13g2_decap_8
X_3950_ videogen.test_lut_thingy.pixel_feeder_inst.row\[41\]\[0\] net575 _1613_ VPWR
+ VGND sg13g2_nor2_1
XFILLER_17_862 VPWR VGND sg13g2_decap_8
XFILLER_35_169 VPWR VGND sg13g2_fill_1
XFILLER_44_692 VPWR VGND sg13g2_decap_4
X_2901_ net798 videogen.test_lut_thingy.pixel_feeder_inst.row\[10\]\[1\] _0784_ _0489_
+ VPWR VGND sg13g2_mux2_1
XFILLER_32_843 VPWR VGND sg13g2_decap_8
X_3881_ _1540_ _1541_ _1542_ _1543_ _1544_ VPWR VGND sg13g2_nor4_1
X_2832_ net779 videogen.test_lut_thingy.pixel_feeder_inst.row\[48\]\[3\] _0769_ _0551_
+ VPWR VGND sg13g2_mux2_1
X_2763_ _0749_ net619 VPWR VGND _0712_ sg13g2_nand2b_2
X_4502_ _2131_ net624 _2129_ VPWR VGND sg13g2_nand2_2
X_2694_ _0710_ _0711_ _0712_ VPWR VGND sg13g2_nor2b_2
X_4433_ green\[7\] green\[6\] net622 _2069_ VPWR VGND sg13g2_nand3_1
X_4364_ _2013_ VPWR _2014_ VGND _0690_ _1976_ sg13g2_o21ai_1
X_5309__238 VPWR VGND net238 sg13g2_tiehi
X_4295_ _1945_ red\[7\] _1947_ VPWR VGND sg13g2_xor2_1
X_3315_ net771 videogen.test_lut_thingy.gol_counter_reg\[0\] _0349_ VPWR VGND sg13g2_nor2_1
X_3246_ _0935_ VPWR _0937_ VGND net633 _0936_ sg13g2_o21ai_1
X_3177_ _0702_ _0696_ net769 _0888_ VPWR VGND sg13g2_a21o_2
XFILLER_42_618 VPWR VGND sg13g2_decap_8
XFILLER_14_309 VPWR VGND sg13g2_fill_2
XFILLER_41_117 VPWR VGND sg13g2_decap_4
XFILLER_41_106 VPWR VGND sg13g2_decap_8
XFILLER_34_191 VPWR VGND sg13g2_decap_8
XFILLER_6_508 VPWR VGND sg13g2_decap_8
XFILLER_2_769 VPWR VGND sg13g2_decap_8
XFILLER_18_626 VPWR VGND sg13g2_decap_4
XFILLER_46_946 VPWR VGND sg13g2_decap_8
XFILLER_18_659 VPWR VGND sg13g2_decap_4
XFILLER_26_681 VPWR VGND sg13g2_decap_4
XFILLER_32_117 VPWR VGND sg13g2_fill_1
XFILLER_41_640 VPWR VGND sg13g2_decap_8
XFILLER_14_865 VPWR VGND sg13g2_fill_2
XFILLER_25_191 VPWR VGND sg13g2_decap_8
XFILLER_40_150 VPWR VGND sg13g2_decap_4
XFILLER_9_379 VPWR VGND sg13g2_decap_8
X_3100_ net620 VPWR _0852_ VGND _0850_ _0851_ sg13g2_o21ai_1
XFILLER_49_740 VPWR VGND sg13g2_decap_8
XFILLER_0_290 VPWR VGND sg13g2_fill_1
XFILLER_1_791 VPWR VGND sg13g2_decap_8
X_4080_ _1739_ _1736_ _1738_ VPWR VGND sg13g2_nand2_1
X_5124__223 VPWR VGND net223 sg13g2_tiehi
X_3031_ videogen.test_lut_thingy.pixel_feeder_inst.row\[37\]\[3\] net786 _0812_ _0326_
+ VPWR VGND sg13g2_mux2_1
XFILLER_24_618 VPWR VGND sg13g2_decap_8
X_4982_ net46 VGND VPWR _0336_ videogen.fancy_shader.shader_counter_reg\[9\] net658
+ sg13g2_dfrbpq_1
XFILLER_23_117 VPWR VGND sg13g2_fill_1
XFILLER_36_489 VPWR VGND sg13g2_fill_2
X_3933_ _1592_ _1593_ _1594_ _1595_ _1596_ VPWR VGND sg13g2_nor4_1
XFILLER_16_191 VPWR VGND sg13g2_fill_2
X_3864_ _1528_ _1331_ _1527_ VPWR VGND sg13g2_nand2_1
XFILLER_20_868 VPWR VGND sg13g2_decap_8
XFILLER_31_172 VPWR VGND sg13g2_fill_2
X_2815_ videogen.test_lut_thingy.pixel_feeder_inst.row\[44\]\[0\] net815 _0765_ _0564_
+ VPWR VGND sg13g2_mux2_1
X_3795_ videogen.test_lut_thingy.pixel_feeder_inst.row\[16\]\[1\] net590 _1459_ VPWR
+ VGND sg13g2_nor2_1
XFILLER_11_39 VPWR VGND sg13g2_decap_4
X_2746_ net619 _0712_ net634 _0740_ VPWR VGND _0738_ sg13g2_nand4_1
X_2677_ videogen.fancy_shader.video_y\[3\] videogen.fancy_shader.video_y\[2\] videogen.fancy_shader.video_y\[1\]
+ net629 _0695_ VPWR VGND sg13g2_nor4_1
X_5211__284 VPWR VGND net284 sg13g2_tiehi
X_4416_ _2058_ VPWR _2059_ VGND _2051_ _2053_ sg13g2_o21ai_1
X_4347_ _1988_ _1997_ _1998_ VPWR VGND sg13g2_nor2b_1
X_4278_ VGND VPWR _1934_ _1932_ _1624_ sg13g2_or2_1
XFILLER_46_209 VPWR VGND sg13g2_decap_8
X_3229_ VPWR _0313_ _0925_ VGND sg13g2_inv_1
XFILLER_27_401 VPWR VGND sg13g2_decap_8
XFILLER_27_412 VPWR VGND sg13g2_fill_2
XFILLER_27_478 VPWR VGND sg13g2_decap_4
XFILLER_36_47 VPWR VGND sg13g2_decap_4
XFILLER_43_938 VPWR VGND sg13g2_fill_2
XFILLER_14_106 VPWR VGND sg13g2_decap_8
XFILLER_11_802 VPWR VGND sg13g2_decap_8
XFILLER_10_312 VPWR VGND sg13g2_decap_8
XFILLER_7_817 VPWR VGND sg13g2_decap_8
X_4960__90 VPWR VGND net90 sg13g2_tiehi
XFILLER_2_511 VPWR VGND sg13g2_decap_8
XFILLER_42_1008 VPWR VGND sg13g2_decap_8
XFILLER_2_588 VPWR VGND sg13g2_decap_8
XFILLER_46_743 VPWR VGND sg13g2_decap_8
XFILLER_33_448 VPWR VGND sg13g2_fill_1
XFILLER_33_459 VPWR VGND sg13g2_decap_4
XFILLER_42_993 VPWR VGND sg13g2_decap_4
XFILLER_41_481 VPWR VGND sg13g2_decap_8
XFILLER_13_172 VPWR VGND sg13g2_decap_8
XFILLER_9_154 VPWR VGND sg13g2_fill_1
X_3580_ net638 _1238_ _1243_ _1244_ VPWR VGND sg13g2_nor3_1
X_5250_ net35 VGND VPWR _0600_ videogen.test_lut_thingy.pixel_feeder_inst.row\[49\]\[0\]
+ _0229_ sg13g2_dfrbpq_1
XFILLER_6_883 VPWR VGND sg13g2_decap_8
XFILLER_5_360 VPWR VGND sg13g2_decap_4
X_4201_ _1845_ _1847_ _1858_ VPWR VGND sg13g2_and2_1
X_5181_ net443 VGND VPWR _0531_ videogen.test_lut_thingy.pixel_feeder_inst.row\[27\]\[3\]
+ _0160_ sg13g2_dfrbpq_1
X_4132_ _1746_ _1769_ _1789_ VPWR VGND sg13g2_nor2_1
X_4063_ _1177_ _1719_ _1721_ _1722_ _1723_ VPWR VGND sg13g2_nor4_1
XFILLER_37_721 VPWR VGND sg13g2_fill_1
X_3014_ net809 videogen.test_lut_thingy.pixel_feeder_inst.row\[16\]\[0\] _0808_ _0391_
+ VPWR VGND sg13g2_mux2_1
XFILLER_37_798 VPWR VGND sg13g2_decap_4
X_4965_ net80 VGND VPWR _0319_ videogen.test_lut_thingy.pixel_feeder_inst.row\[34\]\[0\]
+ _0017_ sg13g2_dfrbpq_1
X_3916_ videogen.test_lut_thingy.pixel_feeder_inst.row\[59\]\[0\] net579 _1579_ VPWR
+ VGND sg13g2_nor2_1
X_4896_ net710 net754 _0251_ VPWR VGND sg13g2_nor2_1
XFILLER_22_16 VPWR VGND sg13g2_decap_8
XFILLER_20_654 VPWR VGND sg13g2_decap_4
XFILLER_22_27 VPWR VGND sg13g2_fill_2
X_3847_ net647 VPWR _1511_ VGND videogen.test_lut_thingy.pixel_feeder_inst.row\[36\]\[1\]
+ net598 sg13g2_o21ai_1
X_3778_ videogen.test_lut_thingy.pixel_feeder_inst.row\[14\]\[1\] net604 _1442_ VPWR
+ VGND sg13g2_nor2_1
XFILLER_20_698 VPWR VGND sg13g2_decap_8
X_2729_ net776 videogen.test_lut_thingy.pixel_feeder_inst.row\[24\]\[3\] _0734_ _0629_
+ VPWR VGND sg13g2_mux2_1
XFILLER_47_529 VPWR VGND sg13g2_decap_8
XFILLER_47_46 VPWR VGND sg13g2_fill_2
XFILLER_47_35 VPWR VGND sg13g2_decap_8
XFILLER_43_702 VPWR VGND sg13g2_fill_1
XFILLER_28_787 VPWR VGND sg13g2_fill_1
XFILLER_42_234 VPWR VGND sg13g2_decap_8
XFILLER_43_779 VPWR VGND sg13g2_fill_1
XFILLER_42_278 VPWR VGND sg13g2_decap_4
XFILLER_8_29 VPWR VGND sg13g2_decap_8
XFILLER_24_993 VPWR VGND sg13g2_fill_1
XFILLER_10_131 VPWR VGND sg13g2_fill_2
X_5038__378 VPWR VGND net378 sg13g2_tiehi
XFILLER_10_153 VPWR VGND sg13g2_fill_2
XFILLER_7_658 VPWR VGND sg13g2_fill_1
XFILLER_3_853 VPWR VGND sg13g2_decap_8
X_5225__228 VPWR VGND net228 sg13g2_tiehi
XFILLER_19_754 VPWR VGND sg13g2_fill_2
XFILLER_15_960 VPWR VGND sg13g2_decap_4
X_4750_ net695 net739 _0107_ VPWR VGND sg13g2_nor2_1
XFILLER_14_492 VPWR VGND sg13g2_fill_2
X_4681_ net686 net730 _0038_ VPWR VGND sg13g2_nor2_1
XFILLER_30_952 VPWR VGND sg13g2_decap_4
X_3701_ net644 _1359_ _1364_ _1365_ VPWR VGND sg13g2_nor3_1
X_3632_ _1292_ _1293_ _1294_ _1295_ _1296_ VPWR VGND sg13g2_nor4_1
X_3563_ VGND VPWR _1211_ _1216_ _1227_ _1213_ sg13g2_a21oi_1
X_5302_ net334 VGND VPWR _0652_ serialize.shift_reg_g\[6\] clknet_3_5_0_clk_regs sg13g2_dfrbpq_1
XFILLER_45_0 VPWR VGND sg13g2_decap_8
X_3494_ _1158_ _1156_ _1157_ VPWR VGND sg13g2_nand2_1
X_5233_ net196 VGND VPWR _0583_ videogen.test_lut_thingy.pixel_feeder_inst.row\[41\]\[3\]
+ _0212_ sg13g2_dfrbpq_1
X_5164_ net93 VGND VPWR _0514_ tmds_blue.dc_balancing_reg\[3\] net659 sg13g2_dfrbpq_2
X_4115_ _1772_ _1659_ _1770_ VPWR VGND sg13g2_nand2b_1
XFILLER_29_518 VPWR VGND sg13g2_fill_2
X_5095_ net281 VGND VPWR _0445_ videogen.test_lut_thingy.pixel_feeder_inst.row\[11\]\[1\]
+ _0082_ sg13g2_dfrbpq_1
X_4046_ _1705_ VPWR _1706_ VGND _1672_ _1681_ sg13g2_o21ai_1
XFILLER_25_724 VPWR VGND sg13g2_decap_8
XFILLER_12_407 VPWR VGND sg13g2_decap_4
XFILLER_13_919 VPWR VGND sg13g2_fill_2
XFILLER_24_267 VPWR VGND sg13g2_decap_8
X_4948_ net114 VGND VPWR _0302_ videogen.test_lut_thingy.pixel_feeder_inst.v_pix\[3\]
+ net653 sg13g2_dfrbpq_2
XFILLER_21_974 VPWR VGND sg13g2_decap_8
XFILLER_32_1018 VPWR VGND sg13g2_fill_1
X_4879_ net720 net765 _0236_ VPWR VGND sg13g2_nor2_1
XFILLER_20_473 VPWR VGND sg13g2_decap_4
XFILLER_20_484 VPWR VGND sg13g2_decap_8
XFILLER_4_628 VPWR VGND sg13g2_fill_1
XFILLER_0_856 VPWR VGND sg13g2_decap_8
XFILLER_48_827 VPWR VGND sg13g2_decap_8
XFILLER_47_304 VPWR VGND sg13g2_fill_1
XFILLER_47_337 VPWR VGND sg13g2_decap_8
XFILLER_47_315 VPWR VGND sg13g2_decap_4
XFILLER_15_245 VPWR VGND sg13g2_fill_1
XFILLER_31_727 VPWR VGND sg13g2_decap_8
XFILLER_8_945 VPWR VGND sg13g2_decap_8
XFILLER_7_422 VPWR VGND sg13g2_decap_4
XFILLER_38_304 VPWR VGND sg13g2_decap_8
XFILLER_19_551 VPWR VGND sg13g2_decap_8
XFILLER_47_893 VPWR VGND sg13g2_decap_8
XFILLER_19_562 VPWR VGND sg13g2_fill_2
XFILLER_34_510 VPWR VGND sg13g2_decap_8
XFILLER_0_63 VPWR VGND sg13g2_decap_8
XFILLER_34_543 VPWR VGND sg13g2_decap_4
XFILLER_34_576 VPWR VGND sg13g2_fill_1
X_2994_ videogen.test_lut_thingy.pixel_feeder_inst.row\[32\]\[0\] net815 _0804_ _0416_
+ VPWR VGND sg13g2_mux2_1
X_4802_ net685 net729 _0159_ VPWR VGND sg13g2_nor2_1
XFILLER_9_61 VPWR VGND sg13g2_decap_4
X_4733_ net699 net743 _0090_ VPWR VGND sg13g2_nor2_1
X_4664_ net719 net764 _0023_ VPWR VGND sg13g2_nor2_1
X_4595_ _2212_ VPWR _0621_ VGND net483 _0869_ sg13g2_o21ai_1
X_3615_ _1278_ net635 _1279_ VPWR VGND sg13g2_nor2b_1
X_3546_ _1208_ _1209_ _1210_ VPWR VGND sg13g2_nor2_1
XFILLER_1_609 VPWR VGND sg13g2_decap_8
X_5216_ net264 VGND VPWR _0566_ videogen.test_lut_thingy.pixel_feeder_inst.row\[44\]\[2\]
+ _0195_ sg13g2_dfrbpq_1
X_3477_ _1140_ _1138_ _1141_ VPWR VGND sg13g2_xor2_1
X_5147_ net173 VGND VPWR _0497_ videogen.test_lut_thingy.pixel_feeder_inst.row\[53\]\[1\]
+ _0134_ sg13g2_dfrbpq_1
XFILLER_45_808 VPWR VGND sg13g2_decap_8
X_5078_ net315 VGND VPWR _0428_ videogen.test_lut_thingy.pixel_feeder_inst.row\[30\]\[0\]
+ _0065_ sg13g2_dfrbpq_1
XFILLER_29_348 VPWR VGND sg13g2_fill_2
X_4029_ _1669_ VPWR _1689_ VGND _1672_ _1681_ sg13g2_o21ai_1
XFILLER_13_716 VPWR VGND sg13g2_fill_1
XFILLER_44_69 VPWR VGND sg13g2_fill_2
XFILLER_12_204 VPWR VGND sg13g2_decap_8
XFILLER_12_215 VPWR VGND sg13g2_fill_2
XFILLER_13_738 VPWR VGND sg13g2_decap_4
XFILLER_5_915 VPWR VGND sg13g2_decap_8
Xheichips25_bagel_30 VPWR VGND uio_out[5] sg13g2_tielo
XFILLER_0_653 VPWR VGND sg13g2_decap_8
XFILLER_48_624 VPWR VGND sg13g2_decap_8
XFILLER_44_841 VPWR VGND sg13g2_decap_8
XFILLER_16_554 VPWR VGND sg13g2_decap_8
XFILLER_44_896 VPWR VGND sg13g2_decap_8
XFILLER_8_775 VPWR VGND sg13g2_decap_8
X_3400_ _1063_ _1033_ _1062_ _1064_ VPWR VGND sg13g2_a21o_1
X_4380_ _1983_ net555 _2030_ VPWR VGND sg13g2_nor2b_2
XFILLER_4_981 VPWR VGND sg13g2_decap_8
X_3331_ _0995_ net629 net633 VPWR VGND sg13g2_nand2_1
X_3262_ VGND VPWR net631 _0943_ _0948_ net630 sg13g2_a21oi_1
XFILLER_39_613 VPWR VGND sg13g2_decap_8
X_3193_ _0900_ videogen.test_lut_thingy.pixel_feeder_inst.v_pix\[4\] videogen.test_lut_thingy.pixel_feeder_inst.v_pix\[3\]
+ _0897_ VPWR VGND sg13g2_and3_1
X_5001_ net428 VGND VPWR _0355_ blue\[1\] net659 sg13g2_dfrbpq_2
XFILLER_22_1028 VPWR VGND sg13g2_fill_1
XFILLER_47_690 VPWR VGND sg13g2_decap_8
XFILLER_19_381 VPWR VGND sg13g2_decap_8
XFILLER_22_535 VPWR VGND sg13g2_decap_8
XFILLER_10_708 VPWR VGND sg13g2_fill_2
XFILLER_22_557 VPWR VGND sg13g2_decap_8
X_2977_ videogen.test_lut_thingy.pixel_feeder_inst.row\[30\]\[2\] net792 _0801_ _0430_
+ VPWR VGND sg13g2_mux2_1
X_5134__203 VPWR VGND net203 sg13g2_tiehi
X_4716_ net699 net743 _0073_ VPWR VGND sg13g2_nor2_1
X_4647_ net711 net755 _0006_ VPWR VGND sg13g2_nor2_1
X_4578_ _2200_ _2201_ _0613_ VPWR VGND sg13g2_nor2_1
X_3529_ _1187_ _1189_ _1117_ _1193_ VPWR VGND sg13g2_nand3_1
XFILLER_17_318 VPWR VGND sg13g2_decap_8
XFILLER_45_649 VPWR VGND sg13g2_decap_8
XFILLER_38_1024 VPWR VGND sg13g2_decap_4
XFILLER_25_362 VPWR VGND sg13g2_fill_1
XFILLER_25_373 VPWR VGND sg13g2_fill_2
XFILLER_40_365 VPWR VGND sg13g2_decap_8
XFILLER_5_712 VPWR VGND sg13g2_fill_2
XFILLER_4_233 VPWR VGND sg13g2_decap_8
XFILLER_5_789 VPWR VGND sg13g2_decap_8
XFILLER_4_244 VPWR VGND sg13g2_fill_1
XFILLER_45_1017 VPWR VGND sg13g2_decap_8
XFILLER_49_922 VPWR VGND sg13g2_decap_8
XFILLER_0_450 VPWR VGND sg13g2_decap_8
XFILLER_1_973 VPWR VGND sg13g2_decap_8
XFILLER_49_999 VPWR VGND sg13g2_decap_8
XFILLER_48_498 VPWR VGND sg13g2_decap_8
XFILLER_35_148 VPWR VGND sg13g2_decap_4
XFILLER_44_671 VPWR VGND sg13g2_decap_8
X_2900_ net787 videogen.test_lut_thingy.pixel_feeder_inst.row\[10\]\[2\] _0784_ _0490_
+ VPWR VGND sg13g2_mux2_1
X_3880_ net610 VPWR _1543_ VGND videogen.test_lut_thingy.pixel_feeder_inst.row\[10\]\[0\]
+ net601 sg13g2_o21ai_1
X_2831_ _0769_ _0731_ _0744_ VPWR VGND sg13g2_nand2_2
XFILLER_31_365 VPWR VGND sg13g2_fill_1
X_2762_ _0681_ _0712_ _0748_ VPWR VGND sg13g2_nor2_1
XFILLER_31_398 VPWR VGND sg13g2_fill_1
X_4501_ _2130_ _2125_ VPWR VGND tmds_blue.dc_balancing_reg\[4\] sg13g2_nand2b_2
XFILLER_6_40 VPWR VGND sg13g2_fill_1
X_4432_ VGND VPWR _0685_ _2066_ _0408_ _2068_ sg13g2_a21oi_1
X_2693_ net638 VPWR _0711_ VGND net643 net588 sg13g2_o21ai_1
XFILLER_6_62 VPWR VGND sg13g2_decap_4
X_4363_ _2013_ _1976_ _1978_ VPWR VGND sg13g2_nand2_1
X_3314_ _0969_ _0983_ _0348_ VPWR VGND sg13g2_nor2_1
X_4294_ _1946_ red\[7\] _1945_ VPWR VGND sg13g2_nand2_1
X_3245_ net772 _0934_ _0936_ VPWR VGND sg13g2_nor2_2
X_3176_ VGND VPWR net770 _0298_ _0887_ _0694_ sg13g2_a21oi_2
XFILLER_27_616 VPWR VGND sg13g2_decap_4
XFILLER_26_104 VPWR VGND sg13g2_decap_8
XFILLER_26_148 VPWR VGND sg13g2_decap_4
XFILLER_35_682 VPWR VGND sg13g2_decap_8
XFILLER_23_899 VPWR VGND sg13g2_decap_8
XFILLER_41_37 VPWR VGND sg13g2_fill_2
XFILLER_10_538 VPWR VGND sg13g2_fill_2
XFILLER_2_748 VPWR VGND sg13g2_decap_8
XFILLER_49_218 VPWR VGND sg13g2_decap_8
XFILLER_46_925 VPWR VGND sg13g2_decap_8
XFILLER_45_402 VPWR VGND sg13g2_decap_8
XFILLER_13_332 VPWR VGND sg13g2_decap_4
XFILLER_9_314 VPWR VGND sg13g2_fill_1
XFILLER_13_354 VPWR VGND sg13g2_decap_4
XFILLER_13_387 VPWR VGND sg13g2_decap_8
XFILLER_49_7 VPWR VGND sg13g2_decap_8
XFILLER_5_575 VPWR VGND sg13g2_fill_2
XFILLER_1_770 VPWR VGND sg13g2_decap_8
X_3030_ _0708_ _0740_ _0812_ VPWR VGND sg13g2_nor2_2
XFILLER_49_796 VPWR VGND sg13g2_decap_8
X_5198__336 VPWR VGND net336 sg13g2_tiehi
X_4981_ net48 VGND VPWR _0335_ videogen.fancy_shader.shader_counter_reg\[8\] net658
+ sg13g2_dfrbpq_2
X_4998__431 VPWR VGND net431 sg13g2_tiehi
X_3932_ videogen.test_lut_thingy.pixel_feeder_inst.row\[55\]\[0\] net581 _1595_ VPWR
+ VGND sg13g2_nor2_1
XFILLER_16_170 VPWR VGND sg13g2_decap_8
X_3863_ _1527_ _1428_ _1525_ VPWR VGND sg13g2_nand2_1
X_2814_ videogen.test_lut_thingy.pixel_feeder_inst.row\[44\]\[1\] net806 _0765_ _0565_
+ VPWR VGND sg13g2_mux2_1
XFILLER_20_847 VPWR VGND sg13g2_fill_1
XFILLER_31_195 VPWR VGND sg13g2_fill_2
X_3794_ net615 VPWR _1458_ VGND videogen.test_lut_thingy.pixel_feeder_inst.row\[19\]\[1\]
+ net577 sg13g2_o21ai_1
X_2745_ _0739_ net562 _0718_ VPWR VGND sg13g2_nand2b_1
X_2676_ videogen.fancy_shader.video_y\[4\] _0693_ _0694_ VPWR VGND sg13g2_nor2b_1
X_4415_ _2058_ _0683_ tmds_green.dc_balancing_reg\[4\] VPWR VGND sg13g2_nand2_1
X_4346_ _1997_ _1965_ _1989_ VPWR VGND sg13g2_nand2_1
X_4277_ VPWR _1933_ _1932_ VGND sg13g2_inv_1
X_3228_ _0924_ VPWR _0925_ VGND videogen.test_lut_thingy.pixel_feeder_inst.v_counter\[2\]
+ _0923_ sg13g2_o21ai_1
XFILLER_39_295 VPWR VGND sg13g2_fill_1
X_3159_ _0877_ net819 _0876_ VPWR VGND sg13g2_nand2_1
XFILLER_27_446 VPWR VGND sg13g2_decap_4
XFILLER_36_991 VPWR VGND sg13g2_fill_1
XFILLER_23_663 VPWR VGND sg13g2_fill_1
XFILLER_35_1027 VPWR VGND sg13g2_fill_2
XFILLER_22_173 VPWR VGND sg13g2_decap_8
XFILLER_23_696 VPWR VGND sg13g2_decap_8
XFILLER_2_567 VPWR VGND sg13g2_decap_8
XFILLER_19_914 VPWR VGND sg13g2_fill_2
XFILLER_46_722 VPWR VGND sg13g2_decap_8
XFILLER_18_424 VPWR VGND sg13g2_decap_4
XFILLER_45_221 VPWR VGND sg13g2_fill_1
XFILLER_18_446 VPWR VGND sg13g2_fill_2
XFILLER_46_799 VPWR VGND sg13g2_decap_8
XFILLER_9_133 VPWR VGND sg13g2_decap_8
XFILLER_6_862 VPWR VGND sg13g2_decap_8
X_4200_ _1849_ _1856_ _1857_ VPWR VGND sg13g2_nor2_1
X_5180_ net33 VGND VPWR _0530_ videogen.test_lut_thingy.pixel_feeder_inst.row\[27\]\[2\]
+ _0159_ sg13g2_dfrbpq_1
X_4131_ _1781_ _1787_ _1788_ VPWR VGND sg13g2_and2_1
X_4062_ _1712_ _1713_ _1715_ _1718_ _1722_ VPWR VGND sg13g2_and4_1
XFILLER_49_593 VPWR VGND sg13g2_decap_8
XFILLER_3_1014 VPWR VGND sg13g2_decap_8
X_3013_ net799 videogen.test_lut_thingy.pixel_feeder_inst.row\[16\]\[1\] _0808_ _0392_
+ VPWR VGND sg13g2_mux2_1
XFILLER_37_777 VPWR VGND sg13g2_fill_1
XFILLER_36_254 VPWR VGND sg13g2_fill_2
XFILLER_36_276 VPWR VGND sg13g2_decap_8
X_4964_ net82 VGND VPWR _0318_ videogen.test_lut_thingy.pixel_feeder_inst.h_counter\[3\]
+ net655 sg13g2_dfrbpq_1
X_5239__152 VPWR VGND net152 sg13g2_tiehi
X_3915_ videogen.test_lut_thingy.pixel_feeder_inst.row\[58\]\[0\] net602 _1578_ VPWR
+ VGND sg13g2_nor2_1
X_4895_ net711 net755 _0250_ VPWR VGND sg13g2_nor2_1
XFILLER_20_622 VPWR VGND sg13g2_decap_8
X_3846_ net617 _1504_ _1509_ _1510_ VPWR VGND sg13g2_nor3_1
X_3777_ net641 VPWR _1441_ VGND videogen.test_lut_thingy.pixel_feeder_inst.row\[12\]\[1\]
+ net594 sg13g2_o21ai_1
X_2728_ _0734_ _0731_ _0732_ VPWR VGND sg13g2_nand2_2
X_2659_ VPWR _0678_ net647 VGND sg13g2_inv_1
X_5183__435 VPWR VGND net435 sg13g2_tiehi
X_4329_ tmds_red.dc_balancing_reg\[4\] _1974_ _1979_ _1980_ _1981_ VPWR VGND sg13g2_nor4_1
XFILLER_47_508 VPWR VGND sg13g2_decap_8
XFILLER_47_14 VPWR VGND sg13g2_decap_8
XFILLER_47_58 VPWR VGND sg13g2_decap_8
XFILLER_43_714 VPWR VGND sg13g2_decap_4
X_5142__187 VPWR VGND net187 sg13g2_tiehi
XFILLER_16_928 VPWR VGND sg13g2_decap_8
XFILLER_16_939 VPWR VGND sg13g2_fill_1
XFILLER_43_747 VPWR VGND sg13g2_decap_4
XFILLER_42_213 VPWR VGND sg13g2_decap_8
XFILLER_15_438 VPWR VGND sg13g2_decap_4
XFILLER_10_110 VPWR VGND sg13g2_decap_8
XFILLER_23_493 VPWR VGND sg13g2_decap_8
XFILLER_7_604 VPWR VGND sg13g2_fill_1
XFILLER_10_187 VPWR VGND sg13g2_fill_1
XFILLER_5_0 VPWR VGND sg13g2_fill_2
XFILLER_3_832 VPWR VGND sg13g2_decap_8
Xfanout690 net691 net690 VPWR VGND sg13g2_buf_1
XFILLER_19_733 VPWR VGND sg13g2_decap_8
XFILLER_18_276 VPWR VGND sg13g2_decap_8
XFILLER_19_788 VPWR VGND sg13g2_fill_2
XFILLER_46_596 VPWR VGND sg13g2_decap_8
XFILLER_18_287 VPWR VGND sg13g2_fill_2
XFILLER_34_736 VPWR VGND sg13g2_decap_4
XFILLER_33_268 VPWR VGND sg13g2_fill_2
X_3700_ _1360_ _1361_ _1362_ _1363_ _1364_ VPWR VGND sg13g2_nor4_1
XFILLER_14_471 VPWR VGND sg13g2_decap_4
XFILLER_15_983 VPWR VGND sg13g2_decap_8
X_4995__434 VPWR VGND net434 sg13g2_tiehi
XFILLER_41_290 VPWR VGND sg13g2_decap_4
X_4680_ net688 net732 _0037_ VPWR VGND sg13g2_nor2_1
X_3631_ videogen.test_lut_thingy.pixel_feeder_inst.row\[14\]\[3\] net604 _1295_ VPWR
+ VGND sg13g2_nor2_1
XFILLER_30_997 VPWR VGND sg13g2_fill_1
X_3562_ VPWR VGND _1222_ _1223_ _1220_ _1171_ _1226_ _1219_ sg13g2_a221oi_1
X_5301_ net342 VGND VPWR _0651_ serialize.shift_reg_g\[5\] clknet_3_6_0_clk_regs sg13g2_dfrbpq_1
X_3493_ _1157_ _1012_ _1152_ VPWR VGND sg13g2_nand2_1
X_5232_ net200 VGND VPWR _0582_ videogen.test_lut_thingy.pixel_feeder_inst.row\[41\]\[2\]
+ _0211_ sg13g2_dfrbpq_1
X_5163_ net95 VGND VPWR _0513_ tmds_blue.dc_balancing_reg\[2\] net659 sg13g2_dfrbpq_2
XFILLER_38_0 VPWR VGND sg13g2_decap_8
X_4114_ _1771_ _1770_ _1659_ VPWR VGND sg13g2_nand2b_1
X_5094_ net283 VGND VPWR _0444_ videogen.test_lut_thingy.pixel_feeder_inst.row\[11\]\[0\]
+ _0081_ sg13g2_dfrbpq_1
X_4045_ _1671_ VPWR _1705_ VGND _1635_ _1681_ sg13g2_o21ai_1
XFILLER_24_202 VPWR VGND sg13g2_fill_2
XFILLER_24_235 VPWR VGND sg13g2_decap_4
X_4947_ net116 VGND VPWR _0301_ videogen.test_lut_thingy.pixel_feeder_inst.v_pix\[2\]
+ net653 sg13g2_dfrbpq_2
XFILLER_33_38 VPWR VGND sg13g2_decap_8
X_4878_ net719 net764 _0235_ VPWR VGND sg13g2_nor2_1
X_3829_ net644 VPWR _1493_ VGND videogen.test_lut_thingy.pixel_feeder_inst.row\[62\]\[1\]
+ net603 sg13g2_o21ai_1
XFILLER_4_618 VPWR VGND sg13g2_decap_4
XFILLER_0_835 VPWR VGND sg13g2_decap_8
XFILLER_48_806 VPWR VGND sg13g2_decap_8
XFILLER_43_533 VPWR VGND sg13g2_fill_2
X_5194__361 VPWR VGND net361 sg13g2_tiehi
XFILLER_11_441 VPWR VGND sg13g2_decap_8
XFILLER_8_924 VPWR VGND sg13g2_decap_8
X_5270__282 VPWR VGND net282 sg13g2_tiehi
XFILLER_38_338 VPWR VGND sg13g2_fill_2
XFILLER_47_872 VPWR VGND sg13g2_decap_8
XFILLER_46_360 VPWR VGND sg13g2_fill_2
XFILLER_0_42 VPWR VGND sg13g2_decap_8
XFILLER_0_1017 VPWR VGND sg13g2_decap_8
XFILLER_0_1028 VPWR VGND sg13g2_fill_1
XFILLER_19_596 VPWR VGND sg13g2_fill_2
X_2993_ videogen.test_lut_thingy.pixel_feeder_inst.row\[32\]\[1\] net805 _0804_ _0417_
+ VPWR VGND sg13g2_mux2_1
X_4801_ net682 net725 _0158_ VPWR VGND sg13g2_nor2_1
XFILLER_21_216 VPWR VGND sg13g2_fill_2
X_4732_ net701 net745 _0089_ VPWR VGND sg13g2_nor2_1
X_5095__281 VPWR VGND net281 sg13g2_tiehi
XFILLER_21_249 VPWR VGND sg13g2_fill_2
XFILLER_30_761 VPWR VGND sg13g2_decap_8
X_4663_ net720 net765 _0022_ VPWR VGND sg13g2_nor2_1
X_3614_ net637 _1266_ _1277_ _1278_ VPWR VGND sg13g2_nor3_1
X_4594_ VGND VPWR net483 _0870_ _2212_ net774 sg13g2_a21oi_1
X_3545_ _1209_ _1142_ _1206_ _1207_ VPWR VGND sg13g2_and3_1
X_3476_ _1140_ _1013_ _1139_ VPWR VGND sg13g2_xnor2_1
X_5215_ net268 VGND VPWR _0565_ videogen.test_lut_thingy.pixel_feeder_inst.row\[44\]\[1\]
+ _0194_ sg13g2_dfrbpq_1
X_5146_ net179 VGND VPWR _0496_ videogen.test_lut_thingy.pixel_feeder_inst.row\[53\]\[0\]
+ _0133_ sg13g2_dfrbpq_1
XFILLER_29_316 VPWR VGND sg13g2_fill_1
X_5077_ net317 VGND VPWR _0427_ videogen.test_lut_thingy.pixel_feeder_inst.row\[31\]\[3\]
+ _0064_ sg13g2_dfrbpq_1
XFILLER_28_49 VPWR VGND sg13g2_fill_1
X_4028_ _1688_ _1682_ _1687_ VPWR VGND sg13g2_nand2_1
XFILLER_25_533 VPWR VGND sg13g2_decap_8
XFILLER_25_566 VPWR VGND sg13g2_fill_1
X_5250__35 VPWR VGND net35 sg13g2_tiehi
XFILLER_20_293 VPWR VGND sg13g2_fill_1
X_5148__171 VPWR VGND net171 sg13g2_tiehi
XFILLER_48_603 VPWR VGND sg13g2_decap_8
XFILLER_0_632 VPWR VGND sg13g2_decap_8
XFILLER_47_146 VPWR VGND sg13g2_decap_8
XFILLER_36_809 VPWR VGND sg13g2_fill_2
XFILLER_18_60 VPWR VGND sg13g2_fill_1
XFILLER_29_894 VPWR VGND sg13g2_decap_8
XFILLER_43_330 VPWR VGND sg13g2_decap_8
XFILLER_31_525 VPWR VGND sg13g2_fill_2
XFILLER_7_264 VPWR VGND sg13g2_fill_1
XFILLER_7_242 VPWR VGND sg13g2_fill_1
XFILLER_4_960 VPWR VGND sg13g2_decap_8
X_3330_ _0994_ _0990_ _0993_ VPWR VGND sg13g2_xnor2_1
X_5162__97 VPWR VGND net97 sg13g2_tiehi
X_3261_ VPWR _0331_ _0947_ VGND sg13g2_inv_1
X_5000_ net429 VGND VPWR _0354_ display_enable net661 sg13g2_dfrbpq_2
X_3192_ VGND VPWR videogen.test_lut_thingy.pixel_feeder_inst.v_pix\[3\] _0897_ _0899_
+ videogen.test_lut_thingy.pixel_feeder_inst.v_pix\[4\] sg13g2_a21oi_1
XFILLER_22_1007 VPWR VGND sg13g2_decap_8
XFILLER_39_669 VPWR VGND sg13g2_decap_8
XFILLER_38_124 VPWR VGND sg13g2_decap_8
XFILLER_38_168 VPWR VGND sg13g2_fill_2
XFILLER_38_157 VPWR VGND sg13g2_decap_8
XFILLER_35_842 VPWR VGND sg13g2_fill_1
XFILLER_34_385 VPWR VGND sg13g2_fill_1
XFILLER_35_897 VPWR VGND sg13g2_decap_4
X_2976_ videogen.test_lut_thingy.pixel_feeder_inst.row\[30\]\[3\] net782 _0801_ _0431_
+ VPWR VGND sg13g2_mux2_1
X_4715_ net712 net756 _0072_ VPWR VGND sg13g2_nor2_1
X_4646_ net482 net821 net675 _0668_ VPWR VGND sg13g2_a21o_1
X_5214__272 VPWR VGND net272 sg13g2_tiehi
X_4577_ net820 VPWR _2201_ VGND net627 hsync sg13g2_o21ai_1
XFILLER_30_39 VPWR VGND sg13g2_fill_2
X_3528_ _1118_ VPWR _1192_ VGND _1186_ _1188_ sg13g2_o21ai_1
X_3459_ _1123_ _1120_ _1110_ VPWR VGND sg13g2_nand2b_1
X_5129_ net213 VGND VPWR _0479_ videogen.test_lut_thingy.pixel_feeder_inst.row\[56\]\[3\]
+ _0116_ sg13g2_dfrbpq_1
XFILLER_45_628 VPWR VGND sg13g2_decap_8
XFILLER_44_105 VPWR VGND sg13g2_fill_1
XFILLER_38_691 VPWR VGND sg13g2_decap_8
XFILLER_26_831 VPWR VGND sg13g2_decap_8
XFILLER_26_842 VPWR VGND sg13g2_fill_1
XFILLER_13_547 VPWR VGND sg13g2_decap_8
XFILLER_41_878 VPWR VGND sg13g2_fill_2
XFILLER_5_768 VPWR VGND sg13g2_decap_8
XFILLER_49_901 VPWR VGND sg13g2_decap_8
XFILLER_1_952 VPWR VGND sg13g2_decap_8
X_5304__318 VPWR VGND net318 sg13g2_tiehi
XFILLER_49_978 VPWR VGND sg13g2_decap_8
XFILLER_48_477 VPWR VGND sg13g2_decap_8
XFILLER_44_650 VPWR VGND sg13g2_decap_8
X_2830_ videogen.test_lut_thingy.pixel_feeder_inst.row\[47\]\[0\] net816 _0768_ _0552_
+ VPWR VGND sg13g2_mux2_1
X_2761_ VGND VPWR _0747_ net559 net596 sg13g2_or2_1
X_4500_ tmds_blue.dc_balancing_reg\[4\] _2125_ _2129_ VPWR VGND sg13g2_nor2b_1
X_2692_ net638 net643 net588 _0710_ VPWR VGND sg13g2_nor3_2
X_4431_ _0960_ VPWR _2068_ VGND _0685_ _2066_ sg13g2_o21ai_1
X_4362_ _2010_ tmds_red.dc_balancing_reg\[3\] _2012_ VPWR VGND sg13g2_xor2_1
X_3313_ _0983_ videogen.fancy_shader.video_y\[9\] _0982_ VPWR VGND sg13g2_xnor2_1
X_4293_ red\[4\] red\[2\] _1945_ VPWR VGND sg13g2_xor2_1
XFILLER_39_400 VPWR VGND sg13g2_fill_1
X_3244_ _0935_ net633 _0933_ VPWR VGND sg13g2_nand2_1
XFILLER_39_422 VPWR VGND sg13g2_fill_2
XFILLER_6_1023 VPWR VGND sg13g2_fill_2
XFILLER_20_0 VPWR VGND sg13g2_fill_2
XFILLER_39_455 VPWR VGND sg13g2_fill_2
X_3175_ _0885_ _0886_ _0887_ VPWR VGND sg13g2_and2_1
XFILLER_26_127 VPWR VGND sg13g2_decap_8
XFILLER_25_39 VPWR VGND sg13g2_decap_8
XFILLER_35_661 VPWR VGND sg13g2_decap_8
X_5101__269 VPWR VGND net269 sg13g2_tiehi
XFILLER_23_878 VPWR VGND sg13g2_fill_2
XFILLER_41_16 VPWR VGND sg13g2_fill_2
XFILLER_22_399 VPWR VGND sg13g2_fill_2
X_2959_ net778 videogen.test_lut_thingy.pixel_feeder_inst.row\[61\]\[3\] _0796_ _0443_
+ VPWR VGND sg13g2_mux2_1
X_4629_ VPWR _0654_ _2229_ VGND sg13g2_inv_1
XFILLER_2_727 VPWR VGND sg13g2_decap_8
XFILLER_46_904 VPWR VGND sg13g2_decap_8
XFILLER_33_609 VPWR VGND sg13g2_decap_8
XFILLER_14_823 VPWR VGND sg13g2_decap_4
XFILLER_32_108 VPWR VGND sg13g2_decap_8
XFILLER_41_675 VPWR VGND sg13g2_decap_8
XFILLER_12_1017 VPWR VGND sg13g2_decap_8
XFILLER_12_1028 VPWR VGND sg13g2_fill_1
XFILLER_5_554 VPWR VGND sg13g2_decap_8
XFILLER_31_82 VPWR VGND sg13g2_fill_2
Xoutput3 net3 tmds_b VPWR VGND sg13g2_buf_1
X_5228__216 VPWR VGND net216 sg13g2_tiehi
XFILLER_49_775 VPWR VGND sg13g2_decap_8
XFILLER_48_296 VPWR VGND sg13g2_fill_2
X_4980_ net50 VGND VPWR _0334_ videogen.fancy_shader.shader_counter_reg\[7\] net658
+ sg13g2_dfrbpq_2
X_3931_ videogen.test_lut_thingy.pixel_feeder_inst.row\[52\]\[0\] net593 _1594_ VPWR
+ VGND sg13g2_nor2_1
XFILLER_16_182 VPWR VGND sg13g2_decap_4
X_5274__258 VPWR VGND net258 sg13g2_tiehi
X_3862_ VPWR _1526_ _1525_ VGND sg13g2_inv_1
X_2813_ videogen.test_lut_thingy.pixel_feeder_inst.row\[44\]\[2\] net794 _0765_ _0566_
+ VPWR VGND sg13g2_mux2_1
XFILLER_31_174 VPWR VGND sg13g2_fill_1
X_3793_ _1453_ _1454_ _1455_ _1456_ _1457_ VPWR VGND sg13g2_nor4_1
XFILLER_9_860 VPWR VGND sg13g2_decap_8
XFILLER_8_381 VPWR VGND sg13g2_fill_2
X_2744_ VGND VPWR net619 _0703_ _0738_ _0718_ sg13g2_a21oi_1
X_2675_ videogen.fancy_shader.video_y\[9\] _0672_ _0692_ _0693_ VPWR VGND sg13g2_nor3_1
X_4414_ green\[7\] _2055_ _2054_ _2057_ VPWR VGND sg13g2_mux2_1
X_4345_ _1984_ VPWR _1996_ VGND _1994_ _1995_ sg13g2_o21ai_1
X_4276_ _1734_ _1928_ _1330_ _1932_ VPWR VGND sg13g2_nand3_1
X_3227_ VGND VPWR videogen.test_lut_thingy.pixel_feeder_inst.v_counter\[2\] _0923_
+ _0924_ _0917_ sg13g2_a21oi_1
X_3158_ _0876_ _0829_ videogen.fancy_shader.video_x\[4\] VPWR VGND sg13g2_nand2b_1
X_3089_ net13 _0705_ _0749_ VPWR VGND sg13g2_nand2_2
XFILLER_22_163 VPWR VGND sg13g2_decap_4
XFILLER_10_336 VPWR VGND sg13g2_fill_2
XFILLER_2_546 VPWR VGND sg13g2_decap_8
XFILLER_46_701 VPWR VGND sg13g2_decap_8
XFILLER_19_948 VPWR VGND sg13g2_fill_1
XFILLER_46_778 VPWR VGND sg13g2_decap_8
XFILLER_45_233 VPWR VGND sg13g2_fill_1
XFILLER_45_266 VPWR VGND sg13g2_fill_1
XFILLER_27_981 VPWR VGND sg13g2_fill_2
XFILLER_6_841 VPWR VGND sg13g2_decap_8
X_4130_ _1787_ _1773_ _1779_ VPWR VGND sg13g2_nand2_1
X_4061_ _1720_ VPWR _1721_ VGND _1698_ _1704_ sg13g2_o21ai_1
XFILLER_49_572 VPWR VGND sg13g2_decap_8
XFILLER_37_734 VPWR VGND sg13g2_decap_8
X_3012_ net788 videogen.test_lut_thingy.pixel_feeder_inst.row\[16\]\[2\] _0808_ _0393_
+ VPWR VGND sg13g2_mux2_1
XFILLER_18_981 VPWR VGND sg13g2_decap_8
X_4963_ net84 VGND VPWR _0317_ videogen.test_lut_thingy.pixel_feeder_inst.h_counter\[2\]
+ net655 sg13g2_dfrbpq_2
XFILLER_17_480 VPWR VGND sg13g2_decap_8
XFILLER_24_428 VPWR VGND sg13g2_fill_1
X_3914_ videogen.test_lut_thingy.pixel_feeder_inst.row\[56\]\[0\] net591 _1577_ VPWR
+ VGND sg13g2_nor2_1
X_4894_ net712 net756 _0249_ VPWR VGND sg13g2_nor2_1
X_3845_ _1505_ _1506_ _1507_ _1508_ _1509_ VPWR VGND sg13g2_nor4_1
X_3776_ net643 _1434_ _1439_ _1440_ VPWR VGND sg13g2_nor3_1
X_2727_ _0733_ _0720_ VPWR VGND net560 sg13g2_nand2b_2
X_2658_ VPWR _0677_ net641 VGND sg13g2_inv_1
X_4328_ tmds_red.dc_balancing_reg\[3\] tmds_red.dc_balancing_reg\[2\] tmds_red.dc_balancing_reg\[1\]
+ _1980_ VPWR VGND sg13g2_nor3_1
XFILLER_41_1021 VPWR VGND sg13g2_decap_8
X_4259_ _1897_ _1908_ _1916_ VPWR VGND sg13g2_nor2_1
XFILLER_47_48 VPWR VGND sg13g2_fill_1
XFILLER_27_200 VPWR VGND sg13g2_fill_1
XFILLER_28_723 VPWR VGND sg13g2_decap_8
XFILLER_24_973 VPWR VGND sg13g2_fill_2
XFILLER_11_656 VPWR VGND sg13g2_decap_4
XFILLER_10_155 VPWR VGND sg13g2_fill_1
XFILLER_7_649 VPWR VGND sg13g2_decap_8
XFILLER_3_811 VPWR VGND sg13g2_decap_8
XFILLER_2_332 VPWR VGND sg13g2_decap_4
XFILLER_3_888 VPWR VGND sg13g2_decap_8
XFILLER_2_376 VPWR VGND sg13g2_decap_4
Xfanout680 _0669_ net680 VPWR VGND sg13g2_buf_8
Xfanout691 net724 net691 VPWR VGND sg13g2_buf_8
XFILLER_18_200 VPWR VGND sg13g2_fill_2
XFILLER_19_701 VPWR VGND sg13g2_decap_8
XFILLER_46_542 VPWR VGND sg13g2_fill_1
XFILLER_46_531 VPWR VGND sg13g2_decap_8
XFILLER_19_756 VPWR VGND sg13g2_fill_1
XFILLER_46_575 VPWR VGND sg13g2_decap_8
XFILLER_37_92 VPWR VGND sg13g2_decap_8
XFILLER_42_792 VPWR VGND sg13g2_decap_4
X_3630_ videogen.test_lut_thingy.pixel_feeder_inst.row\[15\]\[3\] net583 _1294_ VPWR
+ VGND sg13g2_nor2_1
X_5312__214 VPWR VGND net214 sg13g2_tiehi
X_3561_ VGND VPWR _1219_ _1224_ _1225_ _1223_ sg13g2_a21oi_1
X_5300_ net359 VGND VPWR _0650_ serialize.shift_reg_g\[4\] clknet_3_1_0_clk_regs sg13g2_dfrbpq_1
XFILLER_6_693 VPWR VGND sg13g2_decap_8
XFILLER_6_682 VPWR VGND sg13g2_decap_4
XFILLER_5_170 VPWR VGND sg13g2_fill_1
X_3492_ _1154_ _1152_ _1012_ _1156_ VPWR VGND sg13g2_a21o_1
X_5231_ net204 VGND VPWR _0581_ videogen.test_lut_thingy.pixel_feeder_inst.row\[41\]\[1\]
+ _0210_ sg13g2_dfrbpq_1
X_5162_ net97 VGND VPWR _0512_ tmds_blue.dc_balancing_reg\[1\] net663 sg13g2_dfrbpq_2
X_4113_ _1770_ _1021_ _1745_ VPWR VGND sg13g2_nand2_2
XFILLER_25_1027 VPWR VGND sg13g2_fill_2
XFILLER_29_509 VPWR VGND sg13g2_fill_2
X_5093_ net285 VGND VPWR _0443_ videogen.test_lut_thingy.pixel_feeder_inst.row\[61\]\[3\]
+ _0080_ sg13g2_dfrbpq_1
X_4044_ _1633_ _1682_ _1699_ _1701_ _1704_ VPWR VGND sg13g2_and4_1
XFILLER_37_553 VPWR VGND sg13g2_fill_1
XFILLER_25_704 VPWR VGND sg13g2_fill_2
XFILLER_40_707 VPWR VGND sg13g2_decap_8
X_4946_ net118 VGND VPWR _0300_ videogen.test_lut_thingy.pixel_feeder_inst.v_pix\[1\]
+ net653 sg13g2_dfrbpq_1
XFILLER_32_280 VPWR VGND sg13g2_fill_1
X_4877_ net720 net765 _0234_ VPWR VGND sg13g2_nor2_1
X_3828_ _1488_ _1489_ _1490_ _1491_ _1492_ VPWR VGND sg13g2_nor4_1
X_5037__380 VPWR VGND net380 sg13g2_tiehi
X_5168__81 VPWR VGND net81 sg13g2_tiehi
X_3759_ _1419_ _1420_ _1421_ _1422_ _1423_ VPWR VGND sg13g2_nor4_1
XFILLER_0_814 VPWR VGND sg13g2_decap_8
XFILLER_28_520 VPWR VGND sg13g2_fill_1
X_5298__375 VPWR VGND net375 sg13g2_tiehi
XFILLER_16_748 VPWR VGND sg13g2_decap_8
XFILLER_43_567 VPWR VGND sg13g2_fill_1
XFILLER_12_932 VPWR VGND sg13g2_decap_8
X_4938__127 VPWR VGND net127 sg13g2_tiehi
XFILLER_12_943 VPWR VGND sg13g2_fill_2
XFILLER_7_457 VPWR VGND sg13g2_decap_8
XFILLER_48_1027 VPWR VGND sg13g2_fill_2
XFILLER_48_1016 VPWR VGND sg13g2_decap_8
XFILLER_3_685 VPWR VGND sg13g2_decap_8
XFILLER_47_851 VPWR VGND sg13g2_decap_8
XFILLER_0_21 VPWR VGND sg13g2_decap_8
XFILLER_0_98 VPWR VGND sg13g2_decap_4
X_4800_ net682 net726 _0157_ VPWR VGND sg13g2_nor2_1
X_2992_ videogen.test_lut_thingy.pixel_feeder_inst.row\[32\]\[2\] net795 _0804_ _0418_
+ VPWR VGND sg13g2_mux2_1
X_4731_ net699 net743 _0088_ VPWR VGND sg13g2_nor2_1
X_4662_ net718 net762 _0021_ VPWR VGND sg13g2_nor2_1
X_3613_ net641 _1271_ _1276_ _1277_ VPWR VGND sg13g2_nor3_1
XFILLER_7_980 VPWR VGND sg13g2_decap_8
X_4593_ VPWR VGND _2211_ net775 _2210_ net626 _0620_ _2204_ sg13g2_a221oi_1
XFILLER_6_490 VPWR VGND sg13g2_fill_1
X_3544_ VGND VPWR _1206_ _1207_ _1208_ _1142_ sg13g2_a21oi_1
X_3475_ _1003_ _1005_ _1139_ VPWR VGND sg13g2_and2_1
XFILLER_9_1021 VPWR VGND sg13g2_decap_8
X_5214_ net272 VGND VPWR _0564_ videogen.test_lut_thingy.pixel_feeder_inst.row\[44\]\[0\]
+ _0193_ sg13g2_dfrbpq_1
X_5145_ net181 VGND VPWR _0495_ videogen.test_lut_thingy.pixel_feeder_inst.row\[54\]\[3\]
+ _0132_ sg13g2_dfrbpq_1
X_5076_ net319 VGND VPWR _0426_ videogen.test_lut_thingy.pixel_feeder_inst.row\[31\]\[2\]
+ _0063_ sg13g2_dfrbpq_1
XFILLER_44_309 VPWR VGND sg13g2_fill_2
XFILLER_38_851 VPWR VGND sg13g2_fill_2
X_4027_ _1671_ _1685_ _1687_ VPWR VGND sg13g2_nor2_1
XFILLER_13_707 VPWR VGND sg13g2_decap_8
XFILLER_25_589 VPWR VGND sg13g2_decap_4
X_4929_ net140 VGND VPWR _0283_ serialize.bit_cnt\[1\] clknet_3_4_0_clk_regs sg13g2_dfrbpq_1
Xheichips25_bagel_21 VPWR VGND uio_oe[0] sg13g2_tielo
X_5111__249 VPWR VGND net249 sg13g2_tiehi
XFILLER_0_611 VPWR VGND sg13g2_decap_8
XFILLER_0_688 VPWR VGND sg13g2_decap_8
XFILLER_48_659 VPWR VGND sg13g2_decap_8
XFILLER_29_862 VPWR VGND sg13g2_fill_2
XFILLER_29_873 VPWR VGND sg13g2_decap_8
XFILLER_16_501 VPWR VGND sg13g2_fill_2
XFILLER_18_72 VPWR VGND sg13g2_decap_4
XFILLER_18_83 VPWR VGND sg13g2_fill_2
XFILLER_18_94 VPWR VGND sg13g2_decap_8
XFILLER_44_876 VPWR VGND sg13g2_fill_2
XFILLER_43_375 VPWR VGND sg13g2_fill_1
XFILLER_43_364 VPWR VGND sg13g2_decap_8
XFILLER_31_537 VPWR VGND sg13g2_fill_1
XFILLER_8_744 VPWR VGND sg13g2_decap_4
XFILLER_7_210 VPWR VGND sg13g2_fill_1
XFILLER_12_795 VPWR VGND sg13g2_decap_8
XFILLER_11_294 VPWR VGND sg13g2_fill_1
X_3260_ _0947_ _0936_ _0946_ _0934_ net631 VPWR VGND sg13g2_a22oi_1
X_3191_ net563 _0898_ _0302_ VPWR VGND sg13g2_nor2_1
XFILLER_22_4 VPWR VGND sg13g2_decap_8
XFILLER_39_648 VPWR VGND sg13g2_decap_8
XFILLER_19_350 VPWR VGND sg13g2_decap_4
X_5277__234 VPWR VGND net234 sg13g2_tiehi
X_2975_ _0724_ _0733_ _0801_ VPWR VGND sg13g2_nor2_2
X_4714_ net713 net757 _0071_ VPWR VGND sg13g2_nor2_1
X_4645_ net453 net821 net680 _0667_ VPWR VGND sg13g2_a21o_1
X_4576_ VGND VPWR _2199_ _2200_ _2198_ _2125_ sg13g2_a21oi_2
XFILLER_2_909 VPWR VGND sg13g2_decap_8
X_3527_ _1191_ _1187_ _1190_ VPWR VGND sg13g2_nand2_1
X_3458_ _1109_ _1119_ _1059_ _1122_ VPWR VGND sg13g2_nand3_1
X_3389_ _1028_ _1052_ _1053_ VPWR VGND sg13g2_nor2b_2
XFILLER_29_103 VPWR VGND sg13g2_decap_8
X_5128_ net215 VGND VPWR _0478_ videogen.test_lut_thingy.pixel_feeder_inst.row\[56\]\[2\]
+ _0115_ sg13g2_dfrbpq_1
XFILLER_45_607 VPWR VGND sg13g2_decap_8
X_5221__244 VPWR VGND net244 sg13g2_tiehi
XFILLER_44_117 VPWR VGND sg13g2_fill_2
XFILLER_38_670 VPWR VGND sg13g2_decap_8
X_5059_ net350 VGND VPWR _0409_ tmds_green.dc_balancing_reg\[2\] net662 sg13g2_dfrbpq_2
XFILLER_41_813 VPWR VGND sg13g2_fill_1
XFILLER_13_526 VPWR VGND sg13g2_decap_8
XFILLER_25_375 VPWR VGND sg13g2_fill_1
XFILLER_40_312 VPWR VGND sg13g2_decap_8
X_4967__76 VPWR VGND net76 sg13g2_tiehi
XFILLER_40_356 VPWR VGND sg13g2_fill_1
X_4982__46 VPWR VGND net46 sg13g2_tiehi
XFILLER_5_714 VPWR VGND sg13g2_fill_1
XFILLER_5_747 VPWR VGND sg13g2_decap_8
XFILLER_4_202 VPWR VGND sg13g2_decap_8
XFILLER_1_931 VPWR VGND sg13g2_decap_8
XFILLER_49_957 VPWR VGND sg13g2_decap_8
XFILLER_0_485 VPWR VGND sg13g2_decap_8
XFILLER_29_681 VPWR VGND sg13g2_decap_8
XFILLER_29_692 VPWR VGND sg13g2_fill_1
X_5200__328 VPWR VGND net328 sg13g2_tiehi
XFILLER_45_92 VPWR VGND sg13g2_decap_8
XFILLER_16_375 VPWR VGND sg13g2_fill_2
XFILLER_17_876 VPWR VGND sg13g2_fill_1
XFILLER_32_835 VPWR VGND sg13g2_fill_1
XFILLER_31_356 VPWR VGND sg13g2_fill_1
XFILLER_32_879 VPWR VGND sg13g2_decap_8
X_2760_ net810 videogen.test_lut_thingy.pixel_feeder_inst.row\[49\]\[0\] _0746_ _0600_
+ VPWR VGND sg13g2_mux2_1
XFILLER_31_389 VPWR VGND sg13g2_decap_8
X_2691_ VGND VPWR _0709_ net648 videogen.test_lut_thingy.pixel_feeder_inst.h_pix\[1\]
+ sg13g2_or2_1
X_4430_ VPWR _2067_ _2066_ VGND sg13g2_inv_1
X_4361_ VGND VPWR _2011_ _2010_ tmds_red.dc_balancing_reg\[3\] sg13g2_or2_1
X_3312_ net770 _0981_ _0982_ _0347_ VPWR VGND sg13g2_nor3_1
X_4292_ _1944_ _1942_ red\[0\] VPWR VGND sg13g2_nand2b_1
XFILLER_6_1002 VPWR VGND sg13g2_decap_8
X_3243_ _0934_ _0821_ net563 VPWR VGND sg13g2_nand2_2
X_5064__343 VPWR VGND net343 sg13g2_tiehi
X_3174_ net629 videogen.fancy_shader.video_y\[1\] _0886_ VPWR VGND sg13g2_xor2_1
X_2958_ _0796_ _0750_ VPWR VGND _0708_ sg13g2_nand2b_2
X_2889_ videogen.test_lut_thingy.pixel_feeder_inst.row\[53\]\[1\] net801 _0780_ _0497_
+ VPWR VGND sg13g2_mux2_1
X_4628_ _2229_ net671 net475 net678 red_tmds_par\[0\] VPWR VGND sg13g2_a22oi_1
XFILLER_2_706 VPWR VGND sg13g2_decap_8
X_4559_ VGND VPWR _2165_ _2166_ _2185_ _2168_ sg13g2_a21oi_1
XFILLER_1_216 VPWR VGND sg13g2_fill_2
XFILLER_45_426 VPWR VGND sg13g2_decap_8
XFILLER_45_437 VPWR VGND sg13g2_fill_1
XFILLER_14_802 VPWR VGND sg13g2_decap_8
XFILLER_41_654 VPWR VGND sg13g2_decap_8
XFILLER_9_349 VPWR VGND sg13g2_fill_2
XFILLER_5_533 VPWR VGND sg13g2_decap_8
XFILLER_31_72 VPWR VGND sg13g2_decap_4
Xoutput4 net4 tmds_clk VPWR VGND sg13g2_buf_1
XFILLER_5_577 VPWR VGND sg13g2_fill_1
XFILLER_49_754 VPWR VGND sg13g2_decap_8
XFILLER_48_253 VPWR VGND sg13g2_fill_1
XFILLER_48_264 VPWR VGND sg13g2_decap_4
XFILLER_45_982 VPWR VGND sg13g2_fill_2
X_3930_ videogen.test_lut_thingy.pixel_feeder_inst.row\[53\]\[0\] net569 _1593_ VPWR
+ VGND sg13g2_nor2_1
X_3861_ _1525_ _1476_ _1524_ _0686_ videogen.test_lut_thingy.gol_counter_reg\[1\]
+ VPWR VGND sg13g2_a22oi_1
XFILLER_32_643 VPWR VGND sg13g2_decap_4
X_3792_ videogen.test_lut_thingy.pixel_feeder_inst.row\[25\]\[1\] net567 _1456_ VPWR
+ VGND sg13g2_nor2_1
XFILLER_31_186 VPWR VGND sg13g2_fill_1
X_2812_ videogen.test_lut_thingy.pixel_feeder_inst.row\[44\]\[3\] net785 _0765_ _0567_
+ VPWR VGND sg13g2_mux2_1
X_2743_ videogen.test_lut_thingy.pixel_feeder_inst.row\[29\]\[0\] net813 _0737_ _0608_
+ VPWR VGND sg13g2_mux2_1
XFILLER_31_197 VPWR VGND sg13g2_fill_1
XFILLER_9_894 VPWR VGND sg13g2_decap_8
XFILLER_8_393 VPWR VGND sg13g2_fill_2
X_2674_ videogen.fancy_shader.video_y\[6\] videogen.fancy_shader.video_y\[5\] videogen.fancy_shader.video_y\[7\]
+ _0692_ VPWR VGND sg13g2_nand3_1
X_4413_ _0683_ green\[7\] _2056_ VPWR VGND sg13g2_nor2_1
X_4344_ _1995_ net555 net564 _1992_ VPWR VGND sg13g2_and3_2
X_4275_ VPWR _0364_ _1931_ VGND sg13g2_inv_1
XFILLER_39_231 VPWR VGND sg13g2_fill_1
X_3226_ _0891_ _0919_ _0923_ VPWR VGND sg13g2_nor2_1
X_3157_ _0828_ _0875_ _0291_ VPWR VGND sg13g2_nor2_1
XFILLER_36_17 VPWR VGND sg13g2_decap_8
XFILLER_36_982 VPWR VGND sg13g2_fill_2
XFILLER_36_971 VPWR VGND sg13g2_decap_8
X_3088_ VGND VPWR _0701_ _0843_ net10 _0681_ sg13g2_a21oi_1
XFILLER_35_492 VPWR VGND sg13g2_fill_2
XFILLER_11_816 VPWR VGND sg13g2_decap_8
XFILLER_22_142 VPWR VGND sg13g2_decap_8
XFILLER_23_654 VPWR VGND sg13g2_decap_8
XFILLER_11_827 VPWR VGND sg13g2_fill_2
XFILLER_22_153 VPWR VGND sg13g2_fill_1
XFILLER_22_197 VPWR VGND sg13g2_fill_2
X_5286__119 VPWR VGND net119 sg13g2_tiehi
XFILLER_2_525 VPWR VGND sg13g2_decap_8
X_5047__360 VPWR VGND net360 sg13g2_tiehi
XFILLER_46_757 VPWR VGND sg13g2_decap_8
XFILLER_45_245 VPWR VGND sg13g2_decap_8
XFILLER_45_212 VPWR VGND sg13g2_decap_8
XFILLER_26_61 VPWR VGND sg13g2_fill_1
XFILLER_26_481 VPWR VGND sg13g2_decap_8
XFILLER_41_451 VPWR VGND sg13g2_fill_2
XFILLER_13_142 VPWR VGND sg13g2_fill_2
XFILLER_9_113 VPWR VGND sg13g2_decap_4
XFILLER_14_676 VPWR VGND sg13g2_fill_1
XFILLER_13_186 VPWR VGND sg13g2_fill_1
XFILLER_13_197 VPWR VGND sg13g2_fill_2
XFILLER_6_820 VPWR VGND sg13g2_decap_8
XFILLER_6_897 VPWR VGND sg13g2_decap_8
XFILLER_5_396 VPWR VGND sg13g2_decap_4
XFILLER_3_65 VPWR VGND sg13g2_decap_8
XFILLER_49_551 VPWR VGND sg13g2_decap_8
X_4060_ _1720_ _1704_ _1709_ VPWR VGND sg13g2_nand2_1
XFILLER_37_702 VPWR VGND sg13g2_decap_8
XFILLER_37_713 VPWR VGND sg13g2_fill_2
X_3011_ net777 videogen.test_lut_thingy.pixel_feeder_inst.row\[16\]\[3\] _0808_ _0394_
+ VPWR VGND sg13g2_mux2_1
XFILLER_37_768 VPWR VGND sg13g2_fill_1
XFILLER_37_746 VPWR VGND sg13g2_decap_4
XFILLER_24_407 VPWR VGND sg13g2_decap_8
XFILLER_36_267 VPWR VGND sg13g2_decap_4
X_4962_ net86 VGND VPWR _0316_ videogen.test_lut_thingy.pixel_feeder_inst.h_counter\[1\]
+ net655 sg13g2_dfrbpq_1
X_4893_ net681 net725 _0248_ VPWR VGND sg13g2_nor2_1
XFILLER_32_440 VPWR VGND sg13g2_decap_4
X_3913_ net639 VPWR _1576_ VGND videogen.test_lut_thingy.pixel_feeder_inst.row\[57\]\[0\]
+ net570 sg13g2_o21ai_1
X_3844_ videogen.test_lut_thingy.pixel_feeder_inst.row\[45\]\[1\] net575 _1508_ VPWR
+ VGND sg13g2_nor2_1
XFILLER_33_985 VPWR VGND sg13g2_decap_8
X_3775_ _1435_ _1436_ _1437_ _1438_ _1439_ VPWR VGND sg13g2_nor4_1
X_2726_ net560 _0717_ _0719_ _0732_ VPWR VGND sg13g2_nor3_2
X_2657_ net637 _0676_ VPWR VGND sg13g2_inv_4
X_4327_ _1976_ _1978_ _1979_ VPWR VGND sg13g2_nor2_1
XFILLER_41_1000 VPWR VGND sg13g2_decap_8
X_4258_ VPWR _1915_ _1914_ VGND sg13g2_inv_1
X_3209_ _0910_ _0911_ _0307_ VPWR VGND sg13g2_nor2_1
X_4189_ _1846_ _1751_ _1834_ VPWR VGND sg13g2_xnor2_1
XFILLER_16_908 VPWR VGND sg13g2_fill_2
XFILLER_28_768 VPWR VGND sg13g2_decap_8
XFILLER_42_248 VPWR VGND sg13g2_decap_4
XFILLER_24_941 VPWR VGND sg13g2_fill_1
XFILLER_11_635 VPWR VGND sg13g2_fill_2
XFILLER_6_116 VPWR VGND sg13g2_decap_8
XFILLER_10_178 VPWR VGND sg13g2_decap_8
XFILLER_6_127 VPWR VGND sg13g2_fill_1
XFILLER_12_41 VPWR VGND sg13g2_fill_1
XFILLER_12_85 VPWR VGND sg13g2_decap_4
XFILLER_3_867 VPWR VGND sg13g2_decap_8
XFILLER_2_344 VPWR VGND sg13g2_fill_1
XFILLER_2_355 VPWR VGND sg13g2_decap_8
XFILLER_2_399 VPWR VGND sg13g2_fill_1
Xfanout670 net674 net670 VPWR VGND sg13g2_buf_8
Xfanout681 net685 net681 VPWR VGND sg13g2_buf_8
Xfanout692 net694 net692 VPWR VGND sg13g2_buf_8
XFILLER_18_212 VPWR VGND sg13g2_decap_4
XFILLER_46_554 VPWR VGND sg13g2_decap_8
X_5121__229 VPWR VGND net229 sg13g2_tiehi
XFILLER_42_760 VPWR VGND sg13g2_fill_2
XFILLER_15_974 VPWR VGND sg13g2_fill_1
XFILLER_10_690 VPWR VGND sg13g2_decap_8
X_3560_ _1001_ _1172_ _1224_ VPWR VGND sg13g2_nor2_1
XFILLER_6_650 VPWR VGND sg13g2_fill_2
X_5230_ net208 VGND VPWR _0580_ videogen.test_lut_thingy.pixel_feeder_inst.row\[41\]\[0\]
+ _0209_ sg13g2_dfrbpq_1
X_3491_ VGND VPWR _1155_ _1153_ _1012_ sg13g2_or2_1
X_5161_ net99 VGND VPWR _0511_ green_tmds_par\[9\] net665 sg13g2_dfrbpq_1
X_4112_ _1769_ _1765_ _1767_ VPWR VGND sg13g2_nand2_1
X_5092_ net287 VGND VPWR _0442_ videogen.test_lut_thingy.pixel_feeder_inst.row\[61\]\[2\]
+ _0079_ sg13g2_dfrbpq_1
X_4043_ VPWR _1703_ _1702_ VGND sg13g2_inv_1
XFILLER_49_381 VPWR VGND sg13g2_decap_8
XFILLER_37_532 VPWR VGND sg13g2_decap_8
XFILLER_37_565 VPWR VGND sg13g2_fill_2
XFILLER_37_598 VPWR VGND sg13g2_fill_1
XFILLER_24_204 VPWR VGND sg13g2_fill_1
XFILLER_24_215 VPWR VGND sg13g2_fill_2
XFILLER_25_738 VPWR VGND sg13g2_decap_8
X_4945_ net120 VGND VPWR _0299_ videogen.test_lut_thingy.pixel_feeder_inst.v_pix\[0\]
+ net653 sg13g2_dfrbpq_2
XFILLER_33_760 VPWR VGND sg13g2_fill_2
X_4876_ net720 net765 _0233_ VPWR VGND sg13g2_nor2_1
XFILLER_21_933 VPWR VGND sg13g2_decap_4
XFILLER_21_955 VPWR VGND sg13g2_decap_8
XFILLER_32_292 VPWR VGND sg13g2_decap_4
XFILLER_21_988 VPWR VGND sg13g2_decap_8
X_3827_ videogen.test_lut_thingy.pixel_feeder_inst.row\[56\]\[1\] net591 _1491_ VPWR
+ VGND sg13g2_nor2_1
X_5217__260 VPWR VGND net260 sg13g2_tiehi
XFILLER_20_498 VPWR VGND sg13g2_decap_8
X_3758_ videogen.test_lut_thingy.pixel_feeder_inst.row\[1\]\[2\] net573 _1422_ VPWR
+ VGND sg13g2_nor2_1
X_2709_ _0723_ videogen.test_lut_thingy.pixel_feeder_inst.h_pix\[1\] videogen.test_lut_thingy.pixel_feeder_inst.h_pix\[0\]
+ VPWR VGND sg13g2_nand2_2
X_3689_ net613 _1347_ _1352_ _1353_ VPWR VGND sg13g2_nor3_1
X_5187__392 VPWR VGND net392 sg13g2_tiehi
XFILLER_43_535 VPWR VGND sg13g2_fill_1
X_5259__338 VPWR VGND net338 sg13g2_tiehi
XFILLER_16_727 VPWR VGND sg13g2_decap_8
XFILLER_43_579 VPWR VGND sg13g2_decap_8
XFILLER_8_959 VPWR VGND sg13g2_decap_8
XFILLER_7_469 VPWR VGND sg13g2_decap_8
XFILLER_3_664 VPWR VGND sg13g2_decap_8
XFILLER_2_130 VPWR VGND sg13g2_decap_8
XFILLER_2_141 VPWR VGND sg13g2_decap_4
XFILLER_47_830 VPWR VGND sg13g2_decap_8
XFILLER_48_92 VPWR VGND sg13g2_decap_8
XFILLER_17_7 VPWR VGND sg13g2_fill_2
XFILLER_46_362 VPWR VGND sg13g2_fill_1
XFILLER_0_77 VPWR VGND sg13g2_decap_8
X_2991_ videogen.test_lut_thingy.pixel_feeder_inst.row\[32\]\[3\] net784 _0804_ _0419_
+ VPWR VGND sg13g2_mux2_1
XFILLER_15_760 VPWR VGND sg13g2_decap_8
XFILLER_21_218 VPWR VGND sg13g2_fill_1
XFILLER_42_590 VPWR VGND sg13g2_decap_8
XFILLER_14_270 VPWR VGND sg13g2_fill_1
X_4730_ net699 net743 _0087_ VPWR VGND sg13g2_nor2_1
X_4661_ net719 net764 _0020_ VPWR VGND sg13g2_nor2_1
X_3612_ _1272_ _1273_ _1274_ _1275_ _1276_ VPWR VGND sg13g2_nor4_1
X_4592_ VGND VPWR hsync tmds_blue.vsync _2211_ net626 sg13g2_a21oi_1
X_3543_ _1191_ _1197_ _1195_ _1207_ VPWR VGND sg13g2_mux2_1
XFILLER_43_0 VPWR VGND sg13g2_decap_8
X_3474_ _1138_ _1024_ _1137_ VPWR VGND sg13g2_xnor2_1
X_5213_ net276 VGND VPWR _0563_ videogen.test_lut_thingy.pixel_feeder_inst.row\[45\]\[3\]
+ _0192_ sg13g2_dfrbpq_1
XFILLER_9_1000 VPWR VGND sg13g2_decap_8
X_5180__33 VPWR VGND net33 sg13g2_tiehi
X_5144_ net183 VGND VPWR _0494_ videogen.test_lut_thingy.pixel_feeder_inst.row\[54\]\[2\]
+ _0131_ sg13g2_dfrbpq_1
XFILLER_38_830 VPWR VGND sg13g2_decap_8
X_5075_ net321 VGND VPWR _0425_ videogen.test_lut_thingy.pixel_feeder_inst.row\[31\]\[1\]
+ _0062_ sg13g2_dfrbpq_1
X_4026_ VPWR _1686_ _1685_ VGND sg13g2_inv_1
XFILLER_38_896 VPWR VGND sg13g2_fill_1
XFILLER_37_384 VPWR VGND sg13g2_fill_2
XFILLER_37_362 VPWR VGND sg13g2_fill_1
XFILLER_25_502 VPWR VGND sg13g2_fill_2
XFILLER_44_39 VPWR VGND sg13g2_fill_1
X_4979__52 VPWR VGND net52 sg13g2_tiehi
XFILLER_40_505 VPWR VGND sg13g2_fill_2
XFILLER_40_549 VPWR VGND sg13g2_decap_4
X_5074__323 VPWR VGND net323 sg13g2_tiehi
XFILLER_21_730 VPWR VGND sg13g2_decap_8
X_4928_ net141 VGND VPWR _0282_ serialize.bit_cnt\[0\] clknet_3_4_0_clk_regs sg13g2_dfrbpq_1
X_4859_ net702 net746 _0216_ VPWR VGND sg13g2_nor2_1
XFILLER_5_929 VPWR VGND sg13g2_decap_8
Xheichips25_bagel_22 VPWR VGND uio_oe[1] sg13g2_tielo
XFILLER_0_667 VPWR VGND sg13g2_decap_8
XFILLER_48_638 VPWR VGND sg13g2_decap_8
XFILLER_18_51 VPWR VGND sg13g2_decap_8
X_4944__121 VPWR VGND net121 sg13g2_tiehi
XFILLER_44_855 VPWR VGND sg13g2_decap_8
XFILLER_34_50 VPWR VGND sg13g2_fill_2
XFILLER_12_763 VPWR VGND sg13g2_fill_2
XFILLER_34_94 VPWR VGND sg13g2_decap_8
XFILLER_8_789 VPWR VGND sg13g2_decap_8
XFILLER_4_995 VPWR VGND sg13g2_decap_8
XFILLER_39_627 VPWR VGND sg13g2_decap_8
X_3190_ _0898_ videogen.test_lut_thingy.pixel_feeder_inst.v_pix\[3\] _0897_ VPWR VGND
+ sg13g2_xnor2_1
XFILLER_35_833 VPWR VGND sg13g2_decap_8
XFILLER_46_181 VPWR VGND sg13g2_fill_1
X_2974_ videogen.test_lut_thingy.pixel_feeder_inst.row\[6\]\[0\] net814 _0800_ _0432_
+ VPWR VGND sg13g2_mux2_1
X_4713_ net718 net762 _0070_ VPWR VGND sg13g2_nor2_1
X_4644_ net771 clockdiv.q0 net446 _0662_ VPWR VGND sg13g2_nor3_1
X_4575_ _2199_ net626 tmds_blue.dc_balancing_reg\[4\] VPWR VGND sg13g2_nand2b_1
X_3526_ _1181_ VPWR _1190_ VGND _1118_ _1189_ sg13g2_o21ai_1
XFILLER_39_28 VPWR VGND sg13g2_decap_8
X_3457_ _1112_ _1118_ _1120_ _1121_ VPWR VGND sg13g2_nor3_1
X_3388_ videogen.fancy_shader.shader_counter_reg\[5\] videogen.fancy_shader.video_y\[5\]
+ _1052_ VPWR VGND sg13g2_xor2_1
X_5127_ net217 VGND VPWR _0477_ videogen.test_lut_thingy.pixel_feeder_inst.row\[56\]\[1\]
+ _0114_ sg13g2_dfrbpq_1
X_5058_ net351 VGND VPWR _0408_ tmds_green.dc_balancing_reg\[1\] net661 sg13g2_dfrbpq_1
X_4009_ _1667_ _1657_ _1669_ VPWR VGND sg13g2_xor2_1
XFILLER_25_321 VPWR VGND sg13g2_decap_8
XFILLER_41_825 VPWR VGND sg13g2_decap_4
XFILLER_40_379 VPWR VGND sg13g2_decap_8
XFILLER_21_560 VPWR VGND sg13g2_decap_8
XFILLER_5_726 VPWR VGND sg13g2_decap_8
XFILLER_1_910 VPWR VGND sg13g2_decap_8
XFILLER_20_74 VPWR VGND sg13g2_fill_1
XFILLER_0_464 VPWR VGND sg13g2_fill_2
XFILLER_1_987 VPWR VGND sg13g2_decap_8
XFILLER_49_936 VPWR VGND sg13g2_decap_8
XFILLER_29_50 VPWR VGND sg13g2_fill_1
XFILLER_21_1020 VPWR VGND sg13g2_decap_8
XFILLER_29_671 VPWR VGND sg13g2_fill_1
XFILLER_17_855 VPWR VGND sg13g2_decap_8
XFILLER_45_71 VPWR VGND sg13g2_fill_2
XFILLER_44_685 VPWR VGND sg13g2_decap_8
XFILLER_44_696 VPWR VGND sg13g2_fill_2
XFILLER_43_184 VPWR VGND sg13g2_fill_2
XFILLER_31_379 VPWR VGND sg13g2_fill_1
XFILLER_8_564 VPWR VGND sg13g2_decap_4
XFILLER_12_593 VPWR VGND sg13g2_fill_1
X_2690_ net562 _0706_ net645 _0708_ VPWR VGND sg13g2_nand3_1
XFILLER_8_575 VPWR VGND sg13g2_fill_2
X_4360_ _2010_ _1977_ _2009_ VPWR VGND sg13g2_nand2_1
XFILLER_6_87 VPWR VGND sg13g2_fill_2
X_3311_ _0672_ _0692_ _0974_ _0982_ VPWR VGND sg13g2_nor3_1
XFILLER_4_792 VPWR VGND sg13g2_decap_8
X_4291_ VPWR _1943_ _1942_ VGND sg13g2_inv_1
X_3242_ _0821_ _0888_ _0933_ VPWR VGND sg13g2_and2_1
X_3173_ videogen.fancy_shader.video_y\[2\] videogen.fancy_shader.video_y\[3\] _0885_
+ VPWR VGND sg13g2_nor2b_1
XFILLER_35_630 VPWR VGND sg13g2_decap_8
XFILLER_23_814 VPWR VGND sg13g2_decap_4
XFILLER_35_696 VPWR VGND sg13g2_fill_2
XFILLER_41_18 VPWR VGND sg13g2_fill_1
X_5745_ net620 net12 VPWR VGND sg13g2_buf_1
X_2957_ videogen.test_lut_thingy.pixel_feeder_inst.row\[11\]\[0\] net808 _0795_ _0444_
+ VPWR VGND sg13g2_mux2_1
XFILLER_31_891 VPWR VGND sg13g2_decap_4
X_2888_ videogen.test_lut_thingy.pixel_feeder_inst.row\[53\]\[2\] net790 _0780_ _0498_
+ VPWR VGND sg13g2_mux2_1
X_4627_ VPWR _0653_ _2228_ VGND sg13g2_inv_1
X_4934__131 VPWR VGND net131 sg13g2_tiehi
X_4558_ VGND VPWR _2177_ _2184_ _0514_ net566 sg13g2_a21oi_1
X_4489_ VGND VPWR _2121_ _2122_ _0411_ net566 sg13g2_a21oi_1
X_3509_ _1168_ _1172_ _1163_ _1173_ VPWR VGND sg13g2_nand3_1
XFILLER_44_1020 VPWR VGND sg13g2_decap_8
XFILLER_46_939 VPWR VGND sg13g2_decap_8
XFILLER_39_980 VPWR VGND sg13g2_decap_4
XFILLER_38_490 VPWR VGND sg13g2_decap_4
X_4941__124 VPWR VGND net124 sg13g2_tiehi
XFILLER_41_633 VPWR VGND sg13g2_decap_8
XFILLER_13_302 VPWR VGND sg13g2_fill_2
XFILLER_14_858 VPWR VGND sg13g2_decap_8
XFILLER_25_184 VPWR VGND sg13g2_decap_8
XFILLER_26_685 VPWR VGND sg13g2_fill_1
XFILLER_40_143 VPWR VGND sg13g2_decap_8
XFILLER_40_154 VPWR VGND sg13g2_fill_1
XFILLER_31_51 VPWR VGND sg13g2_decap_8
XFILLER_31_84 VPWR VGND sg13g2_fill_1
Xoutput5 net5 tmds_g VPWR VGND sg13g2_buf_1
XFILLER_49_733 VPWR VGND sg13g2_decap_8
XFILLER_0_272 VPWR VGND sg13g2_decap_8
XFILLER_1_784 VPWR VGND sg13g2_decap_8
XFILLER_0_283 VPWR VGND sg13g2_decap_8
XFILLER_45_961 VPWR VGND sg13g2_fill_1
XFILLER_17_652 VPWR VGND sg13g2_decap_8
X_3860_ VGND VPWR _1499_ _1523_ _1524_ _0686_ sg13g2_a21oi_1
X_5100__271 VPWR VGND net271 sg13g2_tiehi
X_3791_ videogen.test_lut_thingy.pixel_feeder_inst.row\[24\]\[1\] net588 _1455_ VPWR
+ VGND sg13g2_nor2_1
XFILLER_31_165 VPWR VGND sg13g2_decap_8
X_2811_ _0757_ _0764_ _0765_ VPWR VGND sg13g2_nor2_2
X_2742_ videogen.test_lut_thingy.pixel_feeder_inst.row\[29\]\[1\] net803 _0737_ _0609_
+ VPWR VGND sg13g2_mux2_1
X_5131__209 VPWR VGND net209 sg13g2_tiehi
X_4918__159 VPWR VGND net159 sg13g2_tiehi
X_4412_ green\[7\] net622 _2055_ VPWR VGND sg13g2_xor2_1
X_4343_ VGND VPWR net555 net564 _1994_ _1993_ sg13g2_a21oi_1
X_4274_ _1927_ _1930_ _1931_ VPWR VGND sg13g2_nor2_1
X_3225_ net563 _0921_ _0922_ _0312_ VPWR VGND sg13g2_nor3_1
X_3156_ net819 VPWR _0875_ VGND videogen.fancy_shader.video_x\[3\] _0827_ sg13g2_o21ai_1
X_3087_ _0843_ net610 net589 VPWR VGND sg13g2_xnor2_1
XFILLER_22_121 VPWR VGND sg13g2_decap_4
XFILLER_10_305 VPWR VGND sg13g2_decap_8
X_3989_ _1091_ _1646_ _1090_ _1649_ VPWR VGND sg13g2_nand3_1
XFILLER_22_187 VPWR VGND sg13g2_fill_2
XFILLER_2_504 VPWR VGND sg13g2_decap_8
XFILLER_46_736 VPWR VGND sg13g2_decap_8
XFILLER_26_40 VPWR VGND sg13g2_decap_8
XFILLER_26_51 VPWR VGND sg13g2_fill_1
XFILLER_26_73 VPWR VGND sg13g2_decap_4
XFILLER_26_460 VPWR VGND sg13g2_decap_8
XFILLER_27_983 VPWR VGND sg13g2_fill_1
XFILLER_14_644 VPWR VGND sg13g2_decap_4
XFILLER_42_61 VPWR VGND sg13g2_fill_2
XFILLER_9_147 VPWR VGND sg13g2_decap_8
XFILLER_42_94 VPWR VGND sg13g2_fill_2
XFILLER_42_72 VPWR VGND sg13g2_decap_8
XFILLER_10_861 VPWR VGND sg13g2_fill_1
XFILLER_6_876 VPWR VGND sg13g2_decap_8
XFILLER_5_364 VPWR VGND sg13g2_fill_2
XFILLER_5_353 VPWR VGND sg13g2_decap_8
XFILLER_47_7 VPWR VGND sg13g2_decap_8
XFILLER_49_530 VPWR VGND sg13g2_decap_8
XFILLER_1_581 VPWR VGND sg13g2_decap_8
X_3010_ _0720_ _0731_ net560 _0808_ VPWR VGND sg13g2_nand3_1
XFILLER_3_1028 VPWR VGND sg13g2_fill_1
X_2673__1 VPWR net445 clknet_1_0__leaf_clk VGND sg13g2_inv_1
XFILLER_18_972 VPWR VGND sg13g2_fill_1
X_4961_ net88 VGND VPWR _0315_ videogen.test_lut_thingy.pixel_feeder_inst.h_counter\[0\]
+ net651 sg13g2_dfrbpq_1
X_4892_ net682 net726 _0247_ VPWR VGND sg13g2_nor2_1
X_3912_ net635 _1551_ _1574_ _1575_ VPWR VGND sg13g2_or3_1
XFILLER_33_953 VPWR VGND sg13g2_fill_1
X_3843_ videogen.test_lut_thingy.pixel_feeder_inst.row\[47\]\[1\] net585 _1507_ VPWR
+ VGND sg13g2_nor2_1
XFILLER_20_647 VPWR VGND sg13g2_decap_8
XFILLER_20_658 VPWR VGND sg13g2_fill_1
XFILLER_32_485 VPWR VGND sg13g2_fill_2
X_3774_ videogen.test_lut_thingy.pixel_feeder_inst.row\[2\]\[1\] net601 _1438_ VPWR
+ VGND sg13g2_nor2_1
X_2725_ net569 net558 _0731_ VPWR VGND sg13g2_nor2_2
X_2656_ VPWR _0675_ videogen.test_lut_thingy.pixel_feeder_inst.v_counter\[0\] VGND
+ sg13g2_inv_1
X_4326_ _1978_ _1977_ _1974_ VPWR VGND sg13g2_nand2b_1
XFILLER_47_28 VPWR VGND sg13g2_decap_8
X_4257_ _1914_ _0999_ _1913_ VPWR VGND sg13g2_xnor2_1
X_3208_ _0837_ VPWR _0911_ VGND net646 _0908_ sg13g2_o21ai_1
X_4188_ _1839_ _1841_ _1844_ _1845_ VPWR VGND sg13g2_nor3_1
X_3139_ VGND VPWR net486 _0867_ _0868_ net773 sg13g2_a21oi_1
XFILLER_43_728 VPWR VGND sg13g2_fill_2
XFILLER_23_441 VPWR VGND sg13g2_decap_4
XFILLER_24_986 VPWR VGND sg13g2_decap_8
XFILLER_24_997 VPWR VGND sg13g2_decap_8
XFILLER_3_846 VPWR VGND sg13g2_decap_8
X_5084__303 VPWR VGND net303 sg13g2_tiehi
Xfanout660 net669 net660 VPWR VGND sg13g2_buf_8
Xfanout682 net685 net682 VPWR VGND sg13g2_buf_2
XFILLER_19_714 VPWR VGND sg13g2_fill_2
Xfanout671 net672 net671 VPWR VGND sg13g2_buf_8
Xfanout693 net694 net693 VPWR VGND sg13g2_buf_1
X_4908__169 VPWR VGND net169 sg13g2_tiehi
XFILLER_14_430 VPWR VGND sg13g2_decap_8
XFILLER_14_441 VPWR VGND sg13g2_fill_1
XFILLER_15_953 VPWR VGND sg13g2_decap_8
XFILLER_14_452 VPWR VGND sg13g2_fill_2
XFILLER_14_463 VPWR VGND sg13g2_decap_4
XFILLER_15_997 VPWR VGND sg13g2_decap_4
XFILLER_14_485 VPWR VGND sg13g2_decap_8
X_3490_ VGND VPWR _1154_ _1153_ _1136_ sg13g2_or2_1
X_5160_ net101 VGND VPWR _0510_ green_tmds_par\[8\] net664 sg13g2_dfrbpq_1
X_4111_ _1765_ _1767_ _1768_ VPWR VGND sg13g2_and2_1
X_5091_ net289 VGND VPWR _0441_ videogen.test_lut_thingy.pixel_feeder_inst.row\[61\]\[1\]
+ _0078_ sg13g2_dfrbpq_1
XFILLER_37_500 VPWR VGND sg13g2_decap_8
X_4042_ _1699_ _1701_ _1702_ VPWR VGND sg13g2_and2_1
XFILLER_25_706 VPWR VGND sg13g2_fill_1
X_4944_ net121 VGND VPWR _0298_ tmds_blue.vsync net660 sg13g2_dfrbpq_1
XFILLER_21_912 VPWR VGND sg13g2_decap_8
XFILLER_33_783 VPWR VGND sg13g2_fill_2
X_4875_ net696 net740 _0232_ VPWR VGND sg13g2_nor2_1
XFILLER_21_945 VPWR VGND sg13g2_fill_2
X_3826_ videogen.test_lut_thingy.pixel_feeder_inst.row\[58\]\[1\] net602 _1490_ VPWR
+ VGND sg13g2_nor2_1
XFILLER_20_477 VPWR VGND sg13g2_fill_2
X_3757_ videogen.test_lut_thingy.pixel_feeder_inst.row\[3\]\[2\] net581 _1421_ VPWR
+ VGND sg13g2_nor2_1
X_2708_ videogen.test_lut_thingy.pixel_feeder_inst.row\[21\]\[0\] net814 _0722_ _0663_
+ VPWR VGND sg13g2_mux2_1
X_3688_ _1348_ _1349_ _1350_ _1351_ _1352_ VPWR VGND sg13g2_nor4_1
XFILLER_0_849 VPWR VGND sg13g2_decap_8
X_4309_ _1961_ _1950_ net556 VPWR VGND sg13g2_xnor2_1
XFILLER_47_319 VPWR VGND sg13g2_fill_1
X_5289_ net63 VGND VPWR _0639_ serialize.shift_reg_b\[1\] clknet_3_3_0_clk_regs sg13g2_dfrbpq_1
X_5224__232 VPWR VGND net232 sg13g2_tiehi
XFILLER_16_706 VPWR VGND sg13g2_decap_4
XFILLER_11_422 VPWR VGND sg13g2_fill_2
XFILLER_8_938 VPWR VGND sg13g2_decap_8
XFILLER_7_415 VPWR VGND sg13g2_decap_8
X_5203__316 VPWR VGND net316 sg13g2_tiehi
XFILLER_19_533 VPWR VGND sg13g2_fill_1
XFILLER_47_886 VPWR VGND sg13g2_decap_8
XFILLER_46_374 VPWR VGND sg13g2_decap_4
XFILLER_0_56 VPWR VGND sg13g2_decap_8
XFILLER_34_503 VPWR VGND sg13g2_fill_2
X_2990_ net574 net558 _0740_ _0804_ VPWR VGND sg13g2_nor3_2
X_4921__155 VPWR VGND net155 sg13g2_tiehi
X_4660_ net716 net760 _0019_ VPWR VGND sg13g2_nor2_1
XFILLER_9_65 VPWR VGND sg13g2_fill_2
XFILLER_30_797 VPWR VGND sg13g2_fill_2
X_3611_ videogen.test_lut_thingy.pixel_feeder_inst.row\[36\]\[3\] net598 _1275_ VPWR
+ VGND sg13g2_nor2_1
X_4591_ VGND VPWR _2210_ tmds_blue.vsync hsync sg13g2_or2_1
XFILLER_6_481 VPWR VGND sg13g2_decap_8
X_3542_ _1203_ _1204_ _1201_ _1206_ VPWR VGND sg13g2_nand3_1
X_3473_ VGND VPWR _1007_ _1009_ _1137_ _1008_ sg13g2_a21oi_1
X_5212_ net280 VGND VPWR _0562_ videogen.test_lut_thingy.pixel_feeder_inst.row\[45\]\[2\]
+ _0191_ sg13g2_dfrbpq_1
X_5143_ net185 VGND VPWR _0493_ videogen.test_lut_thingy.pixel_feeder_inst.row\[54\]\[1\]
+ _0130_ sg13g2_dfrbpq_1
X_5243__107 VPWR VGND net107 sg13g2_tiehi
XFILLER_36_0 VPWR VGND sg13g2_decap_8
X_5074_ net323 VGND VPWR _0424_ videogen.test_lut_thingy.pixel_feeder_inst.row\[31\]\[0\]
+ _0061_ sg13g2_dfrbpq_1
XFILLER_49_190 VPWR VGND sg13g2_decap_8
XFILLER_38_853 VPWR VGND sg13g2_fill_1
X_4025_ _1685_ net561 _1684_ VPWR VGND sg13g2_xnor2_1
XFILLER_37_374 VPWR VGND sg13g2_decap_4
XFILLER_25_514 VPWR VGND sg13g2_fill_1
XFILLER_25_547 VPWR VGND sg13g2_fill_1
X_4927_ net143 VGND VPWR _0281_ videogen.test_lut_thingy.pixel_feeder_inst.row\[1\]\[3\]
+ _0012_ sg13g2_dfrbpq_1
X_4858_ net702 net746 _0215_ VPWR VGND sg13g2_nor2_1
XFILLER_20_230 VPWR VGND sg13g2_decap_8
X_3809_ _1469_ _1470_ _1471_ _1472_ _1473_ VPWR VGND sg13g2_nor4_1
XFILLER_20_274 VPWR VGND sg13g2_fill_2
XFILLER_5_908 VPWR VGND sg13g2_decap_8
X_4789_ net722 net763 _0146_ VPWR VGND sg13g2_nor2_1
Xheichips25_bagel_23 VPWR VGND uio_oe[2] sg13g2_tielo
XFILLER_0_646 VPWR VGND sg13g2_decap_8
XFILLER_48_617 VPWR VGND sg13g2_decap_8
XFILLER_47_105 VPWR VGND sg13g2_fill_2
XFILLER_18_30 VPWR VGND sg13g2_decap_8
XFILLER_29_842 VPWR VGND sg13g2_decap_8
XFILLER_44_834 VPWR VGND sg13g2_decap_8
XFILLER_16_503 VPWR VGND sg13g2_fill_1
XFILLER_16_525 VPWR VGND sg13g2_fill_2
XFILLER_18_85 VPWR VGND sg13g2_fill_1
XFILLER_16_547 VPWR VGND sg13g2_decap_8
XFILLER_44_878 VPWR VGND sg13g2_fill_1
XFILLER_31_506 VPWR VGND sg13g2_fill_2
XFILLER_12_731 VPWR VGND sg13g2_decap_8
XFILLER_15_1028 VPWR VGND sg13g2_fill_1
XFILLER_11_263 VPWR VGND sg13g2_decap_8
XFILLER_4_974 VPWR VGND sg13g2_decap_8
XFILLER_38_138 VPWR VGND sg13g2_decap_4
XFILLER_47_683 VPWR VGND sg13g2_decap_8
XFILLER_22_528 VPWR VGND sg13g2_decap_8
X_2973_ videogen.test_lut_thingy.pixel_feeder_inst.row\[6\]\[1\] net805 _0800_ _0433_
+ VPWR VGND sg13g2_mux2_1
X_4712_ net712 net756 _0069_ VPWR VGND sg13g2_nor2_1
XFILLER_30_561 VPWR VGND sg13g2_fill_2
X_4643_ VPWR _0661_ _2236_ VGND sg13g2_inv_1
X_4574_ net624 blue\[1\] _2198_ VPWR VGND sg13g2_xor2_1
X_3525_ VGND VPWR _1189_ _1179_ _1178_ sg13g2_or2_1
X_5110__251 VPWR VGND net251 sg13g2_tiehi
X_3456_ VPWR _1120_ _1119_ VGND sg13g2_inv_1
X_3387_ VPWR _1051_ _1050_ VGND sg13g2_inv_1
X_5126_ net219 VGND VPWR _0476_ videogen.test_lut_thingy.pixel_feeder_inst.row\[56\]\[0\]
+ _0113_ sg13g2_dfrbpq_1
X_5057_ net352 VGND VPWR _0407_ red_tmds_par\[9\] net665 sg13g2_dfrbpq_1
XFILLER_44_119 VPWR VGND sg13g2_fill_1
X_4008_ _1656_ _1659_ _1654_ _1668_ VPWR VGND _1666_ sg13g2_nand4_1
XFILLER_38_1028 VPWR VGND sg13g2_fill_1
XFILLER_38_1017 VPWR VGND sg13g2_decap_8
XFILLER_13_517 VPWR VGND sg13g2_fill_2
XFILLER_40_347 VPWR VGND sg13g2_fill_1
XFILLER_5_705 VPWR VGND sg13g2_decap_8
XFILLER_4_226 VPWR VGND sg13g2_decap_8
XFILLER_0_421 VPWR VGND sg13g2_decap_8
XFILLER_49_915 VPWR VGND sg13g2_decap_8
XFILLER_0_443 VPWR VGND sg13g2_decap_8
XFILLER_1_966 VPWR VGND sg13g2_decap_8
Xhold40 serialize.bit_cnt\[1\] VPWR VGND net485 sg13g2_dlygate4sd3_1
XFILLER_48_458 VPWR VGND sg13g2_decap_4
XFILLER_16_300 VPWR VGND sg13g2_decap_8
XFILLER_44_664 VPWR VGND sg13g2_decap_8
XFILLER_16_377 VPWR VGND sg13g2_fill_1
XFILLER_31_314 VPWR VGND sg13g2_decap_8
X_5057__352 VPWR VGND net352 sg13g2_tiehi
XFILLER_40_892 VPWR VGND sg13g2_fill_1
X_5092__287 VPWR VGND net287 sg13g2_tiehi
XFILLER_6_33 VPWR VGND sg13g2_decap_8
XFILLER_6_55 VPWR VGND sg13g2_decap_8
XFILLER_4_771 VPWR VGND sg13g2_decap_8
X_3310_ videogen.fancy_shader.video_y\[8\] _0980_ _0981_ VPWR VGND sg13g2_nor2_1
XFILLER_3_270 VPWR VGND sg13g2_fill_1
X_4290_ _1942_ red\[2\] red\[4\] VPWR VGND sg13g2_nand2_1
X_3241_ _0927_ _0932_ _0318_ VPWR VGND sg13g2_nor2_1
X_3172_ _0873_ _0884_ _0297_ VPWR VGND sg13g2_nor2_1
XFILLER_27_609 VPWR VGND sg13g2_decap_8
XFILLER_48_981 VPWR VGND sg13g2_decap_8
XFILLER_35_675 VPWR VGND sg13g2_decap_8
XFILLER_22_314 VPWR VGND sg13g2_fill_2
XFILLER_23_859 VPWR VGND sg13g2_decap_4
X_5744_ videogen.mem_row net11 VPWR VGND sg13g2_buf_8
X_2956_ videogen.test_lut_thingy.pixel_feeder_inst.row\[11\]\[1\] net798 _0795_ _0445_
+ VPWR VGND sg13g2_mux2_1
XFILLER_22_369 VPWR VGND sg13g2_decap_4
X_2887_ videogen.test_lut_thingy.pixel_feeder_inst.row\[53\]\[3\] net778 _0780_ _0499_
+ VPWR VGND sg13g2_mux2_1
X_5138__195 VPWR VGND net195 sg13g2_tiehi
X_4626_ _2228_ net672 net459 net678 green_tmds_par\[7\] VPWR VGND sg13g2_a22oi_1
X_4557_ _2184_ _2130_ _2183_ VPWR VGND sg13g2_nand2_1
XFILLER_1_218 VPWR VGND sg13g2_fill_1
X_4488_ _2052_ _2116_ _2122_ VPWR VGND sg13g2_nor2_1
X_3508_ videogen.fancy_shader.video_x\[0\] videogen.fancy_shader.video_y\[0\] _1172_
+ VPWR VGND sg13g2_xor2_1
X_3439_ VGND VPWR _1034_ _1043_ _1103_ _1033_ sg13g2_a21oi_1
XFILLER_46_918 VPWR VGND sg13g2_decap_8
X_5109_ net253 VGND VPWR _0459_ videogen.test_lut_thingy.pixel_feeder_inst.row\[5\]\[3\]
+ _0096_ sg13g2_dfrbpq_1
XFILLER_41_612 VPWR VGND sg13g2_decap_8
XFILLER_13_325 VPWR VGND sg13g2_decap_8
XFILLER_25_152 VPWR VGND sg13g2_decap_4
XFILLER_13_358 VPWR VGND sg13g2_fill_2
XFILLER_15_42 VPWR VGND sg13g2_decap_4
XFILLER_41_689 VPWR VGND sg13g2_fill_2
XFILLER_21_391 VPWR VGND sg13g2_fill_2
Xoutput6 net6 tmds_r VPWR VGND sg13g2_buf_1
XFILLER_5_568 VPWR VGND sg13g2_decap_8
XFILLER_1_763 VPWR VGND sg13g2_decap_8
XFILLER_49_712 VPWR VGND sg13g2_decap_8
XFILLER_0_295 VPWR VGND sg13g2_decap_8
XFILLER_49_789 VPWR VGND sg13g2_decap_8
XFILLER_29_480 VPWR VGND sg13g2_decap_8
XFILLER_36_439 VPWR VGND sg13g2_fill_2
XFILLER_45_984 VPWR VGND sg13g2_fill_1
XFILLER_16_163 VPWR VGND sg13g2_decap_8
XFILLER_32_667 VPWR VGND sg13g2_decap_8
X_3790_ videogen.test_lut_thingy.pixel_feeder_inst.row\[26\]\[1\] net600 _1454_ VPWR
+ VGND sg13g2_nor2_1
XFILLER_20_818 VPWR VGND sg13g2_fill_1
X_2810_ _0704_ _0728_ net645 _0764_ VPWR VGND sg13g2_nand3_1
X_2741_ videogen.test_lut_thingy.pixel_feeder_inst.row\[29\]\[2\] net792 _0737_ _0610_
+ VPWR VGND sg13g2_mux2_1
XFILLER_12_380 VPWR VGND sg13g2_decap_8
XFILLER_13_892 VPWR VGND sg13g2_fill_1
XFILLER_8_340 VPWR VGND sg13g2_fill_1
XFILLER_9_885 VPWR VGND sg13g2_fill_1
X_2672_ VPWR _0691_ tmds_red.dc_balancing_reg\[4\] VGND sg13g2_inv_1
X_4411_ _2054_ net622 _2052_ VPWR VGND sg13g2_nand2_2
X_4342_ _1993_ net564 _1992_ VPWR VGND sg13g2_xnor2_1
X_4273_ _1928_ _1929_ _1930_ VPWR VGND sg13g2_nor2_1
X_3224_ _0891_ _0920_ _0922_ VPWR VGND sg13g2_nor2_1
.ends
