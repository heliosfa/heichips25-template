* NGSPICE file created from heichips25_bagel.ext - technology: ihp-sg13g2

* Black-box entry subcircuit for sg13g2_a21oi_1 abstract view
.subckt sg13g2_a21oi_1 VSS VDD A1 A2 Y B1
.ends

* Black-box entry subcircuit for sg13g2_and2_1 abstract view
.subckt sg13g2_and2_1 A B X VDD VSS
.ends

* Black-box entry subcircuit for sg13g2_decap_8 abstract view
.subckt sg13g2_decap_8 VDD VSS
.ends

* Black-box entry subcircuit for sg13g2_fill_1 abstract view
.subckt sg13g2_fill_1 VDD VSS
.ends

* Black-box entry subcircuit for sg13g2_xnor2_1 abstract view
.subckt sg13g2_xnor2_1 Y A B VDD VSS
.ends

* Black-box entry subcircuit for sg13g2_fill_2 abstract view
.subckt sg13g2_fill_2 VDD VSS
.ends

* Black-box entry subcircuit for sg13g2_decap_4 abstract view
.subckt sg13g2_decap_4 VDD VSS
.ends

* Black-box entry subcircuit for sg13g2_mux2_1 abstract view
.subckt sg13g2_mux2_1 A0 A1 S X VDD VSS
.ends

* Black-box entry subcircuit for sg13g2_nor2_1 abstract view
.subckt sg13g2_nor2_1 A B Y VDD VSS
.ends

* Black-box entry subcircuit for sg13g2_tiehi abstract view
.subckt sg13g2_tiehi VDD VSS L_HI
.ends

* Black-box entry subcircuit for sg13g2_buf_8 abstract view
.subckt sg13g2_buf_8 A X VDD VSS
.ends

* Black-box entry subcircuit for sg13g2_dfrbpq_1 abstract view
.subckt sg13g2_dfrbpq_1 RESET_B VSS VDD D Q CLK
.ends

* Black-box entry subcircuit for sg13g2_dfrbpq_2 abstract view
.subckt sg13g2_dfrbpq_2 RESET_B VSS VDD D Q CLK
.ends

* Black-box entry subcircuit for sg13g2_mux4_1 abstract view
.subckt sg13g2_mux4_1 S0 A0 A1 A2 A3 S1 X VDD VSS
.ends

* Black-box entry subcircuit for sg13g2_nand2_2 abstract view
.subckt sg13g2_nand2_2 Y A B VDD VSS
.ends

* Black-box entry subcircuit for sg13g2_nand3_1 abstract view
.subckt sg13g2_nand3_1 B C A Y VDD VSS
.ends

* Black-box entry subcircuit for sg13g2_or2_1 abstract view
.subckt sg13g2_or2_1 VSS VDD X B A
.ends

* Black-box entry subcircuit for sg13g2_nand2b_1 abstract view
.subckt sg13g2_nand2b_1 Y B A_N VDD VSS
.ends

* Black-box entry subcircuit for sg13g2_nor3_1 abstract view
.subckt sg13g2_nor3_1 A B C Y VDD VSS
.ends

* Black-box entry subcircuit for sg13g2_buf_1 abstract view
.subckt sg13g2_buf_1 A X VDD VSS
.ends

* Black-box entry subcircuit for sg13g2_a21o_1 abstract view
.subckt sg13g2_a21o_1 A2 A1 B1 X VDD VSS
.ends

* Black-box entry subcircuit for sg13g2_o21ai_1 abstract view
.subckt sg13g2_o21ai_1 B1 VDD Y VSS A1 A2
.ends

* Black-box entry subcircuit for sg13g2_nand2_1 abstract view
.subckt sg13g2_nand2_1 Y A B VDD VSS
.ends

* Black-box entry subcircuit for sg13g2_nand4_1 abstract view
.subckt sg13g2_nand4_1 B C A Y VDD VSS D
.ends

* Black-box entry subcircuit for sg13g2_tielo abstract view
.subckt sg13g2_tielo VDD VSS L_LO
.ends

* Black-box entry subcircuit for sg13g2_xor2_1 abstract view
.subckt sg13g2_xor2_1 B A X VDD VSS
.ends

* Black-box entry subcircuit for sg13g2_dlygate4sd3_1 abstract view
.subckt sg13g2_dlygate4sd3_1 A VDD VSS X
.ends

* Black-box entry subcircuit for sg13g2_nor2_2 abstract view
.subckt sg13g2_nor2_2 A B Y VDD VSS
.ends

* Black-box entry subcircuit for sg13g2_buf_2 abstract view
.subckt sg13g2_buf_2 A X VDD VSS
.ends

* Black-box entry subcircuit for sg13g2_or3_1 abstract view
.subckt sg13g2_or3_1 A B C X VDD VSS
.ends

* Black-box entry subcircuit for sg13g2_nor4_1 abstract view
.subckt sg13g2_nor4_1 A B C D Y VDD VSS
.ends

* Black-box entry subcircuit for sg13g2_inv_1 abstract view
.subckt sg13g2_inv_1 VDD Y A VSS
.ends

* Black-box entry subcircuit for sg13g2_and3_1 abstract view
.subckt sg13g2_and3_1 X A B C VDD VSS
.ends

* Black-box entry subcircuit for sg13g2_nor2b_2 abstract view
.subckt sg13g2_nor2b_2 A B_N Y VDD VSS
.ends

* Black-box entry subcircuit for sg13g2_a22oi_1 abstract view
.subckt sg13g2_a22oi_1 Y B1 B2 A2 A1 VDD VSS
.ends

* Black-box entry subcircuit for sg13g2_nand2b_2 abstract view
.subckt sg13g2_nand2b_2 Y B VDD VSS A_N
.ends

* Black-box entry subcircuit for sg13g2_inv_2 abstract view
.subckt sg13g2_inv_2 Y A VDD VSS
.ends

* Black-box entry subcircuit for sg13g2_a21oi_2 abstract view
.subckt sg13g2_a21oi_2 VSS VDD B1 Y A2 A1
.ends

* Black-box entry subcircuit for sg13g2_a221oi_1 abstract view
.subckt sg13g2_a221oi_1 VDD VSS B2 C1 B1 A1 Y A2
.ends

* Black-box entry subcircuit for sg13g2_nor2b_1 abstract view
.subckt sg13g2_nor2b_1 A B_N Y VDD VSS
.ends

* Black-box entry subcircuit for sg13g2_nand3b_1 abstract view
.subckt sg13g2_nand3b_1 B C Y VDD VSS A_N
.ends

* Black-box entry subcircuit for sg13g2_nor4_2 abstract view
.subckt sg13g2_nor4_2 A B C Y VSS VDD D
.ends

* Black-box entry subcircuit for sg13g2_inv_4 abstract view
.subckt sg13g2_inv_4 A Y VDD VSS
.ends

* Black-box entry subcircuit for sg13g2_nor3_2 abstract view
.subckt sg13g2_nor3_2 A B C Y VDD VSS
.ends

* Black-box entry subcircuit for sg13g2_a21o_2 abstract view
.subckt sg13g2_a21o_2 A2 A1 B1 X VDD VSS
.ends

* Black-box entry subcircuit for sg13g2_and4_1 abstract view
.subckt sg13g2_and4_1 A B C D X VDD VSS
.ends

* Black-box entry subcircuit for sg13g2_or4_1 abstract view
.subckt sg13g2_or4_1 A B C D X VDD VSS
.ends

* Black-box entry subcircuit for sg13g2_and3_2 abstract view
.subckt sg13g2_and3_2 X A B C VDD VSS
.ends

.subckt heichips25_bagel VGND VPWR clk ena rst_n tmds_b tmds_clk tmds_g tmds_r ui_in[0]
+ ui_in[1] ui_in[2] ui_in[3] ui_in[4] ui_in[5] ui_in[6] ui_in[7] uio_in[0] uio_in[1]
+ uio_in[2] uio_in[3] uio_in[4] uio_in[5] uio_in[6] uio_in[7] uio_oe[0] uio_oe[1]
+ uio_oe[2] uio_oe[3] uio_oe[4] uio_oe[5] uio_oe[6] uio_oe[7] uio_out[0] uio_out[1]
+ uio_out[2] uio_out[3] uio_out[4] uio_out[5] uio_out[6] uio_out[7] uo_out[0] uo_out[1]
+ uo_out[2] uo_out[3] uo_out[4] uo_out[5] uo_out[6] uo_out[7]
X_3155_ VGND VPWR net633 _0912_ _0309_ _0913_ sg13g2_a21oi_1
X_3086_ red_tmds_par\[9\] net665 _0264_ VPWR VGND sg13g2_and2_1
XFILLER_36_940 VPWR VGND sg13g2_decap_8
XFILLER_23_601 VPWR VGND sg13g2_fill_1
XFILLER_35_1009 VPWR VGND sg13g2_decap_8
X_3988_ _1699_ _1082_ _1698_ VPWR VGND sg13g2_xnor2_1
XFILLER_22_188 VPWR VGND sg13g2_fill_2
XFILLER_22_199 VPWR VGND sg13g2_decap_4
X_2939_ videogen.test_lut_thingy.pixel_feeder_inst.row\[32\]\[0\] net798 _0811_ _0424_
+ VPWR VGND sg13g2_mux2_1
XFILLER_11_1020 VPWR VGND sg13g2_decap_8
X_4609_ net690 net734 _0073_ VPWR VGND sg13g2_nor2_1
XFILLER_2_505 VPWR VGND sg13g2_decap_8
X_4858__88 VPWR VGND net88 sg13g2_tiehi
X_4873__58 VPWR VGND net58 sg13g2_tiehi
XFILLER_18_417 VPWR VGND sg13g2_fill_2
XFILLER_42_976 VPWR VGND sg13g2_decap_8
Xclkbuf_3_6__f_clk_regs clknet_0_clk_regs clknet_3_6__leaf_clk_regs VPWR VGND sg13g2_buf_8
XFILLER_42_51 VPWR VGND sg13g2_fill_2
XFILLER_42_40 VPWR VGND sg13g2_decap_8
XFILLER_13_177 VPWR VGND sg13g2_fill_2
X_4837__125 VPWR VGND net125 sg13g2_tiehi
XFILLER_10_862 VPWR VGND sg13g2_decap_8
XFILLER_3_34 VPWR VGND sg13g2_fill_1
XFILLER_3_1007 VPWR VGND sg13g2_decap_8
XFILLER_49_586 VPWR VGND sg13g2_decap_8
XFILLER_37_737 VPWR VGND sg13g2_fill_1
XFILLER_18_973 VPWR VGND sg13g2_decap_8
X_4960_ net346 VGND VPWR _0417_ videogen.test_lut_thingy.pixel_feeder_inst.row\[36\]\[1\]
+ _0054_ sg13g2_dfrbpq_1
XFILLER_17_450 VPWR VGND sg13g2_decap_8
X_4891_ net437 VGND VPWR _0352_ videogen.fancy_shader.video_y\[9\] net643 sg13g2_dfrbpq_2
X_3911_ VGND VPWR _1612_ _1613_ _1625_ _1608_ sg13g2_a21oi_1
XFILLER_33_965 VPWR VGND sg13g2_decap_8
X_3842_ net628 videogen.test_lut_thingy.pixel_feeder_inst.row\[48\]\[0\] videogen.test_lut_thingy.pixel_feeder_inst.row\[50\]\[0\]
+ videogen.test_lut_thingy.pixel_feeder_inst.row\[49\]\[0\] videogen.test_lut_thingy.pixel_feeder_inst.row\[51\]\[0\]
+ net631 _1559_ VPWR VGND sg13g2_mux4_1
X_4820__151 VPWR VGND net151 sg13g2_tiehi
X_3773_ videogen.test_lut_thingy.pixel_feeder_inst.row\[28\]\[1\] net578 _1491_ VPWR
+ VGND sg13g2_nor2_1
X_2724_ _0760_ net604 _0733_ VPWR VGND sg13g2_nand2_2
X_2655_ _0723_ _0725_ net604 _0727_ VPWR VGND sg13g2_nand3_1
X_4325_ VGND VPWR _2015_ _2013_ _2007_ sg13g2_or2_1
X_4256_ _1960_ _1959_ _1951_ VPWR VGND sg13g2_nand2b_1
XFILLER_41_1013 VPWR VGND sg13g2_decap_8
X_3207_ net551 _0946_ _0947_ _0335_ VPWR VGND sg13g2_nor3_1
X_4187_ _1888_ _1892_ _1893_ VPWR VGND sg13g2_and2_1
X_3138_ videogen.test_lut_thingy.pixel_feeder_inst.v_pix\[1\] _0901_ _0902_ VPWR VGND
+ sg13g2_and2_1
XFILLER_43_707 VPWR VGND sg13g2_decap_8
X_3069_ VGND VPWR videogen.test_lut_thingy.pixel_feeder_inst.v_pix\[5\] _0866_ _0870_
+ _0869_ sg13g2_a21oi_1
XFILLER_24_921 VPWR VGND sg13g2_decap_8
XFILLER_36_781 VPWR VGND sg13g2_decap_8
XFILLER_23_420 VPWR VGND sg13g2_fill_2
XFILLER_24_998 VPWR VGND sg13g2_decap_8
XFILLER_7_619 VPWR VGND sg13g2_decap_8
XFILLER_12_98 VPWR VGND sg13g2_decap_4
XFILLER_5_4 VPWR VGND sg13g2_decap_8
XFILLER_2_357 VPWR VGND sg13g2_decap_8
Xfanout650 net651 net650 VPWR VGND sg13g2_buf_8
Xfanout661 net662 net661 VPWR VGND sg13g2_buf_8
Xfanout694 net696 net694 VPWR VGND sg13g2_buf_1
Xfanout672 net673 net672 VPWR VGND sg13g2_buf_8
Xfanout683 net686 net683 VPWR VGND sg13g2_buf_8
XFILLER_18_225 VPWR VGND sg13g2_fill_1
XFILLER_27_770 VPWR VGND sg13g2_decap_8
XFILLER_14_420 VPWR VGND sg13g2_fill_1
XFILLER_15_987 VPWR VGND sg13g2_decap_8
XFILLER_18_1015 VPWR VGND sg13g2_decap_8
XFILLER_30_913 VPWR VGND sg13g2_fill_2
XFILLER_14_486 VPWR VGND sg13g2_fill_2
XFILLER_30_968 VPWR VGND sg13g2_decap_8
X_4110_ _1814_ _1808_ _1816_ _1821_ VPWR VGND sg13g2_a21o_1
X_5090_ net362 VGND VPWR _0547_ videogen.test_lut_thingy.pixel_feeder_inst.row\[48\]\[2\]
+ _0175_ sg13g2_dfrbpq_1
X_4041_ _1750_ _1751_ _1752_ VPWR VGND sg13g2_and2_1
XFILLER_49_383 VPWR VGND sg13g2_decap_8
XFILLER_37_589 VPWR VGND sg13g2_fill_1
XFILLER_24_206 VPWR VGND sg13g2_decap_8
X_4943_ net363 VGND VPWR _0404_ videogen.test_lut_thingy.pixel_feeder_inst.row\[15\]\[1\]
+ _0050_ sg13g2_dfrbpq_1
XFILLER_18_792 VPWR VGND sg13g2_decap_4
XFILLER_33_762 VPWR VGND sg13g2_decap_4
X_4874_ net56 VGND VPWR _0335_ videogen.fancy_shader.shader_counter_reg\[4\] net645
+ sg13g2_dfrbpq_2
XFILLER_32_261 VPWR VGND sg13g2_decap_8
XFILLER_21_968 VPWR VGND sg13g2_decap_8
X_3825_ _1541_ VPWR _1542_ VGND net619 _1537_ sg13g2_o21ai_1
X_3756_ videogen.test_lut_thingy.pixel_feeder_inst.row\[27\]\[1\] net567 _1474_ VPWR
+ VGND sg13g2_nor2_1
X_2707_ videogen.test_lut_thingy.pixel_feeder_inst.row\[49\]\[2\] net775 _0753_ _0607_
+ VPWR VGND sg13g2_mux2_1
X_3687_ videogen.test_lut_thingy.pixel_feeder_inst.row\[38\]\[2\] net585 _1405_ VPWR
+ VGND sg13g2_nor2_1
X_2638_ _0698_ _0709_ _0710_ VPWR VGND sg13g2_nor2_1
X_4308_ _0688_ _1987_ _2000_ VPWR VGND sg13g2_nor2_1
X_4239_ _1944_ _1938_ _1941_ VPWR VGND sg13g2_nand2_1
XFILLER_28_512 VPWR VGND sg13g2_decap_8
XFILLER_28_523 VPWR VGND sg13g2_fill_2
XFILLER_28_556 VPWR VGND sg13g2_decap_8
XFILLER_43_559 VPWR VGND sg13g2_fill_2
XFILLER_43_548 VPWR VGND sg13g2_decap_8
XFILLER_12_979 VPWR VGND sg13g2_decap_8
XFILLER_23_53 VPWR VGND sg13g2_decap_8
XFILLER_7_427 VPWR VGND sg13g2_fill_1
X_4834__128 VPWR VGND net128 sg13g2_tiehi
XFILLER_47_865 VPWR VGND sg13g2_decap_8
XFILLER_0_35 VPWR VGND sg13g2_decap_8
XFILLER_19_556 VPWR VGND sg13g2_decap_8
XFILLER_0_57 VPWR VGND sg13g2_fill_1
XFILLER_14_261 VPWR VGND sg13g2_decap_8
XFILLER_14_272 VPWR VGND sg13g2_fill_1
XFILLER_9_66 VPWR VGND sg13g2_decap_4
X_4590_ net673 net716 _0054_ VPWR VGND sg13g2_nor2_1
X_3610_ net625 VPWR _1328_ VGND videogen.test_lut_thingy.pixel_feeder_inst.row\[4\]\[2\]
+ net583 sg13g2_o21ai_1
X_3541_ net600 VPWR _1259_ VGND videogen.test_lut_thingy.pixel_feeder_inst.row\[34\]\[3\]
+ net588 sg13g2_o21ai_1
XFILLER_7_983 VPWR VGND sg13g2_decap_8
XFILLER_6_482 VPWR VGND sg13g2_fill_2
X_3472_ net549 _1181_ _1189_ _1190_ VPWR VGND sg13g2_nor3_1
X_5211_ net207 VGND VPWR _0668_ serialize.shift_reg_c\[5\] clknet_3_2__leaf_clk_regs
+ sg13g2_dfrbpq_1
X_5142_ net59 VGND VPWR _0599_ videogen.test_lut_thingy.pixel_feeder_inst.row\[29\]\[2\]
+ _0227_ sg13g2_dfrbpq_1
XFILLER_29_0 VPWR VGND sg13g2_fill_1
XFILLER_29_309 VPWR VGND sg13g2_fill_1
X_5073_ net45 VGND VPWR _0530_ videogen.test_lut_thingy.pixel_feeder_inst.row\[52\]\[1\]
+ _0158_ sg13g2_dfrbpq_1
XFILLER_37_320 VPWR VGND sg13g2_fill_2
X_4024_ _1715_ _1725_ _1687_ _1735_ VPWR VGND _1731_ sg13g2_nand4_1
XFILLER_38_876 VPWR VGND sg13g2_fill_1
XFILLER_37_364 VPWR VGND sg13g2_fill_2
XFILLER_25_537 VPWR VGND sg13g2_decap_8
X_4926_ net394 VGND VPWR _0387_ videogen.test_lut_thingy.pixel_feeder_inst.row\[12\]\[3\]
+ _0036_ sg13g2_dfrbpq_1
X_4857_ net90 VGND VPWR _0318_ videogen.test_lut_thingy.pixel_feeder_inst.v_counter\[3\]
+ net657 sg13g2_dfrbpq_1
XFILLER_20_253 VPWR VGND sg13g2_decap_8
X_3808_ _1525_ _0736_ videogen.test_lut_thingy.pixel_feeder_inst.row\[5\]\[0\] VPWR
+ VGND sg13g2_nand2b_1
X_4788_ net696 net739 _0250_ VPWR VGND sg13g2_nor2_1
Xheichips25_bagel_24 VPWR VGND uio_oe[3] sg13g2_tielo
X_3739_ videogen.test_lut_thingy.pixel_feeder_inst.row\[49\]\[1\] net558 _1457_ VPWR
+ VGND sg13g2_nor2_1
XFILLER_47_106 VPWR VGND sg13g2_fill_1
XFILLER_29_876 VPWR VGND sg13g2_decap_8
XFILLER_16_548 VPWR VGND sg13g2_decap_8
XFILLER_43_356 VPWR VGND sg13g2_fill_2
XFILLER_24_570 VPWR VGND sg13g2_decap_8
XFILLER_34_96 VPWR VGND sg13g2_decap_8
XFILLER_7_279 VPWR VGND sg13g2_decap_4
XFILLER_4_964 VPWR VGND sg13g2_decap_8
XFILLER_3_441 VPWR VGND sg13g2_decap_4
XFILLER_38_128 VPWR VGND sg13g2_decap_8
XFILLER_47_640 VPWR VGND sg13g2_decap_8
XFILLER_19_364 VPWR VGND sg13g2_fill_2
XFILLER_19_353 VPWR VGND sg13g2_decap_8
X_5097__325 VPWR VGND net325 sg13g2_tiehi
X_2972_ videogen.test_lut_thingy.pixel_feeder_inst.row\[12\]\[2\] net782 _0818_ _0386_
+ VPWR VGND sg13g2_mux2_1
X_4711_ net681 net725 _0175_ VPWR VGND sg13g2_nor2_1
X_4642_ net694 net737 _0106_ VPWR VGND sg13g2_nor2_1
XFILLER_30_573 VPWR VGND sg13g2_fill_1
X_4573_ net701 net745 _0037_ VPWR VGND sg13g2_nor2_1
X_5030__206 VPWR VGND net206 sg13g2_tiehi
X_3524_ net600 VPWR _1242_ VGND videogen.test_lut_thingy.pixel_feeder_inst.row\[49\]\[3\]
+ net558 sg13g2_o21ai_1
X_3455_ _1172_ VPWR _1173_ VGND _1157_ _1169_ sg13g2_o21ai_1
X_3386_ _1104_ _1026_ _1103_ VPWR VGND sg13g2_xnor2_1
X_5125_ net213 VGND VPWR _0582_ videogen.test_lut_thingy.pixel_feeder_inst.row\[40\]\[1\]
+ _0210_ sg13g2_dfrbpq_1
X_5056_ net113 VGND VPWR _0513_ videogen.test_lut_thingy.pixel_feeder_inst.row\[26\]\[0\]
+ _0141_ sg13g2_dfrbpq_1
XFILLER_29_128 VPWR VGND sg13g2_fill_1
X_4007_ _1717_ _1688_ _1718_ VPWR VGND sg13g2_xor2_1
XFILLER_37_183 VPWR VGND sg13g2_decap_4
XFILLER_25_345 VPWR VGND sg13g2_fill_1
X_4909_ net418 VGND VPWR _0370_ red\[7\] net650 sg13g2_dfrbpq_1
X_4800__182 VPWR VGND net182 sg13g2_tiehi
XFILLER_20_76 VPWR VGND sg13g2_decap_4
XFILLER_0_444 VPWR VGND sg13g2_decap_8
XFILLER_1_967 VPWR VGND sg13g2_decap_8
XFILLER_49_938 VPWR VGND sg13g2_decap_8
Xhold30 serialize.shift_reg_g\[8\] VPWR VGND net476 sg13g2_dlygate4sd3_1
XFILLER_48_437 VPWR VGND sg13g2_decap_8
XFILLER_44_621 VPWR VGND sg13g2_fill_2
XFILLER_44_665 VPWR VGND sg13g2_fill_2
XFILLER_44_654 VPWR VGND sg13g2_decap_8
XFILLER_16_367 VPWR VGND sg13g2_fill_1
XFILLER_32_816 VPWR VGND sg13g2_fill_1
XFILLER_45_95 VPWR VGND sg13g2_decap_8
XFILLER_31_315 VPWR VGND sg13g2_fill_2
XFILLER_12_562 VPWR VGND sg13g2_fill_1
XFILLER_12_573 VPWR VGND sg13g2_decap_8
XFILLER_6_45 VPWR VGND sg13g2_decap_8
XFILLER_4_761 VPWR VGND sg13g2_fill_1
XFILLER_4_783 VPWR VGND sg13g2_fill_2
XFILLER_3_271 VPWR VGND sg13g2_decap_8
X_3240_ _0676_ _0852_ _0878_ _0969_ VPWR VGND sg13g2_nor3_1
X_3171_ _0922_ _0923_ _0315_ VPWR VGND sg13g2_nor2_1
XFILLER_20_4 VPWR VGND sg13g2_fill_1
XFILLER_48_971 VPWR VGND sg13g2_decap_8
XFILLER_19_172 VPWR VGND sg13g2_fill_2
XFILLER_23_816 VPWR VGND sg13g2_decap_8
XFILLER_35_676 VPWR VGND sg13g2_fill_1
X_2955_ _0756_ _0803_ _0815_ VPWR VGND sg13g2_nor2_2
X_2886_ _0799_ VPWR _0465_ VGND _0672_ _0798_ sg13g2_o21ai_1
XFILLER_31_893 VPWR VGND sg13g2_fill_1
X_4625_ net703 net749 _0089_ VPWR VGND sg13g2_nor2_1
X_4556_ net672 net716 _0022_ VPWR VGND sg13g2_nor2_1
X_3507_ _0991_ _1218_ _1219_ _1225_ VPWR VGND sg13g2_nor3_1
X_4487_ VGND VPWR net481 _0876_ _2158_ net760 sg13g2_a21oi_1
XFILLER_44_1000 VPWR VGND sg13g2_decap_8
X_4885__34 VPWR VGND net34 sg13g2_tiehi
X_3438_ _1156_ _0989_ _0998_ VPWR VGND sg13g2_xnor2_1
X_3369_ _1087_ _1083_ _1084_ VPWR VGND sg13g2_nand2_1
X_5108_ net281 VGND VPWR _0565_ videogen.test_lut_thingy.pixel_feeder_inst.row\[44\]\[0\]
+ _0193_ sg13g2_dfrbpq_1
XFILLER_46_919 VPWR VGND sg13g2_decap_8
XFILLER_39_982 VPWR VGND sg13g2_decap_8
X_5039_ net196 VGND VPWR _0496_ tmds_blue.dc_balancing_reg\[4\] net648 sg13g2_dfrbpq_2
XFILLER_45_429 VPWR VGND sg13g2_decap_8
XFILLER_38_470 VPWR VGND sg13g2_decap_4
XFILLER_26_610 VPWR VGND sg13g2_decap_8
XFILLER_25_120 VPWR VGND sg13g2_decap_4
XFILLER_13_304 VPWR VGND sg13g2_decap_8
XFILLER_14_849 VPWR VGND sg13g2_decap_8
XFILLER_41_657 VPWR VGND sg13g2_decap_4
Xclkbuf_3_5__f_clk_regs clknet_0_clk_regs clknet_3_5__leaf_clk_regs VPWR VGND sg13g2_buf_8
XFILLER_40_167 VPWR VGND sg13g2_decap_8
XFILLER_9_308 VPWR VGND sg13g2_decap_8
X_5062__89 VPWR VGND net89 sg13g2_tiehi
XFILLER_22_871 VPWR VGND sg13g2_decap_8
XFILLER_31_64 VPWR VGND sg13g2_decap_8
Xoutput20 net20 uo_out[7] VPWR VGND sg13g2_buf_1
Xoutput7 net7 uio_out[0] VPWR VGND sg13g2_buf_1
XFILLER_0_230 VPWR VGND sg13g2_fill_2
XFILLER_1_764 VPWR VGND sg13g2_decap_8
XFILLER_0_296 VPWR VGND sg13g2_fill_2
X_4963__340 VPWR VGND net340 sg13g2_tiehi
XFILLER_45_930 VPWR VGND sg13g2_decap_8
XFILLER_16_175 VPWR VGND sg13g2_fill_2
XFILLER_17_676 VPWR VGND sg13g2_decap_8
XFILLER_13_860 VPWR VGND sg13g2_decap_8
XFILLER_9_831 VPWR VGND sg13g2_decap_4
XFILLER_31_189 VPWR VGND sg13g2_fill_2
X_2740_ videogen.test_lut_thingy.pixel_feeder_inst.row\[3\]\[0\] net802 _0764_ _0585_
+ VPWR VGND sg13g2_mux2_1
XFILLER_8_363 VPWR VGND sg13g2_decap_8
X_2671_ videogen.test_lut_thingy.pixel_feeder_inst.row\[23\]\[3\] net768 _0734_ _0634_
+ VPWR VGND sg13g2_mux2_1
X_4410_ _2061_ VPWR _2091_ VGND _2081_ _2090_ sg13g2_o21ai_1
X_4341_ _2001_ VPWR _2030_ VGND _2007_ _2021_ sg13g2_o21ai_1
XFILLER_4_591 VPWR VGND sg13g2_decap_8
X_4272_ _1966_ VPWR _1975_ VGND _1964_ _1967_ sg13g2_o21ai_1
XFILLER_28_1028 VPWR VGND sg13g2_fill_1
X_3223_ _0958_ net809 net609 VPWR VGND sg13g2_nand2_2
X_3154_ _0842_ VPWR _0913_ VGND net633 _0912_ sg13g2_o21ai_1
X_3085_ red_tmds_par\[8\] net663 _0263_ VPWR VGND sg13g2_and2_1
XFILLER_36_996 VPWR VGND sg13g2_decap_8
XFILLER_23_657 VPWR VGND sg13g2_decap_8
X_3987_ _1038_ _1092_ _1696_ _1698_ VPWR VGND sg13g2_nor3_1
XFILLER_10_307 VPWR VGND sg13g2_decap_8
XFILLER_22_167 VPWR VGND sg13g2_fill_2
XFILLER_23_679 VPWR VGND sg13g2_decap_8
X_2938_ videogen.test_lut_thingy.pixel_feeder_inst.row\[32\]\[1\] net787 _0811_ _0425_
+ VPWR VGND sg13g2_mux2_1
X_2869_ net774 videogen.test_lut_thingy.pixel_feeder_inst.row\[56\]\[2\] _0795_ _0478_
+ VPWR VGND sg13g2_mux2_1
X_4608_ net689 net733 _0072_ VPWR VGND sg13g2_nor2_1
X_4539_ net480 net810 net664 _0669_ VPWR VGND sg13g2_a21o_1
Xfanout810 net811 net810 VPWR VGND sg13g2_buf_8
XFILLER_46_705 VPWR VGND sg13g2_fill_2
XFILLER_45_226 VPWR VGND sg13g2_decap_8
XFILLER_45_237 VPWR VGND sg13g2_decap_4
XFILLER_27_941 VPWR VGND sg13g2_fill_2
XFILLER_27_996 VPWR VGND sg13g2_decap_8
XFILLER_42_955 VPWR VGND sg13g2_decap_8
XFILLER_41_476 VPWR VGND sg13g2_decap_8
XFILLER_13_156 VPWR VGND sg13g2_decap_8
XFILLER_9_149 VPWR VGND sg13g2_decap_8
XFILLER_10_830 VPWR VGND sg13g2_fill_1
XFILLER_10_885 VPWR VGND sg13g2_decap_4
XFILLER_5_355 VPWR VGND sg13g2_fill_2
XFILLER_3_79 VPWR VGND sg13g2_decap_4
XFILLER_49_565 VPWR VGND sg13g2_decap_8
XFILLER_17_440 VPWR VGND sg13g2_fill_2
XFILLER_18_952 VPWR VGND sg13g2_decap_8
XFILLER_33_900 VPWR VGND sg13g2_decap_8
XFILLER_33_911 VPWR VGND sg13g2_decap_4
XFILLER_45_793 VPWR VGND sg13g2_decap_8
XFILLER_44_270 VPWR VGND sg13g2_decap_4
X_4890_ net439 VGND VPWR _0351_ videogen.fancy_shader.video_y\[8\] net643 sg13g2_dfrbpq_2
X_3910_ _1619_ VPWR _1624_ VGND _1621_ _1622_ sg13g2_o21ai_1
XFILLER_33_944 VPWR VGND sg13g2_decap_8
X_3841_ net621 VPWR _1558_ VGND _1556_ _1557_ sg13g2_o21ai_1
XFILLER_20_627 VPWR VGND sg13g2_decap_8
XFILLER_20_638 VPWR VGND sg13g2_decap_8
X_3772_ videogen.test_lut_thingy.pixel_feeder_inst.row\[31\]\[1\] net568 _1490_ VPWR
+ VGND sg13g2_nor2_1
X_2723_ videogen.test_lut_thingy.pixel_feeder_inst.row\[29\]\[0\] net798 _0759_ _0597_
+ VPWR VGND sg13g2_mux2_1
X_2654_ _0726_ _0706_ _0724_ VPWR VGND sg13g2_nand2_2
X_4324_ VGND VPWR _2007_ _2013_ _2014_ _2001_ sg13g2_a21oi_1
X_4255_ _1959_ _1955_ _1957_ VPWR VGND sg13g2_xnor2_1
X_3206_ videogen.fancy_shader.shader_counter_reg\[4\] _0945_ _0947_ VPWR VGND sg13g2_and2_1
X_4186_ _1892_ _1890_ _1887_ VPWR VGND sg13g2_nand2b_1
X_3137_ _0900_ _0901_ _0303_ VPWR VGND sg13g2_nor2_1
X_3068_ _0855_ VPWR _0869_ VGND videogen.test_lut_thingy.pixel_feeder_inst.v_pix\[5\]
+ _0866_ sg13g2_o21ai_1
XFILLER_24_900 VPWR VGND sg13g2_decap_8
XFILLER_36_771 VPWR VGND sg13g2_decap_4
XFILLER_35_281 VPWR VGND sg13g2_fill_1
XFILLER_35_292 VPWR VGND sg13g2_decap_8
XFILLER_24_977 VPWR VGND sg13g2_decap_8
XFILLER_11_649 VPWR VGND sg13g2_fill_2
XFILLER_7_609 VPWR VGND sg13g2_decap_4
XFILLER_3_804 VPWR VGND sg13g2_decap_8
XFILLER_12_55 VPWR VGND sg13g2_decap_8
Xfanout640 net641 net640 VPWR VGND sg13g2_buf_8
Xfanout651 net654 net651 VPWR VGND sg13g2_buf_8
Xfanout684 net686 net684 VPWR VGND sg13g2_buf_1
Xfanout673 net692 net673 VPWR VGND sg13g2_buf_2
Xfanout662 _0874_ net662 VPWR VGND sg13g2_buf_8
Xfanout695 net696 net695 VPWR VGND sg13g2_buf_8
XFILLER_46_535 VPWR VGND sg13g2_decap_8
XFILLER_37_85 VPWR VGND sg13g2_decap_8
XFILLER_26_270 VPWR VGND sg13g2_decap_4
XFILLER_42_774 VPWR VGND sg13g2_fill_1
XFILLER_15_966 VPWR VGND sg13g2_decap_8
XFILLER_30_903 VPWR VGND sg13g2_decap_8
XFILLER_41_284 VPWR VGND sg13g2_fill_1
XFILLER_30_947 VPWR VGND sg13g2_decap_8
XFILLER_41_295 VPWR VGND sg13g2_fill_1
X_4891__437 VPWR VGND net437 sg13g2_tiehi
XFILLER_10_660 VPWR VGND sg13g2_fill_1
XFILLER_5_152 VPWR VGND sg13g2_fill_1
XFILLER_5_141 VPWR VGND sg13g2_decap_8
X_4040_ _1730_ _1734_ _1738_ _1751_ VPWR VGND sg13g2_or3_1
X_4942_ net365 VGND VPWR _0403_ videogen.test_lut_thingy.pixel_feeder_inst.row\[15\]\[0\]
+ _0049_ sg13g2_dfrbpq_1
X_4860__84 VPWR VGND net84 sg13g2_tiehi
XFILLER_24_229 VPWR VGND sg13g2_decap_4
X_4873_ net58 VGND VPWR _0334_ videogen.fancy_shader.shader_counter_reg\[3\] net642
+ sg13g2_dfrbpq_2
XFILLER_21_947 VPWR VGND sg13g2_decap_8
X_3824_ VGND VPWR net619 _1540_ _1541_ net616 sg13g2_a21oi_1
X_3755_ videogen.test_lut_thingy.pixel_feeder_inst.row\[24\]\[1\] net577 _1473_ VPWR
+ VGND sg13g2_nor2_1
XFILLER_9_491 VPWR VGND sg13g2_decap_8
X_3686_ videogen.test_lut_thingy.pixel_feeder_inst.row\[39\]\[2\] net565 _1404_ VPWR
+ VGND sg13g2_nor2_1
X_2706_ videogen.test_lut_thingy.pixel_feeder_inst.row\[49\]\[3\] net763 _0753_ _0608_
+ VPWR VGND sg13g2_mux2_1
X_2637_ _0703_ _0708_ _0700_ _0709_ VPWR VGND sg13g2_nand3_1
X_5113__261 VPWR VGND net261 sg13g2_tiehi
X_4307_ VGND VPWR net610 net545 _0410_ net759 sg13g2_a21oi_1
X_4238_ _1938_ _1942_ _1943_ VPWR VGND sg13g2_nor2_1
XFILLER_28_535 VPWR VGND sg13g2_decap_8
XFILLER_28_546 VPWR VGND sg13g2_fill_1
X_5083__393 VPWR VGND net393 sg13g2_tiehi
X_4169_ red\[0\] red\[2\] _1875_ VPWR VGND sg13g2_and2_1
XFILLER_15_207 VPWR VGND sg13g2_decap_8
XFILLER_24_741 VPWR VGND sg13g2_fill_2
XFILLER_11_413 VPWR VGND sg13g2_decap_8
XFILLER_8_929 VPWR VGND sg13g2_decap_8
XFILLER_7_406 VPWR VGND sg13g2_decap_4
XFILLER_12_958 VPWR VGND sg13g2_decap_8
XFILLER_23_295 VPWR VGND sg13g2_fill_1
XFILLER_19_513 VPWR VGND sg13g2_fill_2
XFILLER_47_844 VPWR VGND sg13g2_decap_8
XFILLER_0_14 VPWR VGND sg13g2_decap_8
XFILLER_19_535 VPWR VGND sg13g2_fill_2
XFILLER_34_549 VPWR VGND sg13g2_decap_4
XFILLER_7_962 VPWR VGND sg13g2_decap_8
X_3540_ _1254_ _1255_ _1256_ _1257_ _1258_ VPWR VGND sg13g2_nor4_1
XFILLER_6_472 VPWR VGND sg13g2_fill_2
X_3471_ _1177_ VPWR _1189_ VGND _1185_ _1188_ sg13g2_o21ai_1
X_5210_ net103 VGND VPWR _0667_ videogen.test_lut_thingy.pixel_feeder_inst.row\[21\]\[3\]
+ _0260_ sg13g2_dfrbpq_1
X_5141_ net67 VGND VPWR _0598_ videogen.test_lut_thingy.pixel_feeder_inst.row\[29\]\[1\]
+ _0226_ sg13g2_dfrbpq_1
XFILLER_9_1014 VPWR VGND sg13g2_decap_8
X_5072_ net49 VGND VPWR _0529_ videogen.test_lut_thingy.pixel_feeder_inst.row\[52\]\[0\]
+ _0157_ sg13g2_dfrbpq_1
X_4023_ _1734_ _1687_ _1732_ VPWR VGND sg13g2_nand2_1
XFILLER_37_332 VPWR VGND sg13g2_fill_1
XFILLER_37_376 VPWR VGND sg13g2_decap_8
XFILLER_25_505 VPWR VGND sg13g2_decap_8
XFILLER_25_516 VPWR VGND sg13g2_fill_1
XFILLER_37_387 VPWR VGND sg13g2_fill_2
X_5078__440 VPWR VGND net440 sg13g2_tiehi
X_4925_ net396 VGND VPWR _0386_ videogen.test_lut_thingy.pixel_feeder_inst.row\[12\]\[2\]
+ _0035_ sg13g2_dfrbpq_1
XFILLER_21_711 VPWR VGND sg13g2_fill_2
X_4856_ net92 VGND VPWR _0317_ videogen.test_lut_thingy.pixel_feeder_inst.v_counter\[2\]
+ net657 sg13g2_dfrbpq_2
XFILLER_21_799 VPWR VGND sg13g2_fill_1
X_3807_ _1524_ _0691_ videogen.test_lut_thingy.pixel_feeder_inst.row\[6\]\[0\] VPWR
+ VGND sg13g2_nand2b_1
X_4787_ net699 net743 _0249_ VPWR VGND sg13g2_nor2_1
Xheichips25_bagel_25 VPWR VGND uio_oe[4] sg13g2_tielo
X_3738_ videogen.test_lut_thingy.pixel_feeder_inst.row\[51\]\[1\] net567 _1456_ VPWR
+ VGND sg13g2_nor2_1
X_3669_ videogen.test_lut_thingy.pixel_feeder_inst.row\[55\]\[2\] net571 _1387_ VPWR
+ VGND sg13g2_nor2_1
XFILLER_18_43 VPWR VGND sg13g2_fill_1
XFILLER_29_855 VPWR VGND sg13g2_decap_8
XFILLER_16_505 VPWR VGND sg13g2_decap_8
XFILLER_16_516 VPWR VGND sg13g2_fill_1
XFILLER_18_76 VPWR VGND sg13g2_fill_1
XFILLER_28_365 VPWR VGND sg13g2_decap_4
X_4840__122 VPWR VGND net122 sg13g2_tiehi
XFILLER_43_379 VPWR VGND sg13g2_fill_2
XFILLER_11_210 VPWR VGND sg13g2_fill_2
XFILLER_15_1008 VPWR VGND sg13g2_decap_8
XFILLER_8_726 VPWR VGND sg13g2_decap_8
XFILLER_12_766 VPWR VGND sg13g2_fill_1
XFILLER_7_225 VPWR VGND sg13g2_fill_1
XFILLER_4_943 VPWR VGND sg13g2_decap_8
XFILLER_3_431 VPWR VGND sg13g2_decap_4
XFILLER_3_497 VPWR VGND sg13g2_decap_4
XFILLER_3_486 VPWR VGND sg13g2_fill_2
X_5127__205 VPWR VGND net205 sg13g2_tiehi
XFILLER_39_619 VPWR VGND sg13g2_fill_1
XFILLER_19_343 VPWR VGND sg13g2_decap_4
XFILLER_35_814 VPWR VGND sg13g2_decap_8
XFILLER_35_825 VPWR VGND sg13g2_fill_1
XFILLER_34_335 VPWR VGND sg13g2_decap_8
X_2971_ videogen.test_lut_thingy.pixel_feeder_inst.row\[12\]\[3\] net771 _0818_ _0387_
+ VPWR VGND sg13g2_mux2_1
XFILLER_15_560 VPWR VGND sg13g2_decap_8
XFILLER_34_379 VPWR VGND sg13g2_decap_8
XFILLER_15_593 VPWR VGND sg13g2_fill_1
X_4710_ net680 net724 _0174_ VPWR VGND sg13g2_nor2_1
X_4973__320 VPWR VGND net320 sg13g2_tiehi
X_4641_ net693 net737 _0105_ VPWR VGND sg13g2_nor2_1
X_4572_ _0685_ net555 _0389_ VPWR VGND sg13g2_nor2_1
X_3523_ net597 _1235_ _1240_ _1241_ VPWR VGND sg13g2_nor3_1
X_4817__157 VPWR VGND net157 sg13g2_tiehi
X_3454_ VGND VPWR _1157_ _1169_ _1172_ _1161_ sg13g2_a21oi_1
XFILLER_41_0 VPWR VGND sg13g2_decap_8
X_3385_ _1025_ VPWR _1103_ VGND _1031_ _1032_ sg13g2_o21ai_1
X_5124_ net217 VGND VPWR _0581_ videogen.test_lut_thingy.pixel_feeder_inst.row\[40\]\[0\]
+ _0209_ sg13g2_dfrbpq_1
X_5055_ net117 VGND VPWR _0512_ videogen.test_lut_thingy.pixel_feeder_inst.row\[35\]\[3\]
+ _0140_ sg13g2_dfrbpq_1
X_4006_ _1717_ _1115_ _1685_ VPWR VGND sg13g2_nand2_1
XFILLER_26_814 VPWR VGND sg13g2_fill_2
XFILLER_37_162 VPWR VGND sg13g2_decap_8
XFILLER_38_1019 VPWR VGND sg13g2_decap_8
XFILLER_26_858 VPWR VGND sg13g2_fill_1
XFILLER_40_338 VPWR VGND sg13g2_decap_4
Xclkbuf_3_4__f_clk_regs clknet_0_clk_regs clknet_3_4__leaf_clk_regs VPWR VGND sg13g2_buf_8
X_4908_ net419 VGND VPWR _0369_ red\[6\] net647 sg13g2_dfrbpq_2
XFILLER_21_541 VPWR VGND sg13g2_fill_2
X_4839_ net123 VGND VPWR _0300_ videogen.fancy_shader.video_x\[8\] net640 sg13g2_dfrbpq_2
XFILLER_4_228 VPWR VGND sg13g2_decap_4
XFILLER_20_22 VPWR VGND sg13g2_fill_1
XFILLER_49_917 VPWR VGND sg13g2_decap_8
XFILLER_0_423 VPWR VGND sg13g2_decap_8
XFILLER_1_946 VPWR VGND sg13g2_decap_8
XFILLER_48_416 VPWR VGND sg13g2_decap_8
Xhold31 serialize.shift_reg_b\[5\] VPWR VGND net477 sg13g2_dlygate4sd3_1
Xhold20 serialize.shift_reg_g\[4\] VPWR VGND net466 sg13g2_dlygate4sd3_1
XFILLER_29_663 VPWR VGND sg13g2_fill_1
XFILLER_29_674 VPWR VGND sg13g2_fill_1
XFILLER_17_847 VPWR VGND sg13g2_fill_2
XFILLER_28_173 VPWR VGND sg13g2_fill_1
XFILLER_32_839 VPWR VGND sg13g2_fill_1
XFILLER_31_349 VPWR VGND sg13g2_decap_8
XFILLER_8_567 VPWR VGND sg13g2_decap_4
X_3170_ _0898_ videogen.test_lut_thingy.pixel_feeder_inst.v_counter\[0\] _0923_ VPWR
+ VGND sg13g2_xor2_1
XFILLER_48_950 VPWR VGND sg13g2_decap_8
XFILLER_47_482 VPWR VGND sg13g2_decap_8
XFILLER_35_655 VPWR VGND sg13g2_fill_1
XFILLER_22_305 VPWR VGND sg13g2_fill_2
XFILLER_34_154 VPWR VGND sg13g2_decap_4
XFILLER_16_891 VPWR VGND sg13g2_fill_2
XFILLER_34_187 VPWR VGND sg13g2_fill_2
XFILLER_34_198 VPWR VGND sg13g2_decap_8
X_2954_ videogen.test_lut_thingy.pixel_feeder_inst.row\[15\]\[0\] net802 _0814_ _0403_
+ VPWR VGND sg13g2_mux2_1
X_2885_ _0799_ net793 _0798_ VPWR VGND sg13g2_nand2_1
X_4624_ net709 net754 _0088_ VPWR VGND sg13g2_nor2_1
X_4555_ net670 net714 _0021_ VPWR VGND sg13g2_nor2_1
X_3506_ _0991_ _1218_ _1224_ VPWR VGND sg13g2_and2_1
X_4486_ net760 _2157_ _0621_ VPWR VGND sg13g2_nor2_1
X_3437_ _1155_ _0987_ _1007_ VPWR VGND sg13g2_xnor2_1
X_3368_ _1086_ _1085_ _1083_ VPWR VGND sg13g2_nand2b_1
X_5107_ net285 VGND VPWR _0564_ videogen.test_lut_thingy.pixel_feeder_inst.row\[45\]\[3\]
+ _0192_ sg13g2_dfrbpq_1
X_3299_ net635 videogen.fancy_shader.shader_counter_reg\[7\] _1017_ VPWR VGND sg13g2_and2_1
X_5038_ net197 VGND VPWR _0495_ tmds_blue.dc_balancing_reg\[3\] net648 sg13g2_dfrbpq_2
XFILLER_25_132 VPWR VGND sg13g2_decap_8
XFILLER_41_669 VPWR VGND sg13g2_fill_1
XFILLER_15_88 VPWR VGND sg13g2_decap_8
XFILLER_5_537 VPWR VGND sg13g2_decap_8
Xoutput8 net8 uio_out[2] VPWR VGND sg13g2_buf_1
Xoutput10 net10 uio_out[4] VPWR VGND sg13g2_buf_1
XFILLER_1_743 VPWR VGND sg13g2_decap_8
XFILLER_49_736 VPWR VGND sg13g2_fill_1
XFILLER_29_460 VPWR VGND sg13g2_decap_8
XFILLER_29_471 VPWR VGND sg13g2_fill_2
XFILLER_36_419 VPWR VGND sg13g2_fill_2
XFILLER_44_441 VPWR VGND sg13g2_fill_2
XFILLER_45_986 VPWR VGND sg13g2_decap_8
XFILLER_17_666 VPWR VGND sg13g2_decap_4
XFILLER_17_699 VPWR VGND sg13g2_decap_8
XFILLER_32_603 VPWR VGND sg13g2_decap_8
XFILLER_9_810 VPWR VGND sg13g2_decap_8
XFILLER_13_894 VPWR VGND sg13g2_decap_4
X_2670_ _0727_ _0732_ _0734_ VPWR VGND sg13g2_nor2_2
X_4340_ VGND VPWR _2026_ _2028_ _0413_ _2029_ sg13g2_a21oi_1
XFILLER_28_1007 VPWR VGND sg13g2_decap_8
X_4271_ VGND VPWR _1973_ _1974_ _0373_ _0958_ sg13g2_a21oi_1
X_3222_ net760 _0688_ _0957_ VPWR VGND sg13g2_nor2_2
X_3153_ VPWR _0912_ _0911_ VGND sg13g2_inv_1
XFILLER_27_419 VPWR VGND sg13g2_fill_2
X_3084_ _0670_ net809 net481 _0873_ VPWR VGND sg13g2_and3_1
XFILLER_36_975 VPWR VGND sg13g2_decap_8
XFILLER_22_124 VPWR VGND sg13g2_decap_8
X_3986_ _1038_ _1696_ _1697_ VPWR VGND sg13g2_nor2_1
XFILLER_22_135 VPWR VGND sg13g2_fill_1
X_2937_ videogen.test_lut_thingy.pixel_feeder_inst.row\[32\]\[2\] net776 _0811_ _0426_
+ VPWR VGND sg13g2_mux2_1
XFILLER_31_691 VPWR VGND sg13g2_decap_4
X_4607_ net689 net733 _0071_ VPWR VGND sg13g2_nor2_1
X_2868_ net761 videogen.test_lut_thingy.pixel_feeder_inst.row\[56\]\[3\] _0795_ _0479_
+ VPWR VGND sg13g2_mux2_1
X_2799_ videogen.test_lut_thingy.pixel_feeder_inst.row\[4\]\[2\] net780 _0781_ _0543_
+ VPWR VGND sg13g2_mux2_1
X_4538_ net454 net809 net664 _0668_ VPWR VGND sg13g2_a21o_1
X_4469_ _2144_ _2145_ _0614_ VPWR VGND sg13g2_nor2_1
Xfanout800 net804 net800 VPWR VGND sg13g2_buf_1
Xfanout811 rst_n net811 VPWR VGND sg13g2_buf_8
XFILLER_45_205 VPWR VGND sg13g2_decap_8
X_5158__315 VPWR VGND net315 sg13g2_tiehi
XFILLER_26_452 VPWR VGND sg13g2_fill_2
XFILLER_27_975 VPWR VGND sg13g2_decap_8
XFILLER_42_934 VPWR VGND sg13g2_decap_8
XFILLER_41_433 VPWR VGND sg13g2_decap_4
XFILLER_13_124 VPWR VGND sg13g2_fill_1
XFILLER_26_76 VPWR VGND sg13g2_fill_1
XFILLER_14_658 VPWR VGND sg13g2_decap_8
XFILLER_13_179 VPWR VGND sg13g2_fill_1
XFILLER_42_75 VPWR VGND sg13g2_decap_8
XFILLER_21_190 VPWR VGND sg13g2_decap_8
XFILLER_6_835 VPWR VGND sg13g2_fill_2
XFILLER_3_25 VPWR VGND sg13g2_decap_8
XFILLER_1_540 VPWR VGND sg13g2_decap_8
XFILLER_49_544 VPWR VGND sg13g2_decap_8
X_4857__90 VPWR VGND net90 sg13g2_tiehi
X_4872__60 VPWR VGND net60 sg13g2_tiehi
XFILLER_18_931 VPWR VGND sg13g2_decap_8
XFILLER_44_293 VPWR VGND sg13g2_fill_1
X_3840_ _1531_ VPWR _1557_ VGND videogen.test_lut_thingy.pixel_feeder_inst.row\[53\]\[0\]
+ net557 sg13g2_o21ai_1
XFILLER_32_455 VPWR VGND sg13g2_decap_4
XFILLER_32_499 VPWR VGND sg13g2_decap_8
X_3771_ videogen.test_lut_thingy.pixel_feeder_inst.row\[30\]\[1\] net588 _1489_ VPWR
+ VGND sg13g2_nor2_1
X_2722_ videogen.test_lut_thingy.pixel_feeder_inst.row\[29\]\[1\] net787 _0759_ _0598_
+ VPWR VGND sg13g2_mux2_1
XFILLER_9_662 VPWR VGND sg13g2_decap_4
X_2653_ _0706_ _0724_ _0725_ VPWR VGND sg13g2_and2_1
X_4323_ _2012_ VPWR _2013_ VGND tmds_green.dc_balancing_reg\[1\] _1991_ sg13g2_o21ai_1
X_4254_ VPWR _1958_ _1957_ VGND sg13g2_inv_1
X_3205_ videogen.fancy_shader.shader_counter_reg\[4\] _0945_ _0946_ VPWR VGND sg13g2_nor2_1
XFILLER_28_706 VPWR VGND sg13g2_decap_4
X_4185_ _1888_ _1890_ _1891_ VPWR VGND sg13g2_and2_1
X_3136_ videogen.test_lut_thingy.pixel_feeder_inst.v_pix\[0\] _0899_ _0901_ VPWR VGND
+ sg13g2_and2_1
XFILLER_27_205 VPWR VGND sg13g2_fill_2
XFILLER_28_739 VPWR VGND sg13g2_fill_1
X_3067_ VGND VPWR _0855_ _0868_ net20 _0857_ sg13g2_a21oi_1
XFILLER_42_208 VPWR VGND sg13g2_fill_2
XFILLER_24_956 VPWR VGND sg13g2_decap_8
XFILLER_11_606 VPWR VGND sg13g2_decap_4
XFILLER_10_105 VPWR VGND sg13g2_fill_1
X_3969_ _1680_ _1143_ _1676_ VPWR VGND sg13g2_nand2_1
X_5639_ videogen.mem_row net11 VPWR VGND sg13g2_buf_8
XFILLER_2_348 VPWR VGND sg13g2_decap_4
Xfanout630 videogen.test_lut_thingy.pixel_feeder_inst.h_pix\[1\] net630 VPWR VGND
+ sg13g2_buf_8
Xfanout641 net656 net641 VPWR VGND sg13g2_buf_1
Xfanout685 net686 net685 VPWR VGND sg13g2_buf_8
Xfanout652 net654 net652 VPWR VGND sg13g2_buf_8
Xfanout663 net667 net663 VPWR VGND sg13g2_buf_8
Xfanout674 net679 net674 VPWR VGND sg13g2_buf_8
XFILLER_46_514 VPWR VGND sg13g2_decap_8
Xfanout696 net700 net696 VPWR VGND sg13g2_buf_8
XFILLER_18_205 VPWR VGND sg13g2_decap_8
XFILLER_18_238 VPWR VGND sg13g2_fill_2
XFILLER_42_720 VPWR VGND sg13g2_fill_2
XFILLER_15_945 VPWR VGND sg13g2_decap_8
XFILLER_41_230 VPWR VGND sg13g2_fill_2
XFILLER_14_488 VPWR VGND sg13g2_fill_1
X_5054__132 VPWR VGND net132 sg13g2_tiehi
XFILLER_6_654 VPWR VGND sg13g2_decap_4
XFILLER_2_893 VPWR VGND sg13g2_decap_8
XFILLER_49_352 VPWR VGND sg13g2_decap_8
X_4941_ net367 VGND VPWR _0402_ videogen.test_lut_thingy.pixel_feeder_inst.row\[14\]\[3\]
+ _0048_ sg13g2_dfrbpq_1
XFILLER_17_260 VPWR VGND sg13g2_fill_2
X_4872_ net60 VGND VPWR _0333_ videogen.fancy_shader.shader_counter_reg\[2\] net644
+ sg13g2_dfrbpq_2
XFILLER_32_241 VPWR VGND sg13g2_decap_8
X_3823_ _1538_ _1539_ net598 _1540_ VPWR VGND sg13g2_mux2_1
XFILLER_21_926 VPWR VGND sg13g2_decap_8
X_3754_ net618 VPWR _1472_ VGND videogen.test_lut_thingy.pixel_feeder_inst.row\[26\]\[1\]
+ net587 sg13g2_o21ai_1
X_3685_ net600 VPWR _1403_ VGND videogen.test_lut_thingy.pixel_feeder_inst.row\[37\]\[2\]
+ net556 sg13g2_o21ai_1
X_2705_ _0744_ _0752_ _0753_ VPWR VGND sg13g2_nor2_2
X_2636_ _0681_ net636 videogen.fancy_shader.video_x\[3\] videogen.fancy_shader.video_x\[2\]
+ _0708_ VPWR VGND sg13g2_nor4_1
XFILLER_0_819 VPWR VGND sg13g2_decap_8
X_4306_ VGND VPWR net610 _1999_ _0409_ net759 sg13g2_a21oi_1
X_4983__300 VPWR VGND net300 sg13g2_tiehi
X_4237_ _1941_ _1903_ _1942_ VPWR VGND sg13g2_xor2_1
X_4168_ _0370_ _1874_ _0366_ VPWR VGND sg13g2_nand2b_1
X_3119_ net635 _0838_ _0888_ VPWR VGND sg13g2_nor2_1
X_4099_ _1803_ _1809_ _1810_ VPWR VGND sg13g2_and2_1
XFILLER_16_709 VPWR VGND sg13g2_fill_2
X_5120__233 VPWR VGND net233 sg13g2_tiehi
XFILLER_12_937 VPWR VGND sg13g2_decap_8
XFILLER_23_252 VPWR VGND sg13g2_decap_8
XFILLER_23_263 VPWR VGND sg13g2_fill_1
XFILLER_24_797 VPWR VGND sg13g2_decap_8
XFILLER_8_908 VPWR VGND sg13g2_decap_8
XFILLER_3_613 VPWR VGND sg13g2_decap_4
XFILLER_47_823 VPWR VGND sg13g2_decap_8
XFILLER_48_63 VPWR VGND sg13g2_decap_4
XFILLER_46_377 VPWR VGND sg13g2_decap_8
XFILLER_34_528 VPWR VGND sg13g2_decap_8
XFILLER_9_13 VPWR VGND sg13g2_fill_2
XFILLER_42_594 VPWR VGND sg13g2_fill_1
XFILLER_30_767 VPWR VGND sg13g2_fill_1
XFILLER_31_1014 VPWR VGND sg13g2_decap_8
XFILLER_7_941 VPWR VGND sg13g2_decap_8
XFILLER_11_992 VPWR VGND sg13g2_decap_8
X_3470_ _1095_ _1187_ _1188_ VPWR VGND sg13g2_nor2_1
XFILLER_6_484 VPWR VGND sg13g2_fill_1
X_5140_ net75 VGND VPWR _0597_ videogen.test_lut_thingy.pixel_feeder_inst.row\[29\]\[0\]
+ _0225_ sg13g2_dfrbpq_1
XFILLER_2_690 VPWR VGND sg13g2_fill_2
X_5071_ net53 VGND VPWR _0528_ videogen.test_lut_thingy.pixel_feeder_inst.row\[53\]\[3\]
+ _0156_ sg13g2_dfrbpq_1
XFILLER_38_823 VPWR VGND sg13g2_fill_1
X_4022_ _1733_ _1725_ _1731_ VPWR VGND sg13g2_nand2_1
XFILLER_49_182 VPWR VGND sg13g2_fill_1
XFILLER_37_344 VPWR VGND sg13g2_fill_1
Xclkbuf_3_3__f_clk_regs clknet_0_clk_regs clknet_3_3__leaf_clk_regs VPWR VGND sg13g2_buf_8
X_4924_ net398 VGND VPWR _0385_ videogen.test_lut_thingy.pixel_feeder_inst.row\[12\]\[1\]
+ _0034_ sg13g2_dfrbpq_1
XFILLER_21_701 VPWR VGND sg13g2_fill_2
XFILLER_21_723 VPWR VGND sg13g2_decap_8
X_4855_ net94 VGND VPWR _0316_ videogen.test_lut_thingy.pixel_feeder_inst.v_counter\[1\]
+ net638 sg13g2_dfrbpq_1
XFILLER_20_200 VPWR VGND sg13g2_fill_2
XFILLER_21_734 VPWR VGND sg13g2_fill_2
X_4786_ net683 net727 _0248_ VPWR VGND sg13g2_nor2_1
X_3806_ VPWR _0359_ _1523_ VGND sg13g2_inv_1
X_3737_ videogen.test_lut_thingy.pixel_feeder_inst.row\[50\]\[1\] net587 _1455_ VPWR
+ VGND sg13g2_nor2_1
X_3668_ net601 VPWR _1386_ VGND videogen.test_lut_thingy.pixel_feeder_inst.row\[52\]\[2\]
+ net580 sg13g2_o21ai_1
Xheichips25_bagel_26 VPWR VGND uio_oe[5] sg13g2_tielo
X_3599_ net598 VPWR _1317_ VGND videogen.test_lut_thingy.pixel_feeder_inst.row\[3\]\[3\]
+ net572 sg13g2_o21ai_1
X_2619_ net633 net629 _0691_ VPWR VGND sg13g2_nor2b_2
XFILLER_0_605 VPWR VGND sg13g2_decap_8
XFILLER_0_638 VPWR VGND sg13g2_fill_2
XFILLER_47_119 VPWR VGND sg13g2_decap_8
XFILLER_44_815 VPWR VGND sg13g2_decap_8
XFILLER_44_826 VPWR VGND sg13g2_fill_1
XFILLER_43_369 VPWR VGND sg13g2_decap_4
XFILLER_11_277 VPWR VGND sg13g2_fill_2
X_5051__146 VPWR VGND net146 sg13g2_tiehi
XFILLER_4_922 VPWR VGND sg13g2_decap_8
XFILLER_4_999 VPWR VGND sg13g2_decap_8
XFILLER_1_0 VPWR VGND sg13g2_decap_8
XFILLER_38_119 VPWR VGND sg13g2_fill_1
X_2970_ _0773_ _0803_ _0818_ VPWR VGND sg13g2_nor2_2
X_4640_ net699 net743 _0104_ VPWR VGND sg13g2_nor2_1
X_4571_ net709 net754 _0036_ VPWR VGND sg13g2_nor2_1
X_3522_ _1236_ _1237_ _1238_ _1239_ _1240_ VPWR VGND sg13g2_nor4_1
XFILLER_6_292 VPWR VGND sg13g2_decap_8
X_3453_ _1171_ _0991_ _1170_ VPWR VGND sg13g2_nand2_1
X_3384_ _1102_ _1055_ _1101_ VPWR VGND sg13g2_xnor2_1
X_5123_ net221 VGND VPWR _0580_ videogen.test_lut_thingy.pixel_feeder_inst.row\[41\]\[3\]
+ _0208_ sg13g2_dfrbpq_1
XFILLER_34_0 VPWR VGND sg13g2_decap_8
XFILLER_29_108 VPWR VGND sg13g2_fill_2
X_5054_ net132 VGND VPWR _0511_ videogen.test_lut_thingy.pixel_feeder_inst.row\[35\]\[2\]
+ _0139_ sg13g2_dfrbpq_1
X_4005_ _1716_ _1713_ _1714_ VPWR VGND sg13g2_nand2_1
XFILLER_25_336 VPWR VGND sg13g2_decap_4
XFILLER_40_306 VPWR VGND sg13g2_decap_8
X_4907_ net420 VGND VPWR _0368_ red\[4\] net647 sg13g2_dfrbpq_2
XFILLER_34_892 VPWR VGND sg13g2_decap_8
X_4838_ net124 VGND VPWR _0299_ videogen.fancy_shader.video_x\[7\] net640 sg13g2_dfrbpq_2
XFILLER_21_575 VPWR VGND sg13g2_decap_4
X_4769_ net683 net727 _0233_ VPWR VGND sg13g2_nor2_1
XFILLER_4_207 VPWR VGND sg13g2_decap_8
XFILLER_0_402 VPWR VGND sg13g2_decap_8
XFILLER_1_925 VPWR VGND sg13g2_decap_8
Xhold21 serialize.shift_reg_g\[6\] VPWR VGND net467 sg13g2_dlygate4sd3_1
Xhold10 serialize.shift_reg_r\[6\] VPWR VGND net456 sg13g2_dlygate4sd3_1
Xhold32 serialize.shift_reg_b\[7\] VPWR VGND net478 sg13g2_dlygate4sd3_1
XFILLER_0_479 VPWR VGND sg13g2_decap_8
XFILLER_21_1024 VPWR VGND sg13g2_decap_4
XFILLER_16_303 VPWR VGND sg13g2_fill_2
XFILLER_16_314 VPWR VGND sg13g2_fill_2
XFILLER_17_826 VPWR VGND sg13g2_decap_8
XFILLER_43_177 VPWR VGND sg13g2_fill_1
X_5065__77 VPWR VGND net77 sg13g2_tiehi
XFILLER_25_870 VPWR VGND sg13g2_decap_8
XFILLER_25_881 VPWR VGND sg13g2_decap_8
XFILLER_31_328 VPWR VGND sg13g2_decap_8
XFILLER_40_862 VPWR VGND sg13g2_decap_8
XFILLER_40_884 VPWR VGND sg13g2_fill_1
XFILLER_6_1018 VPWR VGND sg13g2_decap_8
XFILLER_0_980 VPWR VGND sg13g2_decap_8
XFILLER_47_461 VPWR VGND sg13g2_decap_8
XFILLER_34_122 VPWR VGND sg13g2_decap_8
X_2953_ videogen.test_lut_thingy.pixel_feeder_inst.row\[15\]\[1\] net792 _0814_ _0404_
+ VPWR VGND sg13g2_mux2_1
XFILLER_31_851 VPWR VGND sg13g2_decap_8
X_2884_ videogen.test_lut_thingy.pixel_feeder_inst.row\[61\]\[2\] net779 _0798_ _0466_
+ VPWR VGND sg13g2_mux2_1
X_4623_ net709 net754 _0087_ VPWR VGND sg13g2_nor2_1
X_4554_ net702 net746 _0020_ VPWR VGND sg13g2_nor2_1
X_3505_ _1157_ _1222_ _1223_ VPWR VGND sg13g2_nor2_1
X_4485_ _2156_ VPWR _2157_ VGND _0688_ _2147_ sg13g2_o21ai_1
X_3436_ _1154_ _1136_ _1152_ VPWR VGND sg13g2_xnor2_1
X_4830__133 VPWR VGND net133 sg13g2_tiehi
X_3367_ _1059_ _1044_ _1085_ VPWR VGND sg13g2_xor2_1
X_5106_ net289 VGND VPWR _0563_ videogen.test_lut_thingy.pixel_feeder_inst.row\[45\]\[2\]
+ _0191_ sg13g2_dfrbpq_1
X_5037_ net198 VGND VPWR _0494_ tmds_blue.dc_balancing_reg\[2\] net648 sg13g2_dfrbpq_2
X_3298_ VPWR _1016_ _1015_ VGND sg13g2_inv_1
XFILLER_38_494 VPWR VGND sg13g2_fill_1
X_5006__254 VPWR VGND net254 sg13g2_tiehi
XFILLER_26_645 VPWR VGND sg13g2_fill_1
XFILLER_25_155 VPWR VGND sg13g2_fill_2
XFILLER_15_34 VPWR VGND sg13g2_decap_4
XFILLER_31_11 VPWR VGND sg13g2_decap_8
X_4991__284 VPWR VGND net284 sg13g2_tiehi
Xoutput9 net9 uio_out[3] VPWR VGND sg13g2_buf_1
Xoutput11 net11 uio_out[6] VPWR VGND sg13g2_buf_1
XFILLER_0_243 VPWR VGND sg13g2_decap_8
XFILLER_49_759 VPWR VGND sg13g2_fill_1
XFILLER_49_748 VPWR VGND sg13g2_decap_8
XFILLER_49_726 VPWR VGND sg13g2_fill_1
XFILLER_0_276 VPWR VGND sg13g2_fill_2
XFILLER_1_799 VPWR VGND sg13g2_decap_8
XFILLER_48_236 VPWR VGND sg13g2_fill_1
XFILLER_45_965 VPWR VGND sg13g2_decap_8
XFILLER_16_122 VPWR VGND sg13g2_decap_8
XFILLER_17_634 VPWR VGND sg13g2_decap_4
XFILLER_44_464 VPWR VGND sg13g2_fill_1
XFILLER_16_133 VPWR VGND sg13g2_fill_2
XFILLER_16_177 VPWR VGND sg13g2_fill_1
XFILLER_16_188 VPWR VGND sg13g2_decap_8
XFILLER_31_114 VPWR VGND sg13g2_decap_8
XFILLER_31_125 VPWR VGND sg13g2_decap_8
XFILLER_32_648 VPWR VGND sg13g2_decap_4
XFILLER_12_361 VPWR VGND sg13g2_decap_8
XFILLER_4_560 VPWR VGND sg13g2_fill_2
X_4270_ _1974_ _1968_ _1946_ _1961_ _1947_ VPWR VGND sg13g2_a22oi_1
X_3221_ net551 _0956_ _0340_ VPWR VGND sg13g2_nor2_1
X_3152_ net552 _0910_ videogen.test_lut_thingy.pixel_feeder_inst.h_counter\[3\] _0911_
+ VPWR VGND sg13g2_nand3_1
X_3083_ net483 net452 _0873_ VPWR VGND sg13g2_nor2_1
XFILLER_36_954 VPWR VGND sg13g2_decap_8
XFILLER_23_637 VPWR VGND sg13g2_fill_2
X_3985_ _1696_ _1083_ _1693_ VPWR VGND sg13g2_nand2_2
X_2936_ videogen.test_lut_thingy.pixel_feeder_inst.row\[32\]\[3\] net766 _0811_ _0427_
+ VPWR VGND sg13g2_mux2_1
X_2867_ _0795_ _0747_ VPWR VGND _0740_ sg13g2_nand2b_2
XFILLER_30_180 VPWR VGND sg13g2_decap_8
X_4606_ net689 net733 _0070_ VPWR VGND sg13g2_nor2_1
X_2798_ videogen.test_lut_thingy.pixel_feeder_inst.row\[4\]\[3\] net769 _0781_ _0544_
+ VPWR VGND sg13g2_mux2_1
XFILLER_2_519 VPWR VGND sg13g2_decap_4
X_4537_ net758 clockdiv.q0 net447 _0663_ VPWR VGND sg13g2_nor3_1
X_4468_ net810 VPWR _2145_ VGND net609 hsync sg13g2_o21ai_1
X_3419_ VGND VPWR _1137_ _1135_ _1134_ sg13g2_or2_1
Xfanout801 net804 net801 VPWR VGND sg13g2_buf_8
X_4399_ blue\[1\] blue\[7\] net606 _2080_ VPWR VGND blue\[6\] sg13g2_nand4_1
XFILLER_26_11 VPWR VGND sg13g2_fill_1
XFILLER_26_33 VPWR VGND sg13g2_decap_8
XFILLER_27_954 VPWR VGND sg13g2_decap_8
XFILLER_42_913 VPWR VGND sg13g2_decap_8
XFILLER_26_66 VPWR VGND sg13g2_fill_2
XFILLER_26_88 VPWR VGND sg13g2_decap_4
X_5093__341 VPWR VGND net341 sg13g2_tiehi
XFILLER_5_302 VPWR VGND sg13g2_decap_8
XFILLER_49_523 VPWR VGND sg13g2_decap_8
XFILLER_1_596 VPWR VGND sg13g2_fill_2
XFILLER_17_464 VPWR VGND sg13g2_decap_8
XFILLER_18_987 VPWR VGND sg13g2_decap_8
XFILLER_17_475 VPWR VGND sg13g2_fill_1
XFILLER_33_979 VPWR VGND sg13g2_decap_8
X_3770_ net618 VPWR _1488_ VGND videogen.test_lut_thingy.pixel_feeder_inst.row\[29\]\[1\]
+ net559 sg13g2_o21ai_1
XFILLER_32_478 VPWR VGND sg13g2_fill_2
XFILLER_34_1012 VPWR VGND sg13g2_decap_8
X_2721_ videogen.test_lut_thingy.pixel_feeder_inst.row\[29\]\[2\] net776 _0759_ _0599_
+ VPWR VGND sg13g2_mux2_1
XFILLER_8_184 VPWR VGND sg13g2_decap_4
X_2652_ _0724_ net617 _0715_ VPWR VGND sg13g2_xnor2_1
X_4322_ _2012_ _0683_ green\[7\] VPWR VGND sg13g2_nand2_1
X_4253_ VGND VPWR _0687_ _1912_ _1957_ _1956_ sg13g2_a21oi_1
X_3204_ _0940_ _0944_ _0945_ _0334_ VPWR VGND sg13g2_nor3_1
XFILLER_41_1027 VPWR VGND sg13g2_fill_2
X_4184_ VGND VPWR _1882_ _1884_ _1890_ _1889_ sg13g2_a21oi_1
X_3135_ _0895_ VPWR _0900_ VGND videogen.test_lut_thingy.pixel_feeder_inst.v_pix\[0\]
+ _0899_ sg13g2_o21ai_1
X_3066_ _0868_ _0866_ _0867_ VPWR VGND sg13g2_nand2_1
XFILLER_23_401 VPWR VGND sg13g2_decap_4
XFILLER_24_935 VPWR VGND sg13g2_decap_8
XFILLER_35_272 VPWR VGND sg13g2_decap_4
XFILLER_11_618 VPWR VGND sg13g2_fill_2
X_3968_ _1679_ _1142_ _1676_ VPWR VGND sg13g2_nand2b_1
XFILLER_23_489 VPWR VGND sg13g2_fill_2
X_2919_ videogen.test_lut_thingy.pixel_feeder_inst.row\[10\]\[0\] net803 _0807_ _0440_
+ VPWR VGND sg13g2_mux2_1
X_3899_ _1594_ _1605_ _1613_ VPWR VGND sg13g2_and2_1
XFILLER_3_839 VPWR VGND sg13g2_decap_8
Xfanout642 net645 net642 VPWR VGND sg13g2_buf_8
Xfanout631 net634 net631 VPWR VGND sg13g2_buf_8
Xfanout620 videogen.test_lut_thingy.pixel_feeder_inst.h_pix\[3\] net620 VPWR VGND
+ sg13g2_buf_8
Xfanout664 net667 net664 VPWR VGND sg13g2_buf_8
Xfanout675 net676 net675 VPWR VGND sg13g2_buf_8
Xfanout653 net654 net653 VPWR VGND sg13g2_buf_8
X_5047__162 VPWR VGND net162 sg13g2_tiehi
Xfanout697 net698 net697 VPWR VGND sg13g2_buf_8
Xfanout686 net692 net686 VPWR VGND sg13g2_buf_2
XFILLER_14_456 VPWR VGND sg13g2_decap_8
XFILLER_26_294 VPWR VGND sg13g2_decap_4
XFILLER_41_253 VPWR VGND sg13g2_fill_2
XFILLER_6_633 VPWR VGND sg13g2_decap_8
XFILLER_2_872 VPWR VGND sg13g2_decap_8
XFILLER_49_397 VPWR VGND sg13g2_decap_8
XFILLER_37_537 VPWR VGND sg13g2_decap_8
Xclkbuf_3_2__f_clk_regs clknet_0_clk_regs clknet_3_2__leaf_clk_regs VPWR VGND sg13g2_buf_8
X_4940_ net369 VGND VPWR _0401_ videogen.test_lut_thingy.pixel_feeder_inst.row\[14\]\[2\]
+ _0047_ sg13g2_dfrbpq_1
X_4871_ net62 VGND VPWR _0332_ videogen.fancy_shader.shader_counter_reg\[1\] net655
+ sg13g2_dfrbpq_2
X_3822_ net630 videogen.test_lut_thingy.pixel_feeder_inst.row\[8\]\[0\] videogen.test_lut_thingy.pixel_feeder_inst.row\[10\]\[0\]
+ videogen.test_lut_thingy.pixel_feeder_inst.row\[9\]\[0\] videogen.test_lut_thingy.pixel_feeder_inst.row\[11\]\[0\]
+ net634 _1539_ VPWR VGND sg13g2_mux4_1
X_3753_ _1448_ _1470_ _1471_ VPWR VGND sg13g2_nor2_2
X_3684_ _1398_ _1399_ _1400_ _1401_ _1402_ VPWR VGND sg13g2_nor4_1
X_2704_ _0725_ _0746_ _0721_ _0752_ VPWR VGND sg13g2_nand3_1
X_2635_ _0707_ _0706_ VPWR VGND sg13g2_inv_2
X_4305_ _1987_ _1881_ _1999_ VPWR VGND sg13g2_xor2_1
XFILLER_4_80 VPWR VGND sg13g2_decap_8
X_4236_ _1941_ _1929_ _1939_ VPWR VGND sg13g2_xnor2_1
X_4167_ _1577_ _1866_ net809 _1874_ VPWR VGND sg13g2_nand3_1
X_3118_ net635 _0838_ _0887_ VPWR VGND sg13g2_and2_1
X_4098_ VPWR _1809_ _1808_ VGND sg13g2_inv_1
X_3049_ _0698_ _0854_ _0855_ VPWR VGND sg13g2_nor2_2
XFILLER_36_570 VPWR VGND sg13g2_fill_2
X_5194__368 VPWR VGND net368 sg13g2_tiehi
XFILLER_24_776 VPWR VGND sg13g2_decap_8
XFILLER_20_982 VPWR VGND sg13g2_decap_8
XFILLER_3_669 VPWR VGND sg13g2_fill_1
XFILLER_3_647 VPWR VGND sg13g2_decap_8
XFILLER_3_4 VPWR VGND sg13g2_decap_8
XFILLER_48_42 VPWR VGND sg13g2_decap_8
XFILLER_47_802 VPWR VGND sg13g2_decap_8
XFILLER_19_515 VPWR VGND sg13g2_fill_1
XFILLER_19_526 VPWR VGND sg13g2_decap_4
XFILLER_47_879 VPWR VGND sg13g2_decap_8
XFILLER_0_49 VPWR VGND sg13g2_fill_2
X_5199__279 VPWR VGND net279 sg13g2_tiehi
XFILLER_27_581 VPWR VGND sg13g2_fill_1
XFILLER_42_562 VPWR VGND sg13g2_fill_2
XFILLER_15_776 VPWR VGND sg13g2_decap_4
XFILLER_14_286 VPWR VGND sg13g2_decap_8
XFILLER_7_920 VPWR VGND sg13g2_decap_8
XFILLER_11_971 VPWR VGND sg13g2_decap_8
XFILLER_7_997 VPWR VGND sg13g2_decap_8
X_5070_ net57 VGND VPWR _0527_ videogen.test_lut_thingy.pixel_feeder_inst.row\[53\]\[2\]
+ _0155_ sg13g2_dfrbpq_1
X_4021_ _1725_ _1731_ _1732_ VPWR VGND sg13g2_and2_1
XFILLER_49_194 VPWR VGND sg13g2_decap_8
X_4923_ net400 VGND VPWR _0384_ videogen.test_lut_thingy.pixel_feeder_inst.row\[12\]\[0\]
+ _0033_ sg13g2_dfrbpq_1
XFILLER_18_592 VPWR VGND sg13g2_decap_4
X_4854_ net96 VGND VPWR _0315_ videogen.test_lut_thingy.pixel_feeder_inst.v_counter\[0\]
+ net638 sg13g2_dfrbpq_2
XFILLER_21_746 VPWR VGND sg13g2_decap_8
X_4785_ net684 net728 _0247_ VPWR VGND sg13g2_nor2_1
X_3805_ _1522_ _1230_ net758 _1523_ VPWR VGND sg13g2_a21o_1
X_3736_ net596 VPWR _1454_ VGND videogen.test_lut_thingy.pixel_feeder_inst.row\[48\]\[1\]
+ net577 sg13g2_o21ai_1
X_3667_ net622 _1379_ _1384_ _1385_ VPWR VGND sg13g2_nor3_1
Xheichips25_bagel_27 VPWR VGND uio_oe[6] sg13g2_tielo
X_3598_ _1312_ _1313_ _1314_ _1315_ _1316_ VPWR VGND sg13g2_nor4_1
X_4219_ VGND VPWR _1924_ _1925_ _1923_ net544 sg13g2_a21oi_2
X_5199_ net279 VGND VPWR _0656_ serialize.shift_reg_r\[1\] clknet_3_5__leaf_clk_regs
+ sg13g2_dfrbpq_1
XFILLER_18_67 VPWR VGND sg13g2_decap_8
XFILLER_28_334 VPWR VGND sg13g2_decap_8
XFILLER_28_345 VPWR VGND sg13g2_fill_2
X_4922__402 VPWR VGND net402 sg13g2_tiehi
X_5044__187 VPWR VGND net187 sg13g2_tiehi
XFILLER_18_89 VPWR VGND sg13g2_decap_8
XFILLER_28_389 VPWR VGND sg13g2_decap_4
XFILLER_11_212 VPWR VGND sg13g2_fill_1
XFILLER_11_223 VPWR VGND sg13g2_fill_1
XFILLER_24_584 VPWR VGND sg13g2_fill_1
XFILLER_8_717 VPWR VGND sg13g2_fill_1
XFILLER_7_238 VPWR VGND sg13g2_fill_1
XFILLER_7_216 VPWR VGND sg13g2_decap_8
XFILLER_7_249 VPWR VGND sg13g2_fill_2
XFILLER_4_901 VPWR VGND sg13g2_decap_8
X_5016__234 VPWR VGND net234 sg13g2_tiehi
X_5131__160 VPWR VGND net160 sg13g2_tiehi
XFILLER_4_978 VPWR VGND sg13g2_decap_8
XFILLER_3_488 VPWR VGND sg13g2_fill_1
XFILLER_47_610 VPWR VGND sg13g2_decap_4
XFILLER_47_654 VPWR VGND sg13g2_fill_1
XFILLER_46_142 VPWR VGND sg13g2_decap_8
XFILLER_46_164 VPWR VGND sg13g2_fill_1
XFILLER_19_389 VPWR VGND sg13g2_fill_2
XFILLER_42_381 VPWR VGND sg13g2_fill_2
X_5173__227 VPWR VGND net227 sg13g2_tiehi
XFILLER_15_584 VPWR VGND sg13g2_decap_8
X_4570_ net709 net754 _0035_ VPWR VGND sg13g2_nor2_1
X_3521_ videogen.test_lut_thingy.pixel_feeder_inst.row\[63\]\[3\] net570 _1239_ VPWR
+ VGND sg13g2_nor2_1
XFILLER_7_783 VPWR VGND sg13g2_fill_2
XFILLER_6_271 VPWR VGND sg13g2_decap_8
X_3452_ _1154_ VPWR _1170_ VGND _1162_ _1169_ sg13g2_o21ai_1
X_3383_ _1048_ VPWR _1101_ VGND _1054_ _1056_ sg13g2_o21ai_1
X_5122_ net225 VGND VPWR _0579_ videogen.test_lut_thingy.pixel_feeder_inst.row\[41\]\[2\]
+ _0207_ sg13g2_dfrbpq_1
XFILLER_27_0 VPWR VGND sg13g2_decap_4
XFILLER_38_632 VPWR VGND sg13g2_decap_4
XFILLER_38_610 VPWR VGND sg13g2_decap_8
X_5053_ net136 VGND VPWR _0510_ videogen.test_lut_thingy.pixel_feeder_inst.row\[35\]\[1\]
+ _0138_ sg13g2_dfrbpq_1
X_4004_ _1713_ _1714_ _1715_ VPWR VGND sg13g2_and2_1
XFILLER_26_816 VPWR VGND sg13g2_fill_1
XFILLER_26_849 VPWR VGND sg13g2_fill_1
X_4906_ net421 VGND VPWR _0367_ red\[0\] net650 sg13g2_dfrbpq_2
X_4837_ net125 VGND VPWR _0298_ videogen.fancy_shader.video_x\[6\] net640 sg13g2_dfrbpq_2
X_4768_ net674 net718 _0232_ VPWR VGND sg13g2_nor2_1
X_3719_ net621 VPWR _1437_ VGND videogen.test_lut_thingy.pixel_feeder_inst.row\[44\]\[1\]
+ net575 sg13g2_o21ai_1
XFILLER_20_13 VPWR VGND sg13g2_decap_8
X_4699_ net682 net726 _0163_ VPWR VGND sg13g2_nor2_1
XFILLER_1_904 VPWR VGND sg13g2_decap_8
Xhold22 serialize.shift_reg_b\[2\] VPWR VGND net468 sg13g2_dlygate4sd3_1
Xhold11 serialize.shift_reg_g\[9\] VPWR VGND net457 sg13g2_dlygate4sd3_1
XFILLER_0_458 VPWR VGND sg13g2_decap_8
Xhold33 serialize.shift_reg_b\[4\] VPWR VGND net479 sg13g2_dlygate4sd3_1
XFILLER_21_1003 VPWR VGND sg13g2_decap_8
XFILLER_28_120 VPWR VGND sg13g2_fill_1
XFILLER_17_816 VPWR VGND sg13g2_fill_1
XFILLER_43_134 VPWR VGND sg13g2_fill_2
XFILLER_16_348 VPWR VGND sg13g2_fill_2
XFILLER_17_849 VPWR VGND sg13g2_fill_1
XFILLER_8_525 VPWR VGND sg13g2_decap_8
XFILLER_12_587 VPWR VGND sg13g2_decap_8
XFILLER_6_15 VPWR VGND sg13g2_fill_1
XFILLER_4_753 VPWR VGND sg13g2_fill_2
X_4933__383 VPWR VGND net383 sg13g2_tiehi
XFILLER_3_285 VPWR VGND sg13g2_decap_4
XFILLER_39_418 VPWR VGND sg13g2_fill_2
XFILLER_48_985 VPWR VGND sg13g2_decap_8
XFILLER_35_624 VPWR VGND sg13g2_decap_8
XFILLER_35_646 VPWR VGND sg13g2_fill_2
XFILLER_37_1010 VPWR VGND sg13g2_decap_8
X_2952_ videogen.test_lut_thingy.pixel_feeder_inst.row\[15\]\[2\] net780 _0814_ _0405_
+ VPWR VGND sg13g2_mux2_1
XFILLER_34_189 VPWR VGND sg13g2_fill_1
X_2883_ videogen.test_lut_thingy.pixel_feeder_inst.row\[61\]\[3\] net768 _0798_ _0467_
+ VPWR VGND sg13g2_mux2_1
XFILLER_31_885 VPWR VGND sg13g2_fill_1
X_4622_ net704 net748 _0086_ VPWR VGND sg13g2_nor2_1
XFILLER_30_384 VPWR VGND sg13g2_fill_2
X_4553_ net702 net746 _0019_ VPWR VGND sg13g2_nor2_1
X_3504_ VGND VPWR _0992_ _1214_ _1222_ _1218_ sg13g2_a21oi_1
X_4484_ _2156_ _0688_ _2155_ VPWR VGND sg13g2_nand2_1
X_3435_ VPWR VGND _1151_ _1137_ _1149_ _1140_ _1153_ _1141_ sg13g2_a221oi_1
XFILLER_44_1014 VPWR VGND sg13g2_decap_8
X_3366_ _1084_ _1044_ _1059_ VPWR VGND sg13g2_xnor2_1
X_5105_ net293 VGND VPWR _0562_ videogen.test_lut_thingy.pixel_feeder_inst.row\[45\]\[1\]
+ _0190_ sg13g2_dfrbpq_1
X_3297_ _1015_ _1013_ _1014_ VPWR VGND sg13g2_nand2_2
X_5036_ net199 VGND VPWR _0493_ tmds_blue.dc_balancing_reg\[1\] net648 sg13g2_dfrbpq_2
XFILLER_39_996 VPWR VGND sg13g2_decap_8
XFILLER_26_624 VPWR VGND sg13g2_decap_8
XFILLER_13_329 VPWR VGND sg13g2_decap_4
XFILLER_40_148 VPWR VGND sg13g2_fill_1
XFILLER_22_885 VPWR VGND sg13g2_decap_8
XFILLER_21_384 VPWR VGND sg13g2_decap_8
XFILLER_5_517 VPWR VGND sg13g2_fill_1
XFILLER_5_506 VPWR VGND sg13g2_fill_2
XFILLER_31_78 VPWR VGND sg13g2_decap_8
Xoutput12 net12 uio_out[7] VPWR VGND sg13g2_buf_1
XFILLER_1_778 VPWR VGND sg13g2_decap_8
XFILLER_48_248 VPWR VGND sg13g2_decap_8
XFILLER_45_944 VPWR VGND sg13g2_decap_8
XFILLER_16_112 VPWR VGND sg13g2_fill_2
XFILLER_29_495 VPWR VGND sg13g2_decap_8
XFILLER_44_443 VPWR VGND sg13g2_fill_1
XFILLER_44_476 VPWR VGND sg13g2_fill_1
XFILLER_16_167 VPWR VGND sg13g2_decap_4
XFILLER_8_355 VPWR VGND sg13g2_decap_4
XFILLER_9_856 VPWR VGND sg13g2_fill_2
X_3220_ _0956_ videogen.fancy_shader.shader_counter_reg\[9\] _0955_ VPWR VGND sg13g2_xnor2_1
X_3151_ _0910_ _0831_ videogen.test_lut_thingy.pixel_feeder_inst.h_counter\[0\] VPWR
+ VGND sg13g2_nand2b_1
X_3082_ _0262_ net811 net752 net469 VPWR VGND sg13g2_and3_1
XFILLER_36_922 VPWR VGND sg13g2_decap_8
XFILLER_35_454 VPWR VGND sg13g2_fill_2
XFILLER_35_465 VPWR VGND sg13g2_fill_2
XFILLER_22_104 VPWR VGND sg13g2_fill_1
X_3984_ _1083_ _1693_ _1695_ VPWR VGND sg13g2_and2_1
X_2935_ _0739_ _0755_ _0811_ VPWR VGND sg13g2_nor2_2
X_2866_ net801 videogen.test_lut_thingy.pixel_feeder_inst.row\[57\]\[0\] _0794_ _0480_
+ VPWR VGND sg13g2_mux2_1
X_4605_ net689 net733 _0069_ VPWR VGND sg13g2_nor2_1
XFILLER_11_1013 VPWR VGND sg13g2_decap_8
XFILLER_30_192 VPWR VGND sg13g2_fill_2
X_2797_ _0762_ _0772_ _0781_ VPWR VGND sg13g2_nor2_2
X_4536_ VPWR _0662_ _2182_ VGND sg13g2_inv_1
X_4467_ VGND VPWR _2143_ _2144_ _2142_ _2060_ sg13g2_a21oi_2
Xfanout802 net803 net802 VPWR VGND sg13g2_buf_8
X_4398_ _2068_ blue\[6\] _2078_ _2079_ VPWR VGND sg13g2_a21o_1
X_3418_ _1134_ _1135_ _1136_ VPWR VGND sg13g2_nor2_1
X_3349_ _1066_ VPWR _1067_ VGND _1031_ _1065_ sg13g2_o21ai_1
X_5123__221 VPWR VGND net221 sg13g2_tiehi
XFILLER_38_270 VPWR VGND sg13g2_fill_1
X_5019_ net228 VGND VPWR _0476_ videogen.test_lut_thingy.pixel_feeder_inst.row\[56\]\[0\]
+ _0113_ sg13g2_dfrbpq_1
XFILLER_42_969 VPWR VGND sg13g2_decap_8
XFILLER_42_33 VPWR VGND sg13g2_decap_8
XFILLER_6_837 VPWR VGND sg13g2_fill_1
XFILLER_10_855 VPWR VGND sg13g2_decap_8
XFILLER_49_502 VPWR VGND sg13g2_decap_8
XFILLER_49_579 VPWR VGND sg13g2_decap_8
XFILLER_37_708 VPWR VGND sg13g2_fill_1
X_5102__305 VPWR VGND net305 sg13g2_tiehi
XFILLER_45_763 VPWR VGND sg13g2_decap_4
Xclkbuf_3_1__f_clk_regs clknet_0_clk_regs clknet_3_1__leaf_clk_regs VPWR VGND sg13g2_buf_8
XFILLER_18_966 VPWR VGND sg13g2_decap_8
XFILLER_44_251 VPWR VGND sg13g2_decap_8
XFILLER_33_958 VPWR VGND sg13g2_decap_8
X_2720_ videogen.test_lut_thingy.pixel_feeder_inst.row\[29\]\[3\] net765 _0759_ _0600_
+ VPWR VGND sg13g2_mux2_1
X_2651_ _0718_ _0721_ _0723_ VPWR VGND sg13g2_nor2_1
XFILLER_8_174 VPWR VGND sg13g2_decap_8
X_4321_ VGND VPWR _1992_ _2010_ _2011_ _1993_ sg13g2_a21oi_1
X_4252_ _1912_ _1915_ _1956_ VPWR VGND sg13g2_nor2b_1
X_3203_ videogen.fancy_shader.shader_counter_reg\[3\] _0943_ _0945_ VPWR VGND sg13g2_and2_1
XFILLER_41_1006 VPWR VGND sg13g2_decap_8
X_4183_ red\[0\] _1886_ _1889_ VPWR VGND sg13g2_nor2_1
X_3134_ _0897_ _0898_ _0899_ VPWR VGND sg13g2_nor2_2
X_3065_ _0862_ videogen.test_lut_thingy.pixel_feeder_inst.v_pix\[3\] videogen.test_lut_thingy.pixel_feeder_inst.v_pix\[4\]
+ _0867_ VPWR VGND sg13g2_a21o_1
XFILLER_24_914 VPWR VGND sg13g2_decap_8
XFILLER_36_796 VPWR VGND sg13g2_fill_2
X_3967_ _1674_ _1677_ _1678_ VPWR VGND sg13g2_and2_1
X_2918_ videogen.test_lut_thingy.pixel_feeder_inst.row\[10\]\[1\] net791 _0807_ _0441_
+ VPWR VGND sg13g2_mux2_1
X_3898_ _1609_ _1611_ _1612_ VPWR VGND _1606_ sg13g2_nand3b_1
X_2849_ videogen.test_lut_thingy.pixel_feeder_inst.row\[28\]\[2\] net776 _0791_ _0503_
+ VPWR VGND sg13g2_mux2_1
X_4519_ _2174_ net659 net457 net663 green_tmds_par\[7\] VPWR VGND sg13g2_a22oi_1
Xfanout621 net623 net621 VPWR VGND sg13g2_buf_8
Xfanout632 net634 net632 VPWR VGND sg13g2_buf_8
Xfanout610 display_enable net610 VPWR VGND sg13g2_buf_2
Xfanout665 net667 net665 VPWR VGND sg13g2_buf_8
Xfanout676 net679 net676 VPWR VGND sg13g2_buf_2
Xfanout643 net645 net643 VPWR VGND sg13g2_buf_8
Xfanout654 net655 net654 VPWR VGND sg13g2_buf_8
Xfanout698 net699 net698 VPWR VGND sg13g2_buf_8
Xfanout687 net688 net687 VPWR VGND sg13g2_buf_8
XFILLER_46_549 VPWR VGND sg13g2_fill_2
XFILLER_39_590 VPWR VGND sg13g2_fill_2
XFILLER_27_730 VPWR VGND sg13g2_decap_8
XFILLER_37_44 VPWR VGND sg13g2_fill_2
X_4960__346 VPWR VGND net346 sg13g2_tiehi
XFILLER_37_99 VPWR VGND sg13g2_decap_4
XFILLER_42_722 VPWR VGND sg13g2_fill_1
XFILLER_41_232 VPWR VGND sg13g2_fill_1
XFILLER_41_210 VPWR VGND sg13g2_fill_2
XFILLER_18_1008 VPWR VGND sg13g2_decap_8
XFILLER_6_623 VPWR VGND sg13g2_decap_4
X_4850__104 VPWR VGND net104 sg13g2_tiehi
XFILLER_2_851 VPWR VGND sg13g2_decap_8
X_5026__214 VPWR VGND net214 sg13g2_tiehi
XFILLER_49_376 VPWR VGND sg13g2_decap_8
XFILLER_18_785 VPWR VGND sg13g2_decap_8
XFILLER_18_796 VPWR VGND sg13g2_fill_1
X_4870_ net64 VGND VPWR _0331_ videogen.fancy_shader.shader_counter_reg\[0\] net655
+ sg13g2_dfrbpq_2
XFILLER_33_744 VPWR VGND sg13g2_fill_1
X_3821_ net634 videogen.test_lut_thingy.pixel_feeder_inst.row\[12\]\[0\] videogen.test_lut_thingy.pixel_feeder_inst.row\[13\]\[0\]
+ videogen.test_lut_thingy.pixel_feeder_inst.row\[14\]\[0\] videogen.test_lut_thingy.pixel_feeder_inst.row\[15\]\[0\]
+ net629 _1538_ VPWR VGND sg13g2_mux4_1
XFILLER_21_906 VPWR VGND sg13g2_fill_2
XFILLER_33_766 VPWR VGND sg13g2_fill_1
XFILLER_14_991 VPWR VGND sg13g2_decap_8
X_5213__119 VPWR VGND net119 sg13g2_tiehi
XFILLER_9_461 VPWR VGND sg13g2_decap_8
X_3752_ net614 VPWR _1470_ VGND _1459_ _1469_ sg13g2_o21ai_1
X_3683_ videogen.test_lut_thingy.pixel_feeder_inst.row\[45\]\[2\] net556 _1401_ VPWR
+ VGND sg13g2_nor2_1
X_2703_ videogen.test_lut_thingy.pixel_feeder_inst.row\[59\]\[0\] net801 _0751_ _0609_
+ VPWR VGND sg13g2_mux2_1
X_2634_ net595 _0698_ _0705_ _0706_ VPWR VGND sg13g2_or3_1
X_4304_ net759 _1998_ _0408_ VPWR VGND sg13g2_nor2_1
X_4235_ _1929_ _1939_ _1940_ VPWR VGND sg13g2_nor2b_1
XFILLER_28_505 VPWR VGND sg13g2_decap_8
X_4166_ VGND VPWR _1862_ _1873_ _0369_ net758 sg13g2_a21oi_1
X_3117_ _0838_ _0879_ _0886_ _0298_ VPWR VGND sg13g2_nor3_1
X_4097_ _1717_ _1591_ _1808_ VPWR VGND sg13g2_xor2_1
X_4827__139 VPWR VGND net139 sg13g2_tiehi
X_3048_ net612 _0693_ _0853_ _0854_ VPWR VGND sg13g2_nor3_1
X_4999_ net268 VGND VPWR _0456_ videogen.test_lut_thingy.pixel_feeder_inst.row\[7\]\[0\]
+ _0093_ sg13g2_dfrbpq_1
XFILLER_20_961 VPWR VGND sg13g2_decap_8
XFILLER_3_659 VPWR VGND sg13g2_fill_1
XFILLER_48_21 VPWR VGND sg13g2_decap_8
XFILLER_24_1012 VPWR VGND sg13g2_decap_8
XFILLER_47_858 VPWR VGND sg13g2_decap_8
XFILLER_46_357 VPWR VGND sg13g2_fill_2
XFILLER_46_346 VPWR VGND sg13g2_fill_1
XFILLER_0_28 VPWR VGND sg13g2_decap_8
XFILLER_19_549 VPWR VGND sg13g2_decap_8
XFILLER_27_571 VPWR VGND sg13g2_fill_2
XFILLER_9_59 VPWR VGND sg13g2_decap_8
XFILLER_11_950 VPWR VGND sg13g2_decap_8
XFILLER_7_976 VPWR VGND sg13g2_decap_8
XFILLER_6_431 VPWR VGND sg13g2_fill_1
XFILLER_9_1028 VPWR VGND sg13g2_fill_1
X_4020_ _1731_ _1719_ _1724_ VPWR VGND sg13g2_nand2_1
XFILLER_49_162 VPWR VGND sg13g2_decap_8
XFILLER_38_869 VPWR VGND sg13g2_decap_8
XFILLER_37_357 VPWR VGND sg13g2_decap_8
X_4943__363 VPWR VGND net363 sg13g2_tiehi
XFILLER_18_560 VPWR VGND sg13g2_decap_8
XFILLER_18_571 VPWR VGND sg13g2_decap_8
XFILLER_46_891 VPWR VGND sg13g2_decap_8
X_4922_ net402 VGND VPWR _0383_ videogen.test_lut_thingy.pixel_feeder_inst.row\[13\]\[3\]
+ _0032_ sg13g2_dfrbpq_1
X_4853_ net98 VGND VPWR _0314_ videogen.test_lut_thingy.pixel_feeder_inst.h_pix\[5\]
+ net640 sg13g2_dfrbpq_2
X_4784_ net683 net727 _0246_ VPWR VGND sg13g2_nor2_1
X_3804_ _1522_ _1327_ _1521_ VPWR VGND sg13g2_nand2b_1
X_3735_ _1449_ _1450_ _1451_ _1452_ _1453_ VPWR VGND sg13g2_nor4_1
X_5189__438 VPWR VGND net438 sg13g2_tiehi
Xheichips25_bagel_28 VPWR VGND uio_oe[7] sg13g2_tielo
X_3666_ _1380_ _1381_ _1382_ _1384_ VGND VPWR _1383_ sg13g2_nor4_2
XFILLER_47_1012 VPWR VGND sg13g2_decap_8
X_2617_ VPWR _0690_ blue\[1\] VGND sg13g2_inv_1
X_3597_ videogen.test_lut_thingy.pixel_feeder_inst.row\[7\]\[3\] net573 _1315_ VPWR
+ VGND sg13g2_nor2_1
X_4218_ net544 _1919_ _1924_ VPWR VGND sg13g2_nor2_1
X_5198_ net327 VGND VPWR _0655_ serialize.shift_reg_r\[0\] clknet_3_5__leaf_clk_regs
+ sg13g2_dfrbpq_1
XFILLER_29_825 VPWR VGND sg13g2_decap_4
X_4149_ _1857_ _1859_ _1860_ VPWR VGND sg13g2_nor2_1
XFILLER_34_89 VPWR VGND sg13g2_decap_8
Xclkload0 VPWR clkload0/Y clknet_1_1__leaf_clk VGND sg13g2_inv_1
XFILLER_4_957 VPWR VGND sg13g2_decap_8
XFILLER_3_445 VPWR VGND sg13g2_fill_1
XFILLER_47_633 VPWR VGND sg13g2_decap_8
X_5068__65 VPWR VGND net65 sg13g2_tiehi
XFILLER_19_379 VPWR VGND sg13g2_fill_2
XFILLER_27_390 VPWR VGND sg13g2_decap_8
XFILLER_30_522 VPWR VGND sg13g2_fill_2
X_3520_ videogen.test_lut_thingy.pixel_feeder_inst.row\[61\]\[3\] net561 _1238_ VPWR
+ VGND sg13g2_nor2_1
X_3451_ _1164_ _1168_ _1169_ VPWR VGND sg13g2_and2_1
X_3382_ _1096_ _1099_ _1100_ VPWR VGND sg13g2_nor2_1
X_5121_ net229 VGND VPWR _0578_ videogen.test_lut_thingy.pixel_feeder_inst.row\[41\]\[1\]
+ _0206_ sg13g2_dfrbpq_1
X_5052_ net142 VGND VPWR _0509_ videogen.test_lut_thingy.pixel_feeder_inst.row\[35\]\[0\]
+ _0137_ sg13g2_dfrbpq_1
X_4003_ _1714_ _1703_ _1700_ VPWR VGND sg13g2_nand2b_1
XFILLER_37_132 VPWR VGND sg13g2_decap_8
XFILLER_37_154 VPWR VGND sg13g2_decap_4
XFILLER_19_891 VPWR VGND sg13g2_fill_2
XFILLER_37_176 VPWR VGND sg13g2_decap_8
X_4905_ net422 VGND VPWR _0366_ red\[2\] net650 sg13g2_dfrbpq_2
X_4836_ net126 VGND VPWR _0297_ videogen.fancy_shader.video_x\[5\] net642 sg13g2_dfrbpq_2
X_4767_ net668 net712 _0231_ VPWR VGND sg13g2_nor2_1
XFILLER_21_599 VPWR VGND sg13g2_decap_8
X_4698_ net685 net729 _0162_ VPWR VGND sg13g2_nor2_1
X_3718_ net617 _1430_ _1435_ _1436_ VPWR VGND sg13g2_nor3_1
X_3649_ net623 VPWR _1367_ VGND videogen.test_lut_thingy.pixel_feeder_inst.row\[30\]\[2\]
+ net588 sg13g2_o21ai_1
XFILLER_0_437 VPWR VGND sg13g2_decap_8
Xhold12 serialize.shift_reg_g\[3\] VPWR VGND net458 sg13g2_dlygate4sd3_1
Xhold23 clockdiv.q0 VPWR VGND net469 sg13g2_dlygate4sd3_1
Xhold34 serialize.shift_reg_c\[8\] VPWR VGND net480 sg13g2_dlygate4sd3_1
XFILLER_29_56 VPWR VGND sg13g2_fill_2
XFILLER_45_33 VPWR VGND sg13g2_decap_4
XFILLER_44_636 VPWR VGND sg13g2_fill_1
XFILLER_45_88 VPWR VGND sg13g2_fill_2
XFILLER_45_77 VPWR VGND sg13g2_decap_8
XFILLER_25_850 VPWR VGND sg13g2_decap_4
XFILLER_6_38 VPWR VGND sg13g2_decap_8
XFILLER_6_27 VPWR VGND sg13g2_fill_1
XFILLER_3_242 VPWR VGND sg13g2_fill_2
X_4879__46 VPWR VGND net46 sg13g2_tiehi
XFILLER_48_964 VPWR VGND sg13g2_decap_8
XFILLER_47_441 VPWR VGND sg13g2_decap_8
XFILLER_47_496 VPWR VGND sg13g2_decap_8
XFILLER_19_187 VPWR VGND sg13g2_decap_4
XFILLER_23_809 VPWR VGND sg13g2_decap_8
XFILLER_35_669 VPWR VGND sg13g2_decap_8
X_2951_ videogen.test_lut_thingy.pixel_feeder_inst.row\[15\]\[3\] net771 _0814_ _0406_
+ VPWR VGND sg13g2_mux2_1
X_2882_ _0748_ _0758_ _0798_ VPWR VGND sg13g2_nor2_2
X_4621_ net702 net746 _0085_ VPWR VGND sg13g2_nor2_1
X_4552_ net701 net745 _0018_ VPWR VGND sg13g2_nor2_1
XFILLER_7_581 VPWR VGND sg13g2_fill_2
XFILLER_7_570 VPWR VGND sg13g2_decap_8
X_3503_ _1221_ _1218_ _1220_ VPWR VGND sg13g2_nand2b_1
X_4483_ tmds_blue.vsync hsync _2155_ VPWR VGND sg13g2_xor2_1
X_3434_ _1151_ _1149_ _1142_ _1152_ VPWR VGND sg13g2_a21o_1
X_3365_ _1083_ _1022_ _1036_ VPWR VGND sg13g2_xnor2_1
X_5104_ net297 VGND VPWR _0561_ videogen.test_lut_thingy.pixel_feeder_inst.row\[45\]\[0\]
+ _0189_ sg13g2_dfrbpq_1
X_3296_ VGND VPWR _1014_ _1012_ _1002_ sg13g2_or2_1
X_5035_ net200 VGND VPWR _0492_ tmds_blue.dc_balancing_reg\[0\] net648 sg13g2_dfrbpq_1
XFILLER_39_975 VPWR VGND sg13g2_decap_8
XFILLER_38_474 VPWR VGND sg13g2_fill_1
XFILLER_38_463 VPWR VGND sg13g2_fill_2
XFILLER_26_603 VPWR VGND sg13g2_decap_8
XFILLER_25_113 VPWR VGND sg13g2_fill_2
XFILLER_25_157 VPWR VGND sg13g2_fill_1
XFILLER_25_168 VPWR VGND sg13g2_decap_4
XFILLER_22_864 VPWR VGND sg13g2_decap_8
XFILLER_21_396 VPWR VGND sg13g2_fill_1
X_4956__351 VPWR VGND net351 sg13g2_tiehi
X_4819_ net153 VGND VPWR _0280_ videogen.test_lut_thingy.pixel_feeder_inst.row\[1\]\[2\]
+ _0011_ sg13g2_dfrbpq_1
Xoutput13 net13 uo_out[0] VPWR VGND sg13g2_buf_1
XFILLER_0_223 VPWR VGND sg13g2_decap_8
XFILLER_1_757 VPWR VGND sg13g2_decap_8
XFILLER_48_205 VPWR VGND sg13g2_decap_4
XFILLER_0_278 VPWR VGND sg13g2_fill_1
X_4887__445 VPWR VGND net445 sg13g2_tiehi
X_5140__75 VPWR VGND net75 sg13g2_tiehi
Xclkbuf_3_0__f_clk_regs clknet_0_clk_regs clknet_3_0__leaf_clk_regs VPWR VGND sg13g2_buf_8
XFILLER_45_923 VPWR VGND sg13g2_decap_8
XFILLER_44_488 VPWR VGND sg13g2_decap_8
XFILLER_12_330 VPWR VGND sg13g2_decap_4
XFILLER_13_831 VPWR VGND sg13g2_fill_1
XFILLER_40_650 VPWR VGND sg13g2_decap_8
XFILLER_9_824 VPWR VGND sg13g2_decap_8
X_5061__93 VPWR VGND net93 sg13g2_tiehi
XFILLER_8_378 VPWR VGND sg13g2_fill_1
X_4970__326 VPWR VGND net326 sg13g2_tiehi
XFILLER_4_584 VPWR VGND sg13g2_decap_8
X_3150_ _0894_ _0909_ _0308_ VPWR VGND sg13g2_nor2_1
X_3081_ VGND VPWR net752 net469 _0261_ _0872_ sg13g2_a21oi_1
XFILLER_36_989 VPWR VGND sg13g2_decap_8
X_3983_ VPWR _1694_ _1693_ VGND sg13g2_inv_1
X_2934_ videogen.test_lut_thingy.pixel_feeder_inst.row\[9\]\[0\] net803 _0810_ _0428_
+ VPWR VGND sg13g2_mux2_1
X_2865_ net785 videogen.test_lut_thingy.pixel_feeder_inst.row\[57\]\[1\] _0794_ _0481_
+ VPWR VGND sg13g2_mux2_1
X_4604_ net704 net747 _0068_ VPWR VGND sg13g2_nor2_1
X_2796_ videogen.test_lut_thingy.pixel_feeder_inst.row\[48\]\[0\] net797 _0780_ _0545_
+ VPWR VGND sg13g2_mux2_1
X_4535_ _2182_ net660 net471 net665 red_tmds_par\[7\] VPWR VGND sg13g2_a22oi_1
XFILLER_7_92 VPWR VGND sg13g2_decap_4
X_4466_ _2143_ net609 tmds_blue.dc_balancing_reg\[4\] VPWR VGND sg13g2_nand2b_1
X_4397_ _2077_ VPWR _2078_ VGND blue\[6\] _2076_ sg13g2_o21ai_1
X_3417_ _1015_ _1123_ _1132_ _1135_ VPWR VGND sg13g2_nor3_1
Xfanout803 net804 net803 VPWR VGND sg13g2_buf_8
X_3348_ VPWR VGND _1064_ _1017_ _1027_ _1018_ _1066_ _1020_ sg13g2_a221oi_1
X_3279_ videogen.fancy_shader.video_y\[1\] videogen.fancy_shader.shader_counter_reg\[1\]
+ _0997_ VPWR VGND sg13g2_nor2_1
XFILLER_45_219 VPWR VGND sg13g2_decap_8
XFILLER_38_282 VPWR VGND sg13g2_decap_4
X_5018_ net230 VGND VPWR _0475_ videogen.test_lut_thingy.pixel_feeder_inst.row\[5\]\[3\]
+ _0112_ sg13g2_dfrbpq_1
XFILLER_27_989 VPWR VGND sg13g2_decap_8
XFILLER_42_948 VPWR VGND sg13g2_decap_8
XFILLER_41_403 VPWR VGND sg13g2_fill_2
XFILLER_14_628 VPWR VGND sg13g2_fill_2
X_4919__408 VPWR VGND net408 sg13g2_tiehi
XFILLER_10_878 VPWR VGND sg13g2_decap_8
XFILLER_27_1010 VPWR VGND sg13g2_decap_8
XFILLER_1_554 VPWR VGND sg13g2_decap_8
XFILLER_49_558 VPWR VGND sg13g2_decap_8
X_5208__190 VPWR VGND net190 sg13g2_tiehi
XFILLER_45_720 VPWR VGND sg13g2_fill_2
XFILLER_18_945 VPWR VGND sg13g2_decap_8
XFILLER_29_293 VPWR VGND sg13g2_decap_4
XFILLER_44_274 VPWR VGND sg13g2_fill_1
XFILLER_32_403 VPWR VGND sg13g2_decap_4
XFILLER_33_915 VPWR VGND sg13g2_fill_2
XFILLER_33_937 VPWR VGND sg13g2_decap_8
XFILLER_44_285 VPWR VGND sg13g2_decap_4
XFILLER_41_992 VPWR VGND sg13g2_decap_8
X_5135__115 VPWR VGND net115 sg13g2_tiehi
XFILLER_8_142 VPWR VGND sg13g2_decap_8
X_2650_ VPWR _0722_ _0721_ VGND sg13g2_inv_1
XFILLER_9_698 VPWR VGND sg13g2_decap_8
XFILLER_5_871 VPWR VGND sg13g2_decap_8
X_4320_ tmds_green.dc_balancing_reg\[0\] tmds_green.dc_balancing_reg\[1\] tmds_green.dc_balancing_reg\[3\]
+ tmds_green.dc_balancing_reg\[2\] _2010_ VPWR VGND sg13g2_nor4_1
X_4251_ _1953_ tmds_red.dc_balancing_reg\[3\] _1955_ VPWR VGND sg13g2_xor2_1
X_3202_ videogen.fancy_shader.shader_counter_reg\[3\] _0943_ _0944_ VPWR VGND sg13g2_nor2_1
X_4182_ _1888_ _1887_ _1886_ VPWR VGND sg13g2_nand2b_1
X_3133_ _0710_ VPWR _0898_ VGND net604 _0845_ sg13g2_o21ai_1
X_3064_ videogen.test_lut_thingy.pixel_feeder_inst.v_pix\[3\] _0862_ videogen.test_lut_thingy.pixel_feeder_inst.v_pix\[4\]
+ _0866_ VPWR VGND sg13g2_nand3_1
XFILLER_48_591 VPWR VGND sg13g2_decap_8
XFILLER_36_764 VPWR VGND sg13g2_decap_8
X_3966_ _1677_ _1676_ _1673_ VPWR VGND sg13g2_nand2b_1
XFILLER_23_458 VPWR VGND sg13g2_fill_1
X_2917_ videogen.test_lut_thingy.pixel_feeder_inst.row\[10\]\[2\] net781 _0807_ _0442_
+ VPWR VGND sg13g2_mux2_1
X_3897_ _1591_ _1596_ _1611_ VPWR VGND sg13g2_nor2_1
X_2848_ videogen.test_lut_thingy.pixel_feeder_inst.row\[28\]\[3\] net765 _0791_ _0504_
+ VPWR VGND sg13g2_mux2_1
XFILLER_12_48 VPWR VGND sg13g2_decap_8
X_2779_ videogen.test_lut_thingy.pixel_feeder_inst.row\[46\]\[2\] net773 _0777_ _0559_
+ VPWR VGND sg13g2_mux2_1
XFILLER_3_819 VPWR VGND sg13g2_fill_2
X_4953__354 VPWR VGND net354 sg13g2_tiehi
X_4518_ VPWR _0653_ _2173_ VGND sg13g2_inv_1
X_4449_ _2116_ VPWR _2129_ VGND _2061_ _2128_ sg13g2_o21ai_1
Xfanout633 net634 net633 VPWR VGND sg13g2_buf_8
Xfanout611 videogen.fancy_shader.video_y\[6\] net611 VPWR VGND sg13g2_buf_8
Xfanout622 net623 net622 VPWR VGND sg13g2_buf_1
Xfanout600 net602 net600 VPWR VGND sg13g2_buf_8
Xfanout666 net667 net666 VPWR VGND sg13g2_buf_8
Xfanout644 net645 net644 VPWR VGND sg13g2_buf_1
Xfanout655 net656 net655 VPWR VGND sg13g2_buf_8
Xfanout677 net679 net677 VPWR VGND sg13g2_buf_8
Xfanout699 net700 net699 VPWR VGND sg13g2_buf_8
Xfanout688 net691 net688 VPWR VGND sg13g2_buf_8
XFILLER_46_528 VPWR VGND sg13g2_decap_8
XFILLER_2_1012 VPWR VGND sg13g2_decap_8
X_4854__96 VPWR VGND net96 sg13g2_tiehi
XFILLER_37_78 VPWR VGND sg13g2_decap_8
XFILLER_26_263 VPWR VGND sg13g2_decap_8
XFILLER_15_959 VPWR VGND sg13g2_decap_8
XFILLER_26_274 VPWR VGND sg13g2_fill_1
XFILLER_5_134 VPWR VGND sg13g2_decap_8
XFILLER_2_830 VPWR VGND sg13g2_decap_8
XFILLER_49_333 VPWR VGND sg13g2_fill_1
XFILLER_49_311 VPWR VGND sg13g2_decap_8
XFILLER_37_517 VPWR VGND sg13g2_decap_4
XFILLER_18_731 VPWR VGND sg13g2_decap_8
XFILLER_45_572 VPWR VGND sg13g2_fill_1
X_3820_ _1535_ VPWR _1537_ VGND net625 _1536_ sg13g2_o21ai_1
X_3751_ net615 VPWR _1469_ VGND _1464_ _1468_ sg13g2_o21ai_1
XFILLER_14_970 VPWR VGND sg13g2_decap_8
X_2702_ videogen.test_lut_thingy.pixel_feeder_inst.row\[59\]\[1\] net789 _0751_ _0610_
+ VPWR VGND sg13g2_mux2_1
XFILLER_13_480 VPWR VGND sg13g2_fill_2
X_3682_ videogen.test_lut_thingy.pixel_feeder_inst.row\[47\]\[2\] net565 _1400_ VPWR
+ VGND sg13g2_nor2_1
X_2633_ _0700_ _0703_ videogen.fancy_shader.video_x\[7\] _0705_ VPWR VGND _0704_ sg13g2_nand4_1
X_4303_ VGND VPWR _1878_ _1987_ _1998_ _1997_ sg13g2_a21oi_1
X_4234_ _1927_ VPWR _1939_ VGND _0686_ _1902_ sg13g2_o21ai_1
X_4165_ _1873_ _1872_ _1866_ _1869_ _1577_ VPWR VGND sg13g2_a22oi_1
X_4909__418 VPWR VGND net418 sg13g2_tiehi
X_3116_ videogen.fancy_shader.video_x\[6\] _0837_ _0886_ VPWR VGND sg13g2_nor2_1
X_4096_ VPWR VGND _1801_ _1806_ _1804_ _1796_ _1807_ _1802_ sg13g2_a221oi_1
X_4946__180 VPWR VGND net180 sg13g2_tiehi
X_3047_ videogen.fancy_shader.video_y\[3\] videogen.fancy_shader.video_y\[2\] videogen.fancy_shader.video_y\[4\]
+ _0853_ VPWR VGND _0850_ sg13g2_nand4_1
XFILLER_36_572 VPWR VGND sg13g2_fill_1
X_5200__271 VPWR VGND net271 sg13g2_tiehi
XFILLER_11_406 VPWR VGND sg13g2_decap_8
X_4998_ net270 VGND VPWR _0455_ videogen.test_lut_thingy.pixel_feeder_inst.row\[8\]\[3\]
+ _0092_ sg13g2_dfrbpq_1
XFILLER_20_940 VPWR VGND sg13g2_decap_8
X_3949_ net1 _1662_ _1663_ VPWR VGND sg13g2_and2_1
XFILLER_2_104 VPWR VGND sg13g2_fill_1
XFILLER_2_115 VPWR VGND sg13g2_fill_2
XFILLER_19_506 VPWR VGND sg13g2_decap_8
XFILLER_47_837 VPWR VGND sg13g2_decap_8
XFILLER_34_509 VPWR VGND sg13g2_decap_8
XFILLER_42_564 VPWR VGND sg13g2_fill_1
XFILLER_9_27 VPWR VGND sg13g2_fill_1
XFILLER_15_756 VPWR VGND sg13g2_fill_2
XFILLER_6_410 VPWR VGND sg13g2_decap_8
XFILLER_10_450 VPWR VGND sg13g2_decap_8
XFILLER_31_1028 VPWR VGND sg13g2_fill_1
XFILLER_7_955 VPWR VGND sg13g2_decap_8
X_5212__164 VPWR VGND net164 sg13g2_tiehi
XFILLER_6_465 VPWR VGND sg13g2_fill_1
XFILLER_43_7 VPWR VGND sg13g2_decap_4
XFILLER_9_1007 VPWR VGND sg13g2_decap_8
XFILLER_1_170 VPWR VGND sg13g2_decap_8
XFILLER_49_130 VPWR VGND sg13g2_fill_1
XFILLER_46_870 VPWR VGND sg13g2_decap_8
X_4826__140 VPWR VGND net140 sg13g2_tiehi
X_4921_ net404 VGND VPWR _0382_ videogen.test_lut_thingy.pixel_feeder_inst.row\[13\]\[2\]
+ _0031_ sg13g2_dfrbpq_1
X_4852_ net100 VGND VPWR _0313_ videogen.test_lut_thingy.pixel_feeder_inst.h_pix\[4\]
+ net640 sg13g2_dfrbpq_2
X_3803_ _1424_ _1520_ _1521_ VPWR VGND sg13g2_nor2b_1
X_4783_ net684 net728 _0245_ VPWR VGND sg13g2_nor2_1
X_3734_ videogen.test_lut_thingy.pixel_feeder_inst.row\[53\]\[1\] net556 _1452_ VPWR
+ VGND sg13g2_nor2_1
X_3665_ videogen.test_lut_thingy.pixel_feeder_inst.row\[49\]\[2\] net558 _1383_ VPWR
+ VGND sg13g2_nor2_1
Xheichips25_bagel_29 VPWR VGND uio_out[1] sg13g2_tielo
X_2616_ _0689_ net2 VPWR VGND sg13g2_inv_2
X_3596_ videogen.test_lut_thingy.pixel_feeder_inst.row\[4\]\[3\] net583 _1314_ VPWR
+ VGND sg13g2_nor2_1
X_4950__357 VPWR VGND net357 sg13g2_tiehi
XFILLER_0_619 VPWR VGND sg13g2_fill_1
X_5161__303 VPWR VGND net303 sg13g2_tiehi
XFILLER_29_804 VPWR VGND sg13g2_decap_4
X_4217_ _1920_ _1922_ _1923_ VPWR VGND sg13g2_nor2_2
X_5197_ net335 VGND VPWR _0654_ serialize.shift_reg_g\[7\] clknet_3_7__leaf_clk_regs
+ sg13g2_dfrbpq_1
XFILLER_18_14 VPWR VGND sg13g2_decap_8
X_4148_ _1852_ _1855_ _1784_ _1859_ VPWR VGND _1858_ sg13g2_nand4_1
X_4079_ _1790_ _1639_ _1675_ VPWR VGND sg13g2_xnor2_1
XFILLER_34_35 VPWR VGND sg13g2_decap_4
XFILLER_11_203 VPWR VGND sg13g2_decap_8
XFILLER_24_597 VPWR VGND sg13g2_fill_2
XFILLER_34_68 VPWR VGND sg13g2_decap_8
XFILLER_12_759 VPWR VGND sg13g2_decap_8
Xclkload1 VPWR clkload1/Y clknet_3_1__leaf_clk_regs VGND sg13g2_inv_1
XFILLER_4_936 VPWR VGND sg13g2_decap_8
XFILLER_3_435 VPWR VGND sg13g2_fill_2
XFILLER_3_424 VPWR VGND sg13g2_decap_8
XFILLER_19_336 VPWR VGND sg13g2_fill_2
XFILLER_19_347 VPWR VGND sg13g2_fill_2
XFILLER_28_881 VPWR VGND sg13g2_decap_8
XFILLER_34_317 VPWR VGND sg13g2_decap_4
XFILLER_15_553 VPWR VGND sg13g2_decap_8
XFILLER_30_512 VPWR VGND sg13g2_fill_2
XFILLER_30_545 VPWR VGND sg13g2_fill_2
XFILLER_30_556 VPWR VGND sg13g2_fill_2
XFILLER_10_280 VPWR VGND sg13g2_fill_1
XFILLER_6_262 VPWR VGND sg13g2_decap_4
X_3450_ _1168_ _1167_ _1165_ VPWR VGND sg13g2_nand2b_1
X_3381_ _1082_ net546 _1099_ VPWR VGND sg13g2_nor2_1
X_5120_ net233 VGND VPWR _0577_ videogen.test_lut_thingy.pixel_feeder_inst.row\[41\]\[0\]
+ _0205_ sg13g2_dfrbpq_1
X_5051_ net146 VGND VPWR _0508_ videogen.test_lut_thingy.pixel_feeder_inst.row\[27\]\[3\]
+ _0136_ sg13g2_dfrbpq_1
X_4002_ _1702_ _1700_ _1713_ VPWR VGND _1712_ sg13g2_nand3b_1
X_4980__306 VPWR VGND net306 sg13g2_tiehi
XFILLER_19_870 VPWR VGND sg13g2_decap_8
XFILLER_26_807 VPWR VGND sg13g2_decap_8
X_4904_ net423 VGND VPWR _0365_ green\[7\] net647 sg13g2_dfrbpq_2
X_4835_ net127 VGND VPWR _0296_ videogen.fancy_shader.video_x\[4\] net642 sg13g2_dfrbpq_2
XFILLER_21_534 VPWR VGND sg13g2_decap_8
X_4766_ net672 net716 _0230_ VPWR VGND sg13g2_nor2_1
XFILLER_14_1012 VPWR VGND sg13g2_decap_8
X_3717_ _1431_ _1432_ _1433_ _1434_ _1435_ VPWR VGND sg13g2_nor4_1
X_4697_ net683 net727 _0161_ VPWR VGND sg13g2_nor2_1
X_3648_ _1362_ _1363_ _1364_ _1365_ _1366_ VPWR VGND sg13g2_nor4_1
X_3579_ videogen.test_lut_thingy.pixel_feeder_inst.row\[25\]\[3\] net558 _1297_ VPWR
+ VGND sg13g2_nor2_1
XFILLER_0_416 VPWR VGND sg13g2_fill_2
XFILLER_1_939 VPWR VGND sg13g2_decap_8
XFILLER_48_409 VPWR VGND sg13g2_decap_8
Xhold13 serialize.shift_reg_r\[8\] VPWR VGND net459 sg13g2_dlygate4sd3_1
Xhold24 serialize.shift_reg_r\[5\] VPWR VGND net470 sg13g2_dlygate4sd3_1
Xhold35 serialize.bit_cnt\[2\] VPWR VGND net481 sg13g2_dlygate4sd3_1
XFILLER_28_111 VPWR VGND sg13g2_decap_8
XFILLER_29_645 VPWR VGND sg13g2_fill_2
XFILLER_28_166 VPWR VGND sg13g2_decap_8
XFILLER_25_895 VPWR VGND sg13g2_decap_8
XFILLER_24_383 VPWR VGND sg13g2_decap_4
X_5143__51 VPWR VGND net51 sg13g2_tiehi
XFILLER_48_943 VPWR VGND sg13g2_decap_8
XFILLER_47_420 VPWR VGND sg13g2_decap_8
XFILLER_0_994 VPWR VGND sg13g2_decap_8
XFILLER_13_8 VPWR VGND sg13g2_decap_8
XFILLER_47_475 VPWR VGND sg13g2_decap_8
XFILLER_34_103 VPWR VGND sg13g2_decap_4
XFILLER_16_840 VPWR VGND sg13g2_fill_1
XFILLER_16_851 VPWR VGND sg13g2_decap_4
XFILLER_34_136 VPWR VGND sg13g2_fill_2
XFILLER_34_158 VPWR VGND sg13g2_fill_2
X_2950_ _0760_ _0803_ _0814_ VPWR VGND sg13g2_nor2_2
XFILLER_15_350 VPWR VGND sg13g2_fill_1
XFILLER_16_884 VPWR VGND sg13g2_decap_8
X_2881_ videogen.test_lut_thingy.pixel_feeder_inst.row\[60\]\[0\] net799 _0797_ _0468_
+ VPWR VGND sg13g2_mux2_1
X_4620_ net704 net748 _0084_ VPWR VGND sg13g2_nor2_1
XFILLER_30_386 VPWR VGND sg13g2_fill_1
X_4551_ net695 net739 _0017_ VPWR VGND sg13g2_nor2_1
X_4482_ VGND VPWR net609 net608 _0620_ _2146_ sg13g2_a21oi_1
X_3502_ VGND VPWR _0992_ _1219_ _1220_ _1214_ sg13g2_a21oi_1
X_3433_ _1133_ VPWR _1151_ VGND _1132_ _1150_ sg13g2_o21ai_1
X_5103_ net301 VGND VPWR _0560_ videogen.test_lut_thingy.pixel_feeder_inst.row\[46\]\[3\]
+ _0188_ sg13g2_dfrbpq_1
X_3364_ _1082_ _1071_ _1080_ VPWR VGND sg13g2_xnor2_1
XFILLER_32_0 VPWR VGND sg13g2_fill_2
X_3295_ _1013_ _1002_ _1012_ VPWR VGND sg13g2_nand2_1
X_5034_ net201 VGND VPWR _0491_ green_tmds_par\[9\] net651 sg13g2_dfrbpq_1
XFILLER_38_420 VPWR VGND sg13g2_decap_8
XFILLER_41_629 VPWR VGND sg13g2_decap_4
XFILLER_41_618 VPWR VGND sg13g2_fill_1
XFILLER_15_59 VPWR VGND sg13g2_fill_2
XFILLER_22_843 VPWR VGND sg13g2_decap_8
XFILLER_21_353 VPWR VGND sg13g2_decap_4
X_4818_ net155 VGND VPWR _0279_ videogen.test_lut_thingy.pixel_feeder_inst.row\[1\]\[1\]
+ _0010_ sg13g2_dfrbpq_1
XFILLER_31_25 VPWR VGND sg13g2_fill_2
X_4749_ net706 net751 _0213_ VPWR VGND sg13g2_nor2_1
Xoutput14 net14 uo_out[1] VPWR VGND sg13g2_buf_1
XFILLER_0_202 VPWR VGND sg13g2_decap_8
XFILLER_1_736 VPWR VGND sg13g2_decap_8
XFILLER_45_902 VPWR VGND sg13g2_decap_8
XFILLER_45_979 VPWR VGND sg13g2_decap_8
XFILLER_44_434 VPWR VGND sg13g2_decap_8
XFILLER_25_670 VPWR VGND sg13g2_decap_8
XFILLER_13_821 VPWR VGND sg13g2_decap_4
XFILLER_9_803 VPWR VGND sg13g2_decap_8
XFILLER_13_887 VPWR VGND sg13g2_decap_8
XFILLER_8_324 VPWR VGND sg13g2_decap_4
XFILLER_9_858 VPWR VGND sg13g2_fill_1
XFILLER_9_869 VPWR VGND sg13g2_fill_2
XFILLER_13_898 VPWR VGND sg13g2_fill_2
X_5211__207 VPWR VGND net207 sg13g2_tiehi
XFILLER_21_91 VPWR VGND sg13g2_decap_8
XFILLER_39_206 VPWR VGND sg13g2_decap_4
XFILLER_39_217 VPWR VGND sg13g2_decap_4
XFILLER_0_791 VPWR VGND sg13g2_decap_8
X_3080_ net811 VPWR _0872_ VGND net752 net469 sg13g2_o21ai_1
XFILLER_36_902 VPWR VGND sg13g2_fill_2
XFILLER_47_250 VPWR VGND sg13g2_fill_1
XFILLER_35_456 VPWR VGND sg13g2_fill_1
XFILLER_36_968 VPWR VGND sg13g2_decap_8
X_3982_ _1034_ _1685_ _1693_ VPWR VGND sg13g2_and2_1
XFILLER_35_467 VPWR VGND sg13g2_fill_1
X_2933_ videogen.test_lut_thingy.pixel_feeder_inst.row\[9\]\[1\] net791 _0810_ _0429_
+ VPWR VGND sg13g2_mux2_1
XFILLER_31_662 VPWR VGND sg13g2_fill_1
X_2864_ net774 videogen.test_lut_thingy.pixel_feeder_inst.row\[57\]\[2\] _0794_ _0482_
+ VPWR VGND sg13g2_mux2_1
XFILLER_30_161 VPWR VGND sg13g2_fill_1
X_4603_ net703 net747 _0067_ VPWR VGND sg13g2_nor2_1
X_2795_ videogen.test_lut_thingy.pixel_feeder_inst.row\[48\]\[1\] net786 _0780_ _0546_
+ VPWR VGND sg13g2_mux2_1
X_4534_ VPWR _0661_ _2181_ VGND sg13g2_inv_1
X_4465_ _2076_ _2077_ _2142_ VPWR VGND sg13g2_nor2b_2
X_3416_ VGND VPWR _1016_ _1134_ _1133_ _1124_ sg13g2_a21oi_2
Xfanout804 net805 net804 VPWR VGND sg13g2_buf_8
X_4396_ _2077_ net607 blue\[1\] VPWR VGND sg13g2_nand2_1
X_3347_ _1065_ _1034_ _1064_ VPWR VGND sg13g2_nand2_1
X_4866__72 VPWR VGND net72 sg13g2_tiehi
X_3278_ _0996_ videogen.fancy_shader.video_y\[1\] videogen.fancy_shader.shader_counter_reg\[1\]
+ VPWR VGND sg13g2_nand2_1
X_4881__42 VPWR VGND net42 sg13g2_tiehi
X_5017_ net232 VGND VPWR _0474_ videogen.test_lut_thingy.pixel_feeder_inst.row\[5\]\[2\]
+ _0111_ sg13g2_dfrbpq_1
X_5197__335 VPWR VGND net335 sg13g2_tiehi
XFILLER_26_445 VPWR VGND sg13g2_decap_8
XFILLER_27_968 VPWR VGND sg13g2_decap_8
XFILLER_42_927 VPWR VGND sg13g2_decap_8
XFILLER_26_467 VPWR VGND sg13g2_fill_2
XFILLER_41_437 VPWR VGND sg13g2_fill_2
XFILLER_13_117 VPWR VGND sg13g2_decap_8
XFILLER_42_68 VPWR VGND sg13g2_decap_8
XFILLER_6_817 VPWR VGND sg13g2_decap_4
XFILLER_5_316 VPWR VGND sg13g2_fill_2
XFILLER_1_511 VPWR VGND sg13g2_decap_8
XFILLER_3_18 VPWR VGND sg13g2_decap_8
XFILLER_1_533 VPWR VGND sg13g2_decap_8
XFILLER_49_537 VPWR VGND sg13g2_decap_8
XFILLER_45_710 VPWR VGND sg13g2_decap_4
XFILLER_18_924 VPWR VGND sg13g2_decap_8
XFILLER_29_261 VPWR VGND sg13g2_fill_1
XFILLER_44_231 VPWR VGND sg13g2_fill_2
XFILLER_26_990 VPWR VGND sg13g2_decap_8
XFILLER_41_971 VPWR VGND sg13g2_decap_8
XFILLER_32_459 VPWR VGND sg13g2_fill_2
XFILLER_34_1026 VPWR VGND sg13g2_fill_2
XFILLER_9_677 VPWR VGND sg13g2_decap_8
XFILLER_12_183 VPWR VGND sg13g2_decap_4
XFILLER_4_371 VPWR VGND sg13g2_fill_2
X_4250_ VGND VPWR _1954_ _1953_ tmds_red.dc_balancing_reg\[3\] sg13g2_or2_1
X_3201_ net551 _0942_ _0943_ _0333_ VPWR VGND sg13g2_nor3_1
X_4181_ _1881_ red\[7\] _1887_ VPWR VGND sg13g2_xor2_1
X_3132_ videogen.test_lut_thingy.pixel_feeder_inst.v_counter\[3\] VPWR _0897_ VGND
+ videogen.test_lut_thingy.pixel_feeder_inst.v_counter\[2\] _0896_ sg13g2_o21ai_1
XFILLER_48_570 VPWR VGND sg13g2_decap_8
X_3063_ VGND VPWR _0855_ _0865_ net19 _0857_ sg13g2_a21oi_1
XFILLER_35_253 VPWR VGND sg13g2_decap_4
XFILLER_36_798 VPWR VGND sg13g2_fill_1
XFILLER_24_949 VPWR VGND sg13g2_decap_8
X_3965_ _1675_ _1156_ _1676_ VPWR VGND sg13g2_xor2_1
X_2916_ videogen.test_lut_thingy.pixel_feeder_inst.row\[10\]\[3\] net770 _0807_ _0443_
+ VPWR VGND sg13g2_mux2_1
X_3896_ _1610_ _1607_ _1609_ VPWR VGND sg13g2_nand2_1
XFILLER_32_982 VPWR VGND sg13g2_decap_8
X_2847_ _0735_ _0773_ _0791_ VPWR VGND sg13g2_nor2_2
X_2778_ videogen.test_lut_thingy.pixel_feeder_inst.row\[46\]\[3\] net761 _0777_ _0560_
+ VPWR VGND sg13g2_mux2_1
X_4517_ _2173_ net658 net476 net663 green_tmds_par\[6\] VPWR VGND sg13g2_a22oi_1
X_4448_ _2128_ _2121_ _2127_ _2119_ _2066_ VPWR VGND sg13g2_a22oi_1
Xfanout601 net602 net601 VPWR VGND sg13g2_buf_8
Xfanout612 videogen.fancy_shader.video_y\[5\] net612 VPWR VGND sg13g2_buf_8
Xfanout623 net626 net623 VPWR VGND sg13g2_buf_8
X_4379_ tmds_blue.dc_balancing_reg\[4\] _2060_ _2061_ VPWR VGND sg13g2_nor2b_2
Xfanout634 videogen.test_lut_thingy.pixel_feeder_inst.h_pix\[0\] net634 VPWR VGND
+ sg13g2_buf_8
Xfanout645 net656 net645 VPWR VGND sg13g2_buf_2
Xfanout656 net657 net656 VPWR VGND sg13g2_buf_8
Xfanout667 _0670_ net667 VPWR VGND sg13g2_buf_8
Xfanout689 net691 net689 VPWR VGND sg13g2_buf_8
Xfanout678 net679 net678 VPWR VGND sg13g2_buf_1
XFILLER_39_570 VPWR VGND sg13g2_fill_1
XFILLER_37_46 VPWR VGND sg13g2_fill_1
XFILLER_41_212 VPWR VGND sg13g2_fill_1
XFILLER_15_938 VPWR VGND sg13g2_decap_8
XFILLER_14_448 VPWR VGND sg13g2_decap_4
XFILLER_23_993 VPWR VGND sg13g2_decap_8
XFILLER_6_647 VPWR VGND sg13g2_decap_8
XFILLER_2_886 VPWR VGND sg13g2_decap_8
XFILLER_1_385 VPWR VGND sg13g2_decap_4
XFILLER_49_345 VPWR VGND sg13g2_decap_8
XFILLER_45_551 VPWR VGND sg13g2_fill_1
XFILLER_17_253 VPWR VGND sg13g2_decap_8
XFILLER_45_584 VPWR VGND sg13g2_decap_4
XFILLER_17_297 VPWR VGND sg13g2_fill_1
XFILLER_32_201 VPWR VGND sg13g2_fill_2
XFILLER_32_212 VPWR VGND sg13g2_decap_8
XFILLER_21_919 VPWR VGND sg13g2_decap_8
X_3750_ net620 VPWR _1468_ VGND _1465_ _1467_ sg13g2_o21ai_1
X_2701_ videogen.test_lut_thingy.pixel_feeder_inst.row\[59\]\[2\] net774 _0751_ _0611_
+ VPWR VGND sg13g2_mux2_1
X_3681_ videogen.test_lut_thingy.pixel_feeder_inst.row\[46\]\[2\] net585 _1399_ VPWR
+ VGND sg13g2_nor2_1
X_2632_ net636 videogen.fancy_shader.video_x\[3\] videogen.fancy_shader.video_x\[2\]
+ _0704_ VPWR VGND sg13g2_nor3_1
X_4302_ net610 VPWR _1997_ VGND _1878_ _1987_ sg13g2_o21ai_1
X_4233_ net545 _1903_ _1938_ VPWR VGND sg13g2_nor2_1
X_4164_ _1580_ _1669_ _1424_ _1872_ VPWR VGND sg13g2_nand3_1
X_4095_ VPWR VGND net543 _1798_ _1800_ _1794_ _1806_ _1795_ sg13g2_a221oi_1
X_3115_ _0837_ _0879_ _0885_ _0297_ VPWR VGND sg13g2_nor3_1
X_3046_ _0852_ videogen.fancy_shader.video_y\[2\] _0850_ VPWR VGND sg13g2_nand2_1
XFILLER_24_702 VPWR VGND sg13g2_fill_2
XFILLER_23_212 VPWR VGND sg13g2_fill_2
X_4997_ net272 VGND VPWR _0454_ videogen.test_lut_thingy.pixel_feeder_inst.row\[8\]\[2\]
+ _0091_ sg13g2_dfrbpq_1
XFILLER_23_15 VPWR VGND sg13g2_fill_1
X_3948_ _1655_ _1658_ _1227_ _1662_ VPWR VGND _1661_ sg13g2_nand4_1
X_3879_ _1593_ _1073_ _1592_ VPWR VGND sg13g2_nand2_2
XFILLER_20_996 VPWR VGND sg13g2_decap_8
XFILLER_3_617 VPWR VGND sg13g2_fill_2
XFILLER_48_56 VPWR VGND sg13g2_decap_8
XFILLER_47_816 VPWR VGND sg13g2_decap_8
X_4929__390 VPWR VGND net390 sg13g2_tiehi
XFILLER_14_201 VPWR VGND sg13g2_decap_4
XFILLER_15_713 VPWR VGND sg13g2_decap_4
XFILLER_15_746 VPWR VGND sg13g2_decap_4
XFILLER_27_573 VPWR VGND sg13g2_fill_1
XFILLER_42_587 VPWR VGND sg13g2_decap_8
XFILLER_7_934 VPWR VGND sg13g2_decap_8
XFILLER_11_985 VPWR VGND sg13g2_decap_8
XFILLER_31_1007 VPWR VGND sg13g2_decap_8
XFILLER_13_81 VPWR VGND sg13g2_decap_8
XFILLER_2_650 VPWR VGND sg13g2_fill_1
XFILLER_36_7 VPWR VGND sg13g2_fill_1
XFILLER_49_142 VPWR VGND sg13g2_decap_8
XFILLER_37_337 VPWR VGND sg13g2_decap_8
XFILLER_45_381 VPWR VGND sg13g2_decap_8
X_4920_ net406 VGND VPWR _0381_ videogen.test_lut_thingy.pixel_feeder_inst.row\[13\]\[1\]
+ _0030_ sg13g2_dfrbpq_1
XFILLER_33_510 VPWR VGND sg13g2_decap_8
X_4851_ net102 VGND VPWR _0312_ videogen.test_lut_thingy.pixel_feeder_inst.h_pix\[3\]
+ net640 sg13g2_dfrbpq_2
XFILLER_33_532 VPWR VGND sg13g2_decap_8
XFILLER_33_554 VPWR VGND sg13g2_fill_1
X_3802_ VGND VPWR _1519_ _1520_ _0689_ videogen.test_lut_thingy.gol_counter_reg\[1\]
+ sg13g2_a21oi_2
X_4782_ net685 net729 _0244_ VPWR VGND sg13g2_nor2_1
XFILLER_9_260 VPWR VGND sg13g2_decap_8
X_3733_ videogen.test_lut_thingy.pixel_feeder_inst.row\[54\]\[1\] net586 _1451_ VPWR
+ VGND sg13g2_nor2_1
X_3664_ videogen.test_lut_thingy.pixel_feeder_inst.row\[50\]\[2\] net587 _1382_ VPWR
+ VGND sg13g2_nor2_1
X_2615_ net609 _0688_ VPWR VGND sg13g2_inv_4
X_4915__412 VPWR VGND net412 sg13g2_tiehi
X_3595_ videogen.test_lut_thingy.pixel_feeder_inst.row\[5\]\[3\] net563 _1313_ VPWR
+ VGND sg13g2_nor2_1
X_5196_ net343 VGND VPWR _0653_ serialize.shift_reg_g\[6\] clknet_3_6__leaf_clk_regs
+ sg13g2_dfrbpq_1
X_4216_ _1922_ _1921_ VPWR VGND _1916_ sg13g2_nand2b_2
X_4987__292 VPWR VGND net292 sg13g2_tiehi
X_4147_ _1858_ _1769_ _1780_ VPWR VGND sg13g2_xnor2_1
X_4078_ VGND VPWR _0992_ _1788_ _1789_ _1782_ sg13g2_a21oi_1
XFILLER_43_318 VPWR VGND sg13g2_fill_2
X_3029_ _0843_ net811 videogen.test_lut_thingy.pixel_feeder_inst.state\[0\] VPWR VGND
+ sg13g2_nand2b_1
Xclkload2 clknet_3_2__leaf_clk_regs clkload2/X VPWR VGND sg13g2_buf_1
XFILLER_20_793 VPWR VGND sg13g2_fill_1
XFILLER_4_915 VPWR VGND sg13g2_decap_8
XFILLER_3_469 VPWR VGND sg13g2_fill_2
XFILLER_46_189 VPWR VGND sg13g2_decap_8
XFILLER_27_370 VPWR VGND sg13g2_decap_4
XFILLER_6_252 VPWR VGND sg13g2_fill_2
XFILLER_6_285 VPWR VGND sg13g2_decap_8
X_3380_ _1096_ net547 _1097_ _1098_ VPWR VGND sg13g2_a21o_1
X_5050_ net150 VGND VPWR _0507_ videogen.test_lut_thingy.pixel_feeder_inst.row\[27\]\[2\]
+ _0135_ sg13g2_dfrbpq_1
X_4001_ _1703_ _1706_ _1707_ _1710_ _1712_ VPWR VGND sg13g2_nor4_1
XFILLER_1_95 VPWR VGND sg13g2_decap_8
X_4903_ net424 VGND VPWR _0364_ green\[6\] net647 sg13g2_dfrbpq_2
XFILLER_34_830 VPWR VGND sg13g2_fill_1
XFILLER_33_340 VPWR VGND sg13g2_fill_2
XFILLER_33_351 VPWR VGND sg13g2_decap_8
XFILLER_33_373 VPWR VGND sg13g2_fill_1
X_4834_ net128 VGND VPWR _0295_ videogen.fancy_shader.video_x\[3\] net643 sg13g2_dfrbpq_2
X_4765_ net670 net714 _0229_ VPWR VGND sg13g2_nor2_1
X_3716_ videogen.test_lut_thingy.pixel_feeder_inst.row\[36\]\[1\] net575 _1434_ VPWR
+ VGND sg13g2_nor2_1
X_4696_ net676 net720 _0160_ VPWR VGND sg13g2_nor2_1
X_5050__150 VPWR VGND net150 sg13g2_tiehi
X_3647_ videogen.test_lut_thingy.pixel_feeder_inst.row\[26\]\[2\] net587 _1365_ VPWR
+ VGND sg13g2_nor2_1
XFILLER_20_27 VPWR VGND sg13g2_fill_1
X_3578_ videogen.test_lut_thingy.pixel_feeder_inst.row\[24\]\[3\] net577 _1296_ VPWR
+ VGND sg13g2_nor2_1
XFILLER_1_918 VPWR VGND sg13g2_decap_8
Xhold14 serialize.shift_reg_r\[7\] VPWR VGND net460 sg13g2_dlygate4sd3_1
XFILLER_29_58 VPWR VGND sg13g2_fill_1
Xhold36 _0622_ VPWR VGND net482 sg13g2_dlygate4sd3_1
Xhold25 serialize.shift_reg_r\[9\] VPWR VGND net471 sg13g2_dlygate4sd3_1
X_5179_ net138 VGND VPWR _0636_ videogen.test_lut_thingy.pixel_feeder_inst.row\[22\]\[1\]
+ _0254_ sg13g2_dfrbpq_1
XFILLER_21_1017 VPWR VGND sg13g2_decap_8
XFILLER_21_1028 VPWR VGND sg13g2_fill_1
XFILLER_44_627 VPWR VGND sg13g2_decap_4
XFILLER_25_863 VPWR VGND sg13g2_decap_8
XFILLER_40_855 VPWR VGND sg13g2_decap_8
XFILLER_40_877 VPWR VGND sg13g2_decap_8
XFILLER_8_539 VPWR VGND sg13g2_decap_4
XFILLER_48_922 VPWR VGND sg13g2_decap_8
XFILLER_0_973 VPWR VGND sg13g2_decap_8
XFILLER_48_999 VPWR VGND sg13g2_decap_8
X_4905__422 VPWR VGND net422 sg13g2_tiehi
XFILLER_34_115 VPWR VGND sg13g2_decap_8
XFILLER_37_1024 VPWR VGND sg13g2_decap_4
X_5064__81 VPWR VGND net81 sg13g2_tiehi
X_2880_ videogen.test_lut_thingy.pixel_feeder_inst.row\[60\]\[1\] net789 _0797_ _0469_
+ VPWR VGND sg13g2_mux2_1
XFILLER_31_844 VPWR VGND sg13g2_decap_8
XFILLER_11_590 VPWR VGND sg13g2_decap_4
X_4550_ net711 net746 _0016_ VPWR VGND sg13g2_nor2_1
X_3501_ _1219_ _1205_ _1211_ VPWR VGND sg13g2_xnor2_1
X_4481_ VGND VPWR _2153_ _2154_ _0619_ _2145_ sg13g2_a21oi_1
X_3432_ _1123_ _1128_ _1150_ VPWR VGND sg13g2_and2_1
X_4912__415 VPWR VGND net415 sg13g2_tiehi
X_3363_ _1080_ _1071_ _1081_ VPWR VGND sg13g2_xor2_1
XFILLER_44_1028 VPWR VGND sg13g2_fill_1
X_5102_ net305 VGND VPWR _0559_ videogen.test_lut_thingy.pixel_feeder_inst.row\[46\]\[2\]
+ _0187_ sg13g2_dfrbpq_1
X_3294_ _1011_ _1004_ _1012_ VPWR VGND sg13g2_xor2_1
X_5033_ net202 VGND VPWR _0490_ green_tmds_par\[8\] net654 sg13g2_dfrbpq_1
XFILLER_38_465 VPWR VGND sg13g2_fill_1
XFILLER_25_115 VPWR VGND sg13g2_fill_1
XFILLER_40_107 VPWR VGND sg13g2_decap_4
XFILLER_22_822 VPWR VGND sg13g2_decap_8
XFILLER_34_682 VPWR VGND sg13g2_decap_8
X_4817_ net157 VGND VPWR _0278_ videogen.test_lut_thingy.pixel_feeder_inst.row\[1\]\[0\]
+ _0009_ sg13g2_dfrbpq_1
XFILLER_22_899 VPWR VGND sg13g2_decap_8
X_4748_ net680 net724 _0212_ VPWR VGND sg13g2_nor2_1
X_4679_ net686 net730 _0143_ VPWR VGND sg13g2_nor2_1
Xoutput15 net15 uo_out[2] VPWR VGND sg13g2_buf_1
XFILLER_0_236 VPWR VGND sg13g2_decap_8
XFILLER_0_269 VPWR VGND sg13g2_decap_8
XFILLER_5_1022 VPWR VGND sg13g2_decap_8
XFILLER_29_421 VPWR VGND sg13g2_decap_8
XFILLER_29_432 VPWR VGND sg13g2_fill_1
XFILLER_17_627 VPWR VGND sg13g2_decap_8
XFILLER_45_958 VPWR VGND sg13g2_decap_8
XFILLER_44_424 VPWR VGND sg13g2_decap_4
XFILLER_16_148 VPWR VGND sg13g2_fill_2
XFILLER_12_354 VPWR VGND sg13g2_fill_2
XFILLER_40_696 VPWR VGND sg13g2_fill_1
X_5150__380 VPWR VGND net380 sg13g2_tiehi
XFILLER_4_553 VPWR VGND sg13g2_decap_8
X_5209__148 VPWR VGND net148 sg13g2_tiehi
XFILLER_0_770 VPWR VGND sg13g2_decap_8
XFILLER_35_402 VPWR VGND sg13g2_fill_1
XFILLER_35_413 VPWR VGND sg13g2_decap_4
XFILLER_36_947 VPWR VGND sg13g2_decap_8
XFILLER_47_295 VPWR VGND sg13g2_decap_8
X_3981_ _1093_ _1691_ _1692_ VPWR VGND sg13g2_nor2b_1
X_2932_ videogen.test_lut_thingy.pixel_feeder_inst.row\[9\]\[2\] net781 _0810_ _0430_
+ VPWR VGND sg13g2_mux2_1
XFILLER_31_630 VPWR VGND sg13g2_fill_1
X_2863_ net761 videogen.test_lut_thingy.pixel_feeder_inst.row\[57\]\[3\] _0794_ _0483_
+ VPWR VGND sg13g2_mux2_1
X_4602_ net703 net747 _0066_ VPWR VGND sg13g2_nor2_1
X_2794_ videogen.test_lut_thingy.pixel_feeder_inst.row\[48\]\[2\] net775 _0780_ _0547_
+ VPWR VGND sg13g2_mux2_1
X_4533_ _2181_ net659 net459 net663 red_tmds_par\[6\] VPWR VGND sg13g2_a22oi_1
XFILLER_11_1027 VPWR VGND sg13g2_fill_2
X_4464_ net809 _2141_ _0613_ VPWR VGND sg13g2_and2_1
X_3415_ _1130_ _1131_ _1128_ _1133_ VPWR VGND sg13g2_nand3_1
Xfanout805 ui_in[4] net805 VPWR VGND sg13g2_buf_8
X_4395_ net606 blue\[1\] _2076_ VPWR VGND sg13g2_nor2_1
X_3346_ _1019_ _1022_ _1064_ VPWR VGND sg13g2_nor2_1
XFILLER_39_763 VPWR VGND sg13g2_fill_2
XFILLER_39_741 VPWR VGND sg13g2_fill_1
X_3277_ videogen.fancy_shader.video_y\[2\] videogen.fancy_shader.shader_counter_reg\[2\]
+ _0995_ VPWR VGND sg13g2_and2_1
X_5016_ net234 VGND VPWR _0473_ videogen.test_lut_thingy.pixel_feeder_inst.row\[5\]\[1\]
+ _0110_ sg13g2_dfrbpq_1
XFILLER_27_947 VPWR VGND sg13g2_decap_8
XFILLER_42_906 VPWR VGND sg13g2_decap_8
XFILLER_41_405 VPWR VGND sg13g2_fill_1
XFILLER_26_59 VPWR VGND sg13g2_decap_8
X_4806__172 VPWR VGND net172 sg13g2_tiehi
XFILLER_22_630 VPWR VGND sg13g2_fill_1
XFILLER_10_869 VPWR VGND sg13g2_decap_4
X_4813__165 VPWR VGND net165 sg13g2_tiehi
X_4930__389 VPWR VGND net389 sg13g2_tiehi
XFILLER_49_516 VPWR VGND sg13g2_decap_8
XFILLER_44_265 VPWR VGND sg13g2_fill_1
XFILLER_17_457 VPWR VGND sg13g2_decap_8
XFILLER_44_298 VPWR VGND sg13g2_decap_8
XFILLER_16_70 VPWR VGND sg13g2_fill_2
X_4902__425 VPWR VGND net425 sg13g2_tiehi
XFILLER_41_950 VPWR VGND sg13g2_decap_8
XFILLER_34_1005 VPWR VGND sg13g2_decap_8
XFILLER_13_663 VPWR VGND sg13g2_decap_8
XFILLER_8_188 VPWR VGND sg13g2_fill_1
XFILLER_9_689 VPWR VGND sg13g2_fill_1
XFILLER_5_840 VPWR VGND sg13g2_decap_4
XFILLER_4_394 VPWR VGND sg13g2_decap_4
X_3200_ videogen.fancy_shader.shader_counter_reg\[2\] _0939_ _0943_ VPWR VGND sg13g2_and2_1
X_4180_ _1885_ VPWR _1886_ VGND _1882_ _1884_ sg13g2_o21ai_1
X_3131_ VGND VPWR _0896_ videogen.test_lut_thingy.pixel_feeder_inst.v_counter\[0\]
+ videogen.test_lut_thingy.pixel_feeder_inst.v_counter\[1\] sg13g2_or2_1
X_3062_ _0865_ videogen.test_lut_thingy.pixel_feeder_inst.v_pix\[3\] _0862_ VPWR VGND
+ sg13g2_xnor2_1
XFILLER_24_928 VPWR VGND sg13g2_decap_8
XFILLER_36_788 VPWR VGND sg13g2_decap_4
XFILLER_17_991 VPWR VGND sg13g2_decap_8
X_3964_ _1675_ _0988_ _1007_ VPWR VGND sg13g2_nand2_2
XFILLER_32_961 VPWR VGND sg13g2_decap_8
X_2915_ _0769_ _0803_ _0807_ VPWR VGND sg13g2_nor2_2
X_3895_ _1609_ _1598_ _1602_ VPWR VGND sg13g2_nand2_1
X_2846_ videogen.test_lut_thingy.pixel_feeder_inst.row\[27\]\[0\] net797 _0790_ _0505_
+ VPWR VGND sg13g2_mux2_1
X_5186__47 VPWR VGND net47 sg13g2_tiehi
X_2777_ _0756_ _0765_ _0777_ VPWR VGND sg13g2_nor2_2
X_4516_ VPWR _0652_ _2172_ VGND sg13g2_inv_1
X_4447_ _2066_ _2122_ _2127_ VPWR VGND sg13g2_nor2b_1
Xfanout602 _0679_ net602 VPWR VGND sg13g2_buf_8
Xfanout613 videogen.fancy_shader.video_y\[0\] net613 VPWR VGND sg13g2_buf_8
Xfanout624 net626 net624 VPWR VGND sg13g2_buf_8
X_4378_ tmds_blue.dc_balancing_reg\[1\] tmds_blue.dc_balancing_reg\[0\] tmds_blue.dc_balancing_reg\[3\]
+ _2060_ VGND VPWR tmds_blue.dc_balancing_reg\[2\] sg13g2_nor4_2
Xfanout635 videogen.fancy_shader.video_x\[7\] net635 VPWR VGND sg13g2_buf_8
Xfanout657 clk_video net657 VPWR VGND sg13g2_buf_8
Xfanout646 net648 net646 VPWR VGND sg13g2_buf_8
Xfanout668 net673 net668 VPWR VGND sg13g2_buf_8
X_3329_ _1047_ net612 videogen.fancy_shader.shader_counter_reg\[5\] VPWR VGND sg13g2_nand2_1
Xfanout679 net692 net679 VPWR VGND sg13g2_buf_8
XFILLER_37_14 VPWR VGND sg13g2_fill_2
XFILLER_27_777 VPWR VGND sg13g2_decap_8
XFILLER_26_298 VPWR VGND sg13g2_fill_2
XFILLER_41_246 VPWR VGND sg13g2_decap_8
X_4997__272 VPWR VGND net272 sg13g2_tiehi
XFILLER_23_972 VPWR VGND sg13g2_decap_8
XFILLER_2_865 VPWR VGND sg13g2_decap_8
XFILLER_49_302 VPWR VGND sg13g2_decap_4
XFILLER_17_276 VPWR VGND sg13g2_fill_2
XFILLER_32_268 VPWR VGND sg13g2_decap_4
X_2700_ videogen.test_lut_thingy.pixel_feeder_inst.row\[59\]\[3\] net761 _0751_ _0612_
+ VPWR VGND sg13g2_mux2_1
XFILLER_13_482 VPWR VGND sg13g2_fill_1
XFILLER_40_290 VPWR VGND sg13g2_fill_1
X_3680_ net617 VPWR _1398_ VGND videogen.test_lut_thingy.pixel_feeder_inst.row\[44\]\[2\]
+ net575 sg13g2_o21ai_1
XFILLER_9_475 VPWR VGND sg13g2_fill_1
X_2631_ videogen.fancy_shader.video_x\[1\] net637 _0702_ _0703_ VPWR VGND sg13g2_nor3_1
X_4301_ VGND VPWR net610 _1996_ _0407_ net759 sg13g2_a21oi_1
XFILLER_4_180 VPWR VGND sg13g2_fill_2
XFILLER_4_40 VPWR VGND sg13g2_decap_4
X_4232_ _1934_ _1933_ _1935_ _1937_ VPWR VGND sg13g2_a21o_1
XFILLER_4_73 VPWR VGND sg13g2_decap_8
X_4163_ _1869_ net809 _0368_ _0367_ VPWR VGND sg13g2_a21o_1
X_4094_ net543 _1804_ _1805_ VPWR VGND sg13g2_and2_1
X_3114_ VGND VPWR net636 _0834_ _0885_ videogen.fancy_shader.video_x\[5\] sg13g2_a21oi_1
XFILLER_28_519 VPWR VGND sg13g2_decap_4
X_3045_ _0851_ videogen.fancy_shader.video_y\[1\] net613 VPWR VGND sg13g2_nand2_1
XFILLER_36_552 VPWR VGND sg13g2_fill_1
X_4996_ net274 VGND VPWR _0453_ videogen.test_lut_thingy.pixel_feeder_inst.row\[8\]\[1\]
+ _0090_ sg13g2_dfrbpq_1
XFILLER_24_769 VPWR VGND sg13g2_decap_8
X_3947_ _1657_ _1659_ _1660_ _1661_ VPWR VGND sg13g2_nor3_1
X_4803__175 VPWR VGND net175 sg13g2_tiehi
XFILLER_32_791 VPWR VGND sg13g2_decap_4
X_3878_ _1052_ _1058_ _1582_ _1592_ VPWR VGND sg13g2_nor3_2
XFILLER_20_975 VPWR VGND sg13g2_decap_8
X_2829_ videogen.test_lut_thingy.pixel_feeder_inst.row\[55\]\[2\] net778 _0787_ _0519_
+ VPWR VGND sg13g2_mux2_1
XFILLER_2_117 VPWR VGND sg13g2_fill_1
XFILLER_48_35 VPWR VGND sg13g2_decap_8
XFILLER_24_1026 VPWR VGND sg13g2_fill_2
X_4810__168 VPWR VGND net168 sg13g2_tiehi
XFILLER_42_555 VPWR VGND sg13g2_decap_8
XFILLER_15_758 VPWR VGND sg13g2_fill_1
XFILLER_7_913 VPWR VGND sg13g2_decap_8
XFILLER_11_964 VPWR VGND sg13g2_decap_8
XFILLER_13_60 VPWR VGND sg13g2_fill_2
XFILLER_49_121 VPWR VGND sg13g2_decap_8
XFILLER_49_187 VPWR VGND sg13g2_decap_8
XFILLER_49_176 VPWR VGND sg13g2_fill_2
XFILLER_18_585 VPWR VGND sg13g2_decap_8
XFILLER_18_596 VPWR VGND sg13g2_fill_1
X_4850_ net104 VGND VPWR _0311_ videogen.test_lut_thingy.pixel_feeder_inst.h_pix\[2\]
+ net639 sg13g2_dfrbpq_1
X_3801_ _0689_ _1471_ _1518_ _1519_ VPWR VGND sg13g2_nor3_1
X_4781_ net685 net729 _0243_ VPWR VGND sg13g2_nor2_1
X_3732_ videogen.test_lut_thingy.pixel_feeder_inst.row\[55\]\[1\] net566 _1450_ VPWR
+ VGND sg13g2_nor2_1
X_3663_ videogen.test_lut_thingy.pixel_feeder_inst.row\[48\]\[2\] net577 _1381_ VPWR
+ VGND sg13g2_nor2_1
X_5037__198 VPWR VGND net198 sg13g2_tiehi
X_2614_ VPWR _0687_ tmds_red.dc_balancing_reg\[2\] VGND sg13g2_inv_1
XFILLER_6_990 VPWR VGND sg13g2_decap_8
X_3594_ net625 VPWR _1312_ VGND videogen.test_lut_thingy.pixel_feeder_inst.row\[6\]\[3\]
+ net592 sg13g2_o21ai_1
XFILLER_47_1026 VPWR VGND sg13g2_fill_2
X_5195_ net360 VGND VPWR _0652_ serialize.shift_reg_g\[5\] clknet_3_7__leaf_clk_regs
+ sg13g2_dfrbpq_1
X_4215_ _1921_ _1917_ tmds_red.dc_balancing_reg\[4\] VPWR VGND sg13g2_nand2b_1
X_4146_ _1843_ _1856_ _1857_ VPWR VGND sg13g2_nor2_1
XFILLER_28_327 VPWR VGND sg13g2_decap_8
X_4077_ _1786_ _1787_ _1784_ _1788_ VPWR VGND sg13g2_nand3_1
XFILLER_37_883 VPWR VGND sg13g2_fill_2
X_3028_ net757 videogen.test_lut_thingy.pixel_feeder_inst.state\[0\] _0842_ VPWR VGND
+ sg13g2_nor2_2
XFILLER_36_371 VPWR VGND sg13g2_decap_8
XFILLER_12_706 VPWR VGND sg13g2_decap_8
XFILLER_12_717 VPWR VGND sg13g2_decap_8
XFILLER_24_577 VPWR VGND sg13g2_decap_8
X_4979_ net308 VGND VPWR _0436_ videogen.test_lut_thingy.pixel_feeder_inst.row\[30\]\[0\]
+ _0073_ sg13g2_dfrbpq_1
XFILLER_24_599 VPWR VGND sg13g2_fill_1
Xclkload3 VPWR clkload3/Y clknet_3_3__leaf_clk_regs VGND sg13g2_inv_1
XFILLER_20_772 VPWR VGND sg13g2_fill_1
XFILLER_8_1020 VPWR VGND sg13g2_decap_8
XFILLER_47_603 VPWR VGND sg13g2_decap_8
XFILLER_47_614 VPWR VGND sg13g2_fill_1
XFILLER_19_305 VPWR VGND sg13g2_fill_1
XFILLER_47_647 VPWR VGND sg13g2_decap_8
XFILLER_19_338 VPWR VGND sg13g2_fill_1
XFILLER_43_820 VPWR VGND sg13g2_fill_2
XFILLER_15_577 VPWR VGND sg13g2_decap_8
XFILLER_42_374 VPWR VGND sg13g2_fill_2
XFILLER_30_547 VPWR VGND sg13g2_fill_1
XFILLER_10_271 VPWR VGND sg13g2_fill_1
XFILLER_7_776 VPWR VGND sg13g2_decap_8
XFILLER_3_993 VPWR VGND sg13g2_decap_8
X_4000_ _1703_ _1710_ _1711_ VPWR VGND sg13g2_nor2_1
XFILLER_27_4 VPWR VGND sg13g2_fill_2
XFILLER_38_636 VPWR VGND sg13g2_fill_1
XFILLER_37_113 VPWR VGND sg13g2_fill_2
XFILLER_38_669 VPWR VGND sg13g2_decap_4
XFILLER_1_74 VPWR VGND sg13g2_decap_4
X_4902_ net425 VGND VPWR _0363_ green\[0\] net647 sg13g2_dfrbpq_2
XFILLER_34_842 VPWR VGND sg13g2_fill_1
X_4833_ net129 VGND VPWR _0294_ videogen.fancy_shader.video_x\[2\] net643 sg13g2_dfrbpq_2
X_4764_ net690 net734 _0228_ VPWR VGND sg13g2_nor2_1
X_3715_ videogen.test_lut_thingy.pixel_feeder_inst.row\[39\]\[1\] net565 _1433_ VPWR
+ VGND sg13g2_nor2_1
X_4695_ net676 net720 _0159_ VPWR VGND sg13g2_nor2_1
X_3646_ videogen.test_lut_thingy.pixel_feeder_inst.row\[25\]\[2\] net558 _1364_ VPWR
+ VGND sg13g2_nor2_1
X_3577_ videogen.test_lut_thingy.pixel_feeder_inst.row\[27\]\[3\] net567 _1295_ VPWR
+ VGND sg13g2_nor2_1
XFILLER_0_418 VPWR VGND sg13g2_fill_1
Xhold15 serialize.shift_reg_b\[8\] VPWR VGND net461 sg13g2_dlygate4sd3_1
Xhold26 serialize.shift_reg_b\[3\] VPWR VGND net472 sg13g2_dlygate4sd3_1
Xhold37 serialize.bit_cnt\[1\] VPWR VGND net483 sg13g2_dlygate4sd3_1
X_5178_ net156 VGND VPWR _0635_ videogen.test_lut_thingy.pixel_feeder_inst.row\[22\]\[0\]
+ _0253_ sg13g2_dfrbpq_1
XFILLER_29_625 VPWR VGND sg13g2_decap_8
X_4129_ VGND VPWR _1840_ _1825_ _1790_ sg13g2_or2_1
XFILLER_25_820 VPWR VGND sg13g2_fill_2
X_4926__394 VPWR VGND net394 sg13g2_tiehi
XFILLER_24_341 VPWR VGND sg13g2_fill_1
XFILLER_12_514 VPWR VGND sg13g2_decap_8
XFILLER_12_558 VPWR VGND sg13g2_decap_4
XFILLER_3_278 VPWR VGND sg13g2_decap_8
XFILLER_48_901 VPWR VGND sg13g2_decap_8
XFILLER_0_952 VPWR VGND sg13g2_decap_8
XFILLER_48_978 VPWR VGND sg13g2_decap_8
XFILLER_47_455 VPWR VGND sg13g2_fill_2
XFILLER_19_135 VPWR VGND sg13g2_fill_2
XFILLER_19_168 VPWR VGND sg13g2_decap_4
XFILLER_16_831 VPWR VGND sg13g2_decap_8
XFILLER_34_138 VPWR VGND sg13g2_fill_1
XFILLER_34_149 VPWR VGND sg13g2_fill_1
X_4940__369 VPWR VGND net369 sg13g2_tiehi
XFILLER_37_1003 VPWR VGND sg13g2_decap_8
XFILLER_15_341 VPWR VGND sg13g2_decap_8
X_4823__145 VPWR VGND net145 sg13g2_tiehi
XFILLER_43_683 VPWR VGND sg13g2_fill_2
XFILLER_42_160 VPWR VGND sg13g2_fill_1
XFILLER_15_385 VPWR VGND sg13g2_fill_1
X_5177__186 VPWR VGND net186 sg13g2_tiehi
XFILLER_31_878 VPWR VGND sg13g2_decap_8
X_3500_ VGND VPWR _1214_ _1216_ _1218_ _1217_ sg13g2_a21oi_1
X_4480_ _0688_ _2152_ _2154_ VPWR VGND sg13g2_nor2_1
X_3431_ _1147_ _1146_ _1144_ _1149_ VPWR VGND sg13g2_a21o_1
X_3362_ _1080_ _1078_ _1079_ VPWR VGND sg13g2_xnor2_1
XFILLER_44_1007 VPWR VGND sg13g2_decap_8
XFILLER_3_790 VPWR VGND sg13g2_fill_2
X_5101_ net309 VGND VPWR _0558_ videogen.test_lut_thingy.pixel_feeder_inst.row\[46\]\[1\]
+ _0186_ sg13g2_dfrbpq_1
X_3293_ VGND VPWR videogen.fancy_shader.video_x\[2\] videogen.fancy_shader.shader_counter_reg\[2\]
+ _1011_ _1010_ sg13g2_a21oi_1
X_5032_ net203 VGND VPWR _0489_ green_tmds_par\[6\] net654 sg13g2_dfrbpq_1
XFILLER_39_989 VPWR VGND sg13g2_decap_8
XFILLER_26_617 VPWR VGND sg13g2_decap_8
XFILLER_22_801 VPWR VGND sg13g2_decap_8
XFILLER_40_119 VPWR VGND sg13g2_fill_2
X_4816_ net159 VGND VPWR _0277_ videogen.test_lut_thingy.pixel_feeder_inst.row\[20\]\[3\]
+ _0008_ sg13g2_dfrbpq_1
XFILLER_22_878 VPWR VGND sg13g2_decap_8
X_4747_ net680 net724 _0211_ VPWR VGND sg13g2_nor2_1
X_4678_ net685 net729 _0142_ VPWR VGND sg13g2_nor2_1
X_3629_ videogen.test_lut_thingy.pixel_feeder_inst.row\[9\]\[2\] net562 _1347_ VPWR
+ VGND sg13g2_nor2_1
Xoutput16 net16 uo_out[3] VPWR VGND sg13g2_buf_1
XFILLER_5_1001 VPWR VGND sg13g2_decap_8
X_4846__112 VPWR VGND net112 sg13g2_tiehi
XFILLER_45_937 VPWR VGND sg13g2_decap_8
XFILLER_44_469 VPWR VGND sg13g2_decap_8
XFILLER_44_458 VPWR VGND sg13g2_fill_2
XFILLER_12_300 VPWR VGND sg13g2_decap_8
XFILLER_12_311 VPWR VGND sg13g2_fill_1
XFILLER_13_812 VPWR VGND sg13g2_fill_1
XFILLER_24_160 VPWR VGND sg13g2_decap_8
XFILLER_12_322 VPWR VGND sg13g2_fill_2
X_3980_ _1061_ _1690_ _1691_ VPWR VGND sg13g2_nor2b_1
X_2931_ videogen.test_lut_thingy.pixel_feeder_inst.row\[9\]\[3\] net770 _0810_ _0431_
+ VPWR VGND sg13g2_mux2_1
XFILLER_15_171 VPWR VGND sg13g2_fill_2
Xclkbuf_0_clk clk clknet_0_clk VPWR VGND sg13g2_buf_8
X_4601_ net703 net747 _0065_ VPWR VGND sg13g2_nor2_1
X_2862_ _0743_ _0747_ net603 _0794_ VPWR VGND sg13g2_nand3_1
X_2793_ videogen.test_lut_thingy.pixel_feeder_inst.row\[48\]\[3\] net763 _0780_ _0548_
+ VPWR VGND sg13g2_mux2_1
XFILLER_11_1006 VPWR VGND sg13g2_decap_8
X_4532_ VPWR _0660_ _2180_ VGND sg13g2_inv_1
X_4463_ _2139_ VPWR _2141_ VGND _2067_ _2140_ sg13g2_o21ai_1
XFILLER_7_392 VPWR VGND sg13g2_decap_8
X_3414_ _1130_ _1131_ _1132_ VPWR VGND sg13g2_and2_1
X_4394_ net555 _2074_ _2075_ _0493_ VPWR VGND sg13g2_nor3_1
Xfanout806 net807 net806 VPWR VGND sg13g2_buf_8
X_3345_ videogen.fancy_shader.video_x\[8\] videogen.fancy_shader.shader_counter_reg\[8\]
+ _1063_ VPWR VGND sg13g2_and2_1
X_3276_ videogen.fancy_shader.shader_counter_reg\[3\] videogen.fancy_shader.video_y\[3\]
+ _0994_ VPWR VGND sg13g2_xor2_1
X_5015_ net236 VGND VPWR _0472_ videogen.test_lut_thingy.pixel_feeder_inst.row\[5\]\[0\]
+ _0109_ sg13g2_dfrbpq_1
XFILLER_38_263 VPWR VGND sg13g2_decap_8
XFILLER_27_904 VPWR VGND sg13g2_decap_8
XFILLER_27_937 VPWR VGND sg13g2_decap_4
XFILLER_38_274 VPWR VGND sg13g2_fill_2
XFILLER_26_16 VPWR VGND sg13g2_decap_8
XFILLER_26_469 VPWR VGND sg13g2_fill_1
XFILLER_35_981 VPWR VGND sg13g2_decap_8
XFILLER_21_141 VPWR VGND sg13g2_decap_8
XFILLER_21_152 VPWR VGND sg13g2_fill_1
XFILLER_27_1024 VPWR VGND sg13g2_decap_4
XFILLER_29_230 VPWR VGND sg13g2_fill_1
XFILLER_45_734 VPWR VGND sg13g2_decap_4
XFILLER_17_436 VPWR VGND sg13g2_decap_4
XFILLER_18_959 VPWR VGND sg13g2_decap_8
XFILLER_44_244 VPWR VGND sg13g2_decap_8
XFILLER_44_233 VPWR VGND sg13g2_fill_1
XFILLER_25_491 VPWR VGND sg13g2_fill_2
XFILLER_40_472 VPWR VGND sg13g2_decap_4
XFILLER_34_1028 VPWR VGND sg13g2_fill_1
X_4939__371 VPWR VGND net371 sg13g2_tiehi
XFILLER_40_494 VPWR VGND sg13g2_decap_4
XFILLER_40_483 VPWR VGND sg13g2_decap_8
XFILLER_8_167 VPWR VGND sg13g2_decap_8
XFILLER_8_156 VPWR VGND sg13g2_fill_2
XFILLER_5_830 VPWR VGND sg13g2_fill_2
XFILLER_4_384 VPWR VGND sg13g2_decap_4
X_3130_ _0894_ _0895_ VPWR VGND sg13g2_inv_4
X_3061_ _0857_ _0864_ net18 VPWR VGND sg13g2_nor2b_1
XFILLER_36_734 VPWR VGND sg13g2_fill_2
XFILLER_24_907 VPWR VGND sg13g2_decap_8
XFILLER_17_970 VPWR VGND sg13g2_decap_8
XFILLER_16_480 VPWR VGND sg13g2_fill_1
X_3963_ _1674_ _1156_ _1673_ VPWR VGND sg13g2_nand2_1
XFILLER_32_940 VPWR VGND sg13g2_decap_8
XFILLER_35_299 VPWR VGND sg13g2_fill_2
X_2914_ videogen.test_lut_thingy.pixel_feeder_inst.row\[11\]\[0\] net803 _0806_ _0444_
+ VPWR VGND sg13g2_mux2_1
X_3894_ _1594_ _1605_ _1608_ VPWR VGND sg13g2_nor2_1
X_2845_ videogen.test_lut_thingy.pixel_feeder_inst.row\[27\]\[1\] net787 _0790_ _0506_
+ VPWR VGND sg13g2_mux2_1
XFILLER_31_472 VPWR VGND sg13g2_fill_2
X_4515_ _2172_ net660 net465 net665 green_tmds_par\[1\] VPWR VGND sg13g2_a22oi_1
X_2776_ videogen.test_lut_thingy.pixel_feeder_inst.row\[45\]\[0\] net794 _0776_ _0561_
+ VPWR VGND sg13g2_mux2_1
X_4446_ _2126_ _2123_ _2125_ VPWR VGND sg13g2_xnor2_1
X_4377_ tmds_blue.dc_balancing_reg\[0\] net554 _0492_ VPWR VGND sg13g2_and2_1
Xfanout603 videogen.mem_read net603 VPWR VGND sg13g2_buf_8
Xfanout614 videogen.test_lut_thingy.pixel_feeder_inst.h_pix\[5\] net614 VPWR VGND
+ sg13g2_buf_8
Xfanout658 net662 net658 VPWR VGND sg13g2_buf_8
X_3328_ net612 videogen.fancy_shader.shader_counter_reg\[5\] _1046_ VPWR VGND sg13g2_and2_1
Xfanout636 videogen.fancy_shader.video_x\[4\] net636 VPWR VGND sg13g2_buf_8
Xfanout625 net626 net625 VPWR VGND sg13g2_buf_8
Xfanout647 net648 net647 VPWR VGND sg13g2_buf_8
Xfanout669 net673 net669 VPWR VGND sg13g2_buf_1
X_3259_ net808 VPWR _0981_ VGND videogen.test_lut_thingy.gol_counter_reg\[0\] videogen.test_lut_thingy.gol_counter_reg\[1\]
+ sg13g2_o21ai_1
XFILLER_2_1026 VPWR VGND sg13g2_fill_2
XFILLER_27_723 VPWR VGND sg13g2_decap_8
XFILLER_23_951 VPWR VGND sg13g2_decap_8
XFILLER_10_612 VPWR VGND sg13g2_fill_2
XFILLER_6_627 VPWR VGND sg13g2_fill_2
XFILLER_6_605 VPWR VGND sg13g2_fill_1
XFILLER_5_148 VPWR VGND sg13g2_decap_4
XFILLER_2_844 VPWR VGND sg13g2_decap_8
XFILLER_49_325 VPWR VGND sg13g2_decap_4
XFILLER_18_745 VPWR VGND sg13g2_decap_4
XFILLER_18_778 VPWR VGND sg13g2_decap_8
XFILLER_33_737 VPWR VGND sg13g2_decap_8
X_5002__262 VPWR VGND net262 sg13g2_tiehi
XFILLER_32_225 VPWR VGND sg13g2_fill_2
XFILLER_9_410 VPWR VGND sg13g2_decap_4
XFILLER_14_984 VPWR VGND sg13g2_decap_8
XFILLER_41_792 VPWR VGND sg13g2_fill_1
XFILLER_13_494 VPWR VGND sg13g2_decap_4
X_2630_ VGND VPWR _0702_ videogen.fancy_shader.video_x\[5\] videogen.fancy_shader.video_x\[6\]
+ sg13g2_or2_1
XFILLER_9_454 VPWR VGND sg13g2_decap_8
XFILLER_9_498 VPWR VGND sg13g2_decap_8
X_4300_ _1996_ red\[2\] _1987_ VPWR VGND sg13g2_xnor2_1
X_4231_ VPWR _1936_ _1935_ VGND sg13g2_inv_1
X_4162_ VGND VPWR _1862_ _1867_ _0368_ net760 sg13g2_a21oi_1
X_4093_ VPWR VGND net543 _1799_ _1797_ _1794_ _1804_ _1795_ sg13g2_a221oi_1
X_3113_ _0296_ net806 _0835_ _0884_ VPWR VGND sg13g2_and3_1
X_3044_ videogen.fancy_shader.video_y\[1\] net613 _0850_ VPWR VGND sg13g2_and2_1
XFILLER_36_520 VPWR VGND sg13g2_fill_1
XFILLER_24_704 VPWR VGND sg13g2_fill_1
XFILLER_23_214 VPWR VGND sg13g2_fill_1
X_4995_ net276 VGND VPWR _0452_ videogen.test_lut_thingy.pixel_feeder_inst.row\[8\]\[0\]
+ _0089_ sg13g2_dfrbpq_1
XFILLER_24_748 VPWR VGND sg13g2_fill_2
XFILLER_17_1012 VPWR VGND sg13g2_decap_8
X_3946_ _1644_ _1646_ _1660_ VPWR VGND sg13g2_nor2_1
X_3877_ _1590_ net549 _1591_ VPWR VGND sg13g2_xor2_1
XFILLER_20_954 VPWR VGND sg13g2_decap_8
X_2828_ videogen.test_lut_thingy.pixel_feeder_inst.row\[55\]\[3\] net767 _0787_ _0520_
+ VPWR VGND sg13g2_mux2_1
X_2759_ _0750_ _0765_ _0771_ VPWR VGND sg13g2_nor2_2
X_4429_ _2082_ VPWR _2109_ VGND _0690_ _2081_ sg13g2_o21ai_1
XFILLER_48_14 VPWR VGND sg13g2_decap_8
XFILLER_24_1005 VPWR VGND sg13g2_decap_8
XFILLER_46_339 VPWR VGND sg13g2_decap_8
XFILLER_9_19 VPWR VGND sg13g2_decap_4
XFILLER_11_943 VPWR VGND sg13g2_decap_8
XFILLER_23_781 VPWR VGND sg13g2_decap_8
XFILLER_6_424 VPWR VGND sg13g2_decap_8
XFILLER_10_464 VPWR VGND sg13g2_fill_2
XFILLER_10_475 VPWR VGND sg13g2_decap_4
XFILLER_7_969 VPWR VGND sg13g2_decap_8
XFILLER_10_497 VPWR VGND sg13g2_decap_8
XFILLER_49_100 VPWR VGND sg13g2_decap_8
XFILLER_1_184 VPWR VGND sg13g2_decap_4
XFILLER_38_80 VPWR VGND sg13g2_fill_2
XFILLER_18_553 VPWR VGND sg13g2_decap_8
XFILLER_46_884 VPWR VGND sg13g2_decap_8
X_4780_ net685 net729 _0242_ VPWR VGND sg13g2_nor2_1
X_3800_ videogen.test_lut_thingy.pixel_feeder_inst.h_pix\[5\] _1494_ _1517_ _1518_
+ VPWR VGND sg13g2_nor3_1
XFILLER_14_781 VPWR VGND sg13g2_decap_4
X_3731_ net621 VPWR _1449_ VGND videogen.test_lut_thingy.pixel_feeder_inst.row\[52\]\[1\]
+ net575 sg13g2_o21ai_1
X_3662_ net600 VPWR _1380_ VGND videogen.test_lut_thingy.pixel_feeder_inst.row\[51\]\[2\]
+ net567 sg13g2_o21ai_1
X_3593_ net601 _1305_ _1310_ _1311_ VPWR VGND sg13g2_nor3_1
X_2613_ VPWR _0686_ tmds_red.dc_balancing_reg\[1\] VGND sg13g2_inv_1
XFILLER_47_1005 VPWR VGND sg13g2_decap_8
XFILLER_48_0 VPWR VGND sg13g2_decap_8
X_5194_ net368 VGND VPWR _0651_ serialize.shift_reg_g\[4\] clknet_3_7__leaf_clk_regs
+ sg13g2_dfrbpq_1
X_4214_ _1920_ _1919_ VPWR VGND sg13g2_inv_2
X_4145_ _0992_ _1850_ _1157_ _1856_ VPWR VGND sg13g2_mux2_1
XFILLER_29_818 VPWR VGND sg13g2_decap_8
XFILLER_29_829 VPWR VGND sg13g2_fill_1
X_4076_ _1756_ VPWR _1787_ VGND _1766_ _1785_ sg13g2_o21ai_1
X_3027_ VGND VPWR net595 _0841_ _0003_ net757 sg13g2_a21oi_1
XFILLER_36_361 VPWR VGND sg13g2_fill_2
X_4978_ net310 VGND VPWR _0435_ videogen.test_lut_thingy.pixel_feeder_inst.row\[31\]\[3\]
+ _0072_ sg13g2_dfrbpq_1
Xclkload4 clknet_3_4__leaf_clk_regs clkload4/X VPWR VGND sg13g2_buf_1
X_3929_ VGND VPWR _1630_ _1636_ _1643_ _1628_ sg13g2_a21oi_1
XFILLER_20_740 VPWR VGND sg13g2_decap_8
X_4966__334 VPWR VGND net334 sg13g2_tiehi
XFILLER_47_626 VPWR VGND sg13g2_decap_8
XFILLER_46_136 VPWR VGND sg13g2_fill_2
XFILLER_46_169 VPWR VGND sg13g2_fill_2
XFILLER_15_567 VPWR VGND sg13g2_fill_1
XFILLER_24_82 VPWR VGND sg13g2_decap_4
XFILLER_10_250 VPWR VGND sg13g2_decap_8
XFILLER_40_70 VPWR VGND sg13g2_fill_2
XFILLER_41_7 VPWR VGND sg13g2_fill_2
XFILLER_3_972 VPWR VGND sg13g2_decap_8
XFILLER_1_42 VPWR VGND sg13g2_decap_4
XFILLER_37_147 VPWR VGND sg13g2_decap_8
XFILLER_19_862 VPWR VGND sg13g2_fill_2
XFILLER_19_884 VPWR VGND sg13g2_decap_8
XFILLER_37_169 VPWR VGND sg13g2_decap_8
XFILLER_18_394 VPWR VGND sg13g2_decap_8
X_4901_ net426 VGND VPWR _0362_ blue\[7\] net646 sg13g2_dfrbpq_2
X_4832_ net130 VGND VPWR _0293_ videogen.fancy_shader.video_x\[1\] net644 sg13g2_dfrbpq_2
X_4763_ net691 net735 _0227_ VPWR VGND sg13g2_nor2_1
XFILLER_14_1026 VPWR VGND sg13g2_fill_2
X_4694_ net677 net721 _0158_ VPWR VGND sg13g2_nor2_1
X_3714_ videogen.test_lut_thingy.pixel_feeder_inst.row\[37\]\[1\] net556 _1432_ VPWR
+ VGND sg13g2_nor2_1
X_3645_ videogen.test_lut_thingy.pixel_feeder_inst.row\[27\]\[2\] net567 _1363_ VPWR
+ VGND sg13g2_nor2_1
X_3576_ net596 VPWR _1294_ VGND videogen.test_lut_thingy.pixel_feeder_inst.row\[26\]\[3\]
+ net587 sg13g2_o21ai_1
Xhold27 serialize.shift_reg_b\[6\] VPWR VGND net473 sg13g2_dlygate4sd3_1
Xhold16 serialize.shift_reg_b\[9\] VPWR VGND net462 sg13g2_dlygate4sd3_1
Xhold38 serialize.bit_cnt\[2\] VPWR VGND net484 sg13g2_dlygate4sd3_1
X_5177_ net186 VGND VPWR _0634_ videogen.test_lut_thingy.pixel_feeder_inst.row\[23\]\[3\]
+ _0252_ sg13g2_dfrbpq_1
XFILLER_28_103 VPWR VGND sg13g2_fill_2
X_4128_ _1839_ _1828_ _1835_ VPWR VGND sg13g2_xnor2_1
XFILLER_28_147 VPWR VGND sg13g2_fill_2
XFILLER_45_37 VPWR VGND sg13g2_fill_2
X_4059_ _1678_ _1756_ _1770_ VPWR VGND sg13g2_nor2b_1
XFILLER_45_59 VPWR VGND sg13g2_decap_8
XFILLER_43_117 VPWR VGND sg13g2_fill_2
XFILLER_25_843 VPWR VGND sg13g2_decap_8
XFILLER_36_180 VPWR VGND sg13g2_fill_2
XFILLER_25_854 VPWR VGND sg13g2_fill_2
Xclkbuf_regs_0_clk clk clk_regs VPWR VGND sg13g2_buf_8
XFILLER_0_931 VPWR VGND sg13g2_decap_8
XFILLER_48_957 VPWR VGND sg13g2_decap_8
XFILLER_47_434 VPWR VGND sg13g2_decap_8
XFILLER_47_489 VPWR VGND sg13g2_fill_2
XFILLER_19_93 VPWR VGND sg13g2_fill_2
XFILLER_28_692 VPWR VGND sg13g2_decap_8
XFILLER_15_331 VPWR VGND sg13g2_decap_4
XFILLER_35_70 VPWR VGND sg13g2_decap_8
XFILLER_15_397 VPWR VGND sg13g2_fill_2
X_3430_ _1146_ _1147_ _1148_ VPWR VGND sg13g2_and2_1
X_3361_ videogen.fancy_shader.shader_counter_reg\[9\] videogen.fancy_shader.video_y\[9\]
+ _1079_ VPWR VGND sg13g2_xor2_1
X_5100_ net313 VGND VPWR _0557_ videogen.test_lut_thingy.pixel_feeder_inst.row\[46\]\[0\]
+ _0185_ sg13g2_dfrbpq_1
X_5031_ net204 VGND VPWR _0488_ green_tmds_par\[2\] net652 sg13g2_dfrbpq_1
X_3292_ _1009_ _1008_ _1010_ VPWR VGND sg13g2_nor2b_1
XFILLER_39_924 VPWR VGND sg13g2_decap_4
XFILLER_39_968 VPWR VGND sg13g2_decap_8
XFILLER_38_456 VPWR VGND sg13g2_fill_2
XFILLER_38_434 VPWR VGND sg13g2_decap_4
XFILLER_25_139 VPWR VGND sg13g2_fill_2
XFILLER_33_161 VPWR VGND sg13g2_decap_4
X_4815_ net161 VGND VPWR _0276_ videogen.test_lut_thingy.pixel_feeder_inst.row\[20\]\[2\]
+ _0007_ sg13g2_dfrbpq_1
XFILLER_22_857 VPWR VGND sg13g2_decap_8
X_4948__87 VPWR VGND net87 sg13g2_tiehi
X_4746_ net671 net715 _0210_ VPWR VGND sg13g2_nor2_1
X_4677_ net684 net728 _0141_ VPWR VGND sg13g2_nor2_1
X_3628_ videogen.test_lut_thingy.pixel_feeder_inst.row\[8\]\[2\] net582 _1346_ VPWR
+ VGND sg13g2_nor2_1
Xoutput17 net17 uo_out[4] VPWR VGND sg13g2_buf_1
XFILLER_0_216 VPWR VGND sg13g2_decap_8
X_3559_ VGND VPWR _1277_ _1276_ _1253_ sg13g2_or2_1
X_5204__239 VPWR VGND net239 sg13g2_tiehi
XFILLER_45_916 VPWR VGND sg13g2_decap_8
XFILLER_44_404 VPWR VGND sg13g2_fill_2
XFILLER_29_467 VPWR VGND sg13g2_decap_4
XFILLER_29_478 VPWR VGND sg13g2_fill_1
XFILLER_25_684 VPWR VGND sg13g2_fill_1
XFILLER_40_643 VPWR VGND sg13g2_fill_2
XFILLER_9_817 VPWR VGND sg13g2_decap_8
XFILLER_12_334 VPWR VGND sg13g2_fill_1
XFILLER_12_345 VPWR VGND sg13g2_fill_2
XFILLER_12_356 VPWR VGND sg13g2_fill_1
XFILLER_21_61 VPWR VGND sg13g2_fill_2
XFILLER_48_765 VPWR VGND sg13g2_fill_1
XFILLER_16_640 VPWR VGND sg13g2_fill_1
XFILLER_44_993 VPWR VGND sg13g2_decap_8
X_5040__195 VPWR VGND net195 sg13g2_tiehi
X_2930_ _0744_ _0803_ _0810_ VPWR VGND sg13g2_nor2_2
XFILLER_16_695 VPWR VGND sg13g2_decap_8
XFILLER_31_621 VPWR VGND sg13g2_decap_8
X_2861_ net801 videogen.test_lut_thingy.pixel_feeder_inst.row\[58\]\[0\] _0793_ _0484_
+ VPWR VGND sg13g2_mux2_1
X_4600_ net687 net731 _0064_ VPWR VGND sg13g2_nor2_1
X_2792_ _0740_ _0752_ _0780_ VPWR VGND sg13g2_nor2_2
X_4531_ _2180_ net661 net460 net666 red_tmds_par\[5\] VPWR VGND sg13g2_a22oi_1
X_4462_ _2140_ net609 _2062_ VPWR VGND sg13g2_nand2_1
XFILLER_7_85 VPWR VGND sg13g2_decap_8
X_5012__242 VPWR VGND net242 sg13g2_tiehi
X_3413_ _1100_ VPWR _1131_ VGND _1113_ _1129_ sg13g2_o21ai_1
X_4393_ _2063_ _2067_ _2072_ _2075_ VPWR VGND sg13g2_nor3_1
Xfanout807 net808 net807 VPWR VGND sg13g2_buf_8
X_3344_ _1062_ _1038_ _1061_ VPWR VGND sg13g2_xnor2_1
X_3275_ videogen.fancy_shader.video_y\[3\] videogen.fancy_shader.shader_counter_reg\[3\]
+ _0993_ VPWR VGND sg13g2_nor2_1
X_5014_ net238 VGND VPWR _0471_ videogen.test_lut_thingy.pixel_feeder_inst.row\[60\]\[3\]
+ _0108_ sg13g2_dfrbpq_1
XFILLER_38_231 VPWR VGND sg13g2_fill_2
XFILLER_38_286 VPWR VGND sg13g2_fill_2
XFILLER_26_426 VPWR VGND sg13g2_decap_4
XFILLER_35_960 VPWR VGND sg13g2_decap_8
XFILLER_34_492 VPWR VGND sg13g2_fill_2
XFILLER_22_665 VPWR VGND sg13g2_decap_4
XFILLER_21_197 VPWR VGND sg13g2_decap_8
XFILLER_22_698 VPWR VGND sg13g2_decap_4
X_4729_ net669 net713 _0193_ VPWR VGND sg13g2_nor2_1
XFILLER_1_525 VPWR VGND sg13g2_decap_4
XFILLER_27_1003 VPWR VGND sg13g2_decap_8
XFILLER_1_547 VPWR VGND sg13g2_decap_8
XFILLER_18_938 VPWR VGND sg13g2_decap_8
XFILLER_29_297 VPWR VGND sg13g2_fill_2
XFILLER_13_621 VPWR VGND sg13g2_decap_8
XFILLER_16_72 VPWR VGND sg13g2_fill_1
XFILLER_16_94 VPWR VGND sg13g2_decap_4
XFILLER_41_985 VPWR VGND sg13g2_decap_8
XFILLER_12_131 VPWR VGND sg13g2_fill_2
XFILLER_8_124 VPWR VGND sg13g2_decap_4
XFILLER_5_864 VPWR VGND sg13g2_decap_8
X_3060_ _0855_ VPWR _0864_ VGND _0862_ _0863_ sg13g2_o21ai_1
XFILLER_0_591 VPWR VGND sg13g2_decap_8
XFILLER_48_584 VPWR VGND sg13g2_decap_8
X_4863__78 VPWR VGND net78 sg13g2_tiehi
X_3962_ _0988_ _1155_ _1673_ VPWR VGND sg13g2_nor2_1
X_2913_ videogen.test_lut_thingy.pixel_feeder_inst.row\[11\]\[1\] net791 _0806_ _0445_
+ VPWR VGND sg13g2_mux2_1
X_3893_ _1604_ _1594_ _1603_ _1607_ VPWR VGND sg13g2_a21o_2
X_2844_ videogen.test_lut_thingy.pixel_feeder_inst.row\[27\]\[2\] net776 _0790_ _0507_
+ VPWR VGND sg13g2_mux2_1
XFILLER_32_996 VPWR VGND sg13g2_decap_8
X_4514_ VPWR _0651_ _2171_ VGND sg13g2_inv_1
XFILLER_8_691 VPWR VGND sg13g2_decap_4
X_2775_ videogen.test_lut_thingy.pixel_feeder_inst.row\[45\]\[1\] net784 _0776_ _0562_
+ VPWR VGND sg13g2_mux2_1
X_4445_ _2124_ tmds_blue.dc_balancing_reg\[4\] _2125_ VPWR VGND sg13g2_xor2_1
Xfanout604 videogen.mem_read net604 VPWR VGND sg13g2_buf_8
Xfanout615 videogen.test_lut_thingy.pixel_feeder_inst.h_pix\[4\] net615 VPWR VGND
+ sg13g2_buf_8
X_4376_ VGND VPWR net610 _1993_ _0491_ net759 sg13g2_a21oi_1
X_3327_ net612 videogen.fancy_shader.shader_counter_reg\[5\] _1045_ VPWR VGND sg13g2_nor2_1
Xfanout637 videogen.fancy_shader.video_x\[0\] net637 VPWR VGND sg13g2_buf_8
Xfanout626 videogen.test_lut_thingy.pixel_feeder_inst.h_pix\[2\] net626 VPWR VGND
+ sg13g2_buf_8
Xfanout648 net649 net648 VPWR VGND sg13g2_buf_8
Xfanout659 net662 net659 VPWR VGND sg13g2_buf_2
XFILLER_2_1005 VPWR VGND sg13g2_decap_8
X_3258_ net758 videogen.test_lut_thingy.gol_counter_reg\[0\] _0353_ VPWR VGND sg13g2_nor2_1
XFILLER_37_16 VPWR VGND sg13g2_fill_1
X_3189_ _0931_ _0935_ _0321_ VPWR VGND sg13g2_nor2_1
XFILLER_27_746 VPWR VGND sg13g2_fill_1
XFILLER_23_930 VPWR VGND sg13g2_decap_8
X_5169__259 VPWR VGND net259 sg13g2_tiehi
XFILLER_2_823 VPWR VGND sg13g2_decap_8
XFILLER_1_344 VPWR VGND sg13g2_decap_4
XFILLER_49_359 VPWR VGND sg13g2_decap_8
XFILLER_18_702 VPWR VGND sg13g2_decap_8
XFILLER_45_532 VPWR VGND sg13g2_fill_1
XFILLER_17_234 VPWR VGND sg13g2_decap_8
XFILLER_17_278 VPWR VGND sg13g2_fill_1
X_4976__314 VPWR VGND net314 sg13g2_tiehi
XFILLER_14_963 VPWR VGND sg13g2_decap_8
XFILLER_5_672 VPWR VGND sg13g2_decap_4
XFILLER_4_171 VPWR VGND sg13g2_fill_2
X_4230_ net544 _1932_ _1935_ VPWR VGND sg13g2_and2_1
X_4161_ VGND VPWR _1862_ _1871_ _0366_ net760 sg13g2_a21oi_1
X_4092_ VGND VPWR _1797_ net543 _1803_ _1799_ sg13g2_a21oi_1
X_3112_ VGND VPWR _0884_ _0834_ net636 sg13g2_or2_1
XFILLER_49_882 VPWR VGND sg13g2_decap_8
X_3043_ VGND VPWR net594 net15 _0720_ net553 sg13g2_a21oi_2
X_4994_ net278 VGND VPWR _0451_ videogen.test_lut_thingy.pixel_feeder_inst.row\[0\]\[3\]
+ _0088_ sg13g2_dfrbpq_1
X_3945_ VGND VPWR _1648_ _1651_ _1659_ _1642_ sg13g2_a21oi_1
XFILLER_23_259 VPWR VGND sg13g2_decap_4
XFILLER_20_933 VPWR VGND sg13g2_decap_8
XFILLER_31_270 VPWR VGND sg13g2_decap_8
X_3876_ _1590_ _1116_ _1587_ VPWR VGND sg13g2_nand2_1
X_2827_ _0752_ _0760_ _0787_ VPWR VGND sg13g2_nor2_2
X_2758_ videogen.test_lut_thingy.pixel_feeder_inst.row\[42\]\[0\] net794 _0770_ _0573_
+ VPWR VGND sg13g2_mux2_1
X_4428_ _2108_ _2104_ _2107_ VPWR VGND sg13g2_xnor2_1
X_2689_ _0735_ _0744_ _0745_ VPWR VGND sg13g2_nor2_2
X_4359_ VGND VPWR _2041_ _2047_ _0414_ net555 sg13g2_a21oi_1
XFILLER_24_1028 VPWR VGND sg13g2_fill_1
XFILLER_42_579 VPWR VGND sg13g2_decap_4
XFILLER_11_922 VPWR VGND sg13g2_decap_8
XFILLER_7_948 VPWR VGND sg13g2_decap_8
XFILLER_6_403 VPWR VGND sg13g2_decap_8
XFILLER_11_999 VPWR VGND sg13g2_decap_8
XFILLER_6_458 VPWR VGND sg13g2_decap_8
XFILLER_13_95 VPWR VGND sg13g2_decap_4
XFILLER_2_697 VPWR VGND sg13g2_decap_8
XFILLER_2_686 VPWR VGND sg13g2_decap_4
XFILLER_1_163 VPWR VGND sg13g2_decap_8
XFILLER_46_863 VPWR VGND sg13g2_decap_8
XFILLER_33_524 VPWR VGND sg13g2_decap_4
X_3730_ net615 _1436_ _1447_ _1448_ VPWR VGND sg13g2_nor3_1
X_3661_ _1375_ _1376_ _1377_ _1378_ _1379_ VPWR VGND sg13g2_nor4_1
X_3592_ _1306_ _1307_ _1308_ _1309_ _1310_ VPWR VGND sg13g2_nor4_1
X_2612_ _0685_ tmds_green.dc_balancing_reg\[4\] VPWR VGND sg13g2_inv_2
XFILLER_47_1028 VPWR VGND sg13g2_fill_1
XFILLER_5_491 VPWR VGND sg13g2_decap_8
X_5193_ net376 VGND VPWR _0650_ serialize.shift_reg_g\[3\] clknet_3_7__leaf_clk_regs
+ sg13g2_dfrbpq_1
X_4213_ VGND VPWR _1918_ _1919_ _1913_ tmds_red.dc_balancing_reg\[4\] sg13g2_a21oi_2
X_4144_ _0991_ _1849_ _1854_ _1855_ VPWR VGND sg13g2_or3_1
XFILLER_29_808 VPWR VGND sg13g2_fill_2
X_4075_ _1756_ _1766_ _1785_ _1786_ VPWR VGND sg13g2_or3_1
X_3026_ net806 net552 _0358_ VPWR VGND sg13g2_and2_1
XFILLER_36_395 VPWR VGND sg13g2_decap_4
XFILLER_34_39 VPWR VGND sg13g2_fill_2
X_4977_ net312 VGND VPWR _0434_ videogen.test_lut_thingy.pixel_feeder_inst.row\[31\]\[2\]
+ _0071_ sg13g2_dfrbpq_1
Xclkload5 VPWR clkload5/Y clknet_3_5__leaf_clk_regs VGND sg13g2_inv_1
X_3928_ _1641_ VPWR _1642_ VGND _1631_ _1633_ sg13g2_o21ai_1
X_3859_ _1576_ net2 _1575_ VPWR VGND sg13g2_nand2_1
XFILLER_30_1010 VPWR VGND sg13g2_decap_8
XFILLER_4_929 VPWR VGND sg13g2_decap_8
XFILLER_3_417 VPWR VGND sg13g2_decap_8
XFILLER_1_7 VPWR VGND sg13g2_decap_8
X_5207__215 VPWR VGND net215 sg13g2_tiehi
XFILLER_19_329 VPWR VGND sg13g2_decap_8
XFILLER_28_852 VPWR VGND sg13g2_decap_8
XFILLER_28_874 VPWR VGND sg13g2_decap_8
XFILLER_43_822 VPWR VGND sg13g2_fill_1
XFILLER_15_546 VPWR VGND sg13g2_fill_2
XFILLER_42_376 VPWR VGND sg13g2_fill_1
XFILLER_30_505 VPWR VGND sg13g2_decap_8
XFILLER_30_538 VPWR VGND sg13g2_decap_8
XFILLER_11_730 VPWR VGND sg13g2_fill_1
XFILLER_11_752 VPWR VGND sg13g2_decap_8
XFILLER_6_211 VPWR VGND sg13g2_fill_2
XFILLER_10_284 VPWR VGND sg13g2_decap_4
XFILLER_11_796 VPWR VGND sg13g2_fill_2
XFILLER_6_266 VPWR VGND sg13g2_fill_1
XFILLER_3_951 VPWR VGND sg13g2_decap_8
XFILLER_34_7 VPWR VGND sg13g2_fill_1
XFILLER_1_21 VPWR VGND sg13g2_decap_8
XFILLER_18_340 VPWR VGND sg13g2_decap_4
X_4900_ net427 VGND VPWR _0361_ blue\[6\] net646 sg13g2_dfrbpq_2
X_4831_ net131 VGND VPWR _0292_ videogen.fancy_shader.video_x\[0\] net644 sg13g2_dfrbpq_2
XFILLER_34_899 VPWR VGND sg13g2_decap_8
X_4762_ net689 net733 _0226_ VPWR VGND sg13g2_nor2_1
XFILLER_14_1005 VPWR VGND sg13g2_decap_8
X_3713_ net621 VPWR _1431_ VGND videogen.test_lut_thingy.pixel_feeder_inst.row\[38\]\[1\]
+ net585 sg13g2_o21ai_1
X_4693_ net678 net722 _0157_ VPWR VGND sg13g2_nor2_1
X_3644_ net599 VPWR _1362_ VGND videogen.test_lut_thingy.pixel_feeder_inst.row\[24\]\[2\]
+ net577 sg13g2_o21ai_1
X_3575_ _1289_ _1290_ _1291_ _1292_ _1293_ VPWR VGND sg13g2_nor4_1
XFILLER_0_409 VPWR VGND sg13g2_decap_8
Xhold17 serialize.shift_reg_r\[2\] VPWR VGND net463 sg13g2_dlygate4sd3_1
Xhold28 serialize.shift_reg_r\[4\] VPWR VGND net474 sg13g2_dlygate4sd3_1
XFILLER_29_28 VPWR VGND sg13g2_fill_1
X_5176_ net194 VGND VPWR _0633_ videogen.test_lut_thingy.pixel_feeder_inst.row\[23\]\[2\]
+ _0251_ sg13g2_dfrbpq_1
X_4127_ _1830_ VPWR _1838_ VGND _1832_ _1837_ sg13g2_o21ai_1
XFILLER_43_107 VPWR VGND sg13g2_fill_2
XFILLER_37_660 VPWR VGND sg13g2_decap_8
X_4058_ _1767_ _1768_ _1769_ VPWR VGND sg13g2_nor2_1
XFILLER_37_682 VPWR VGND sg13g2_decap_4
X_5022__222 VPWR VGND net222 sg13g2_tiehi
X_3009_ videogen.test_lut_thingy.pixel_feeder_inst.row\[20\]\[0\] net800 _0825_ _0274_
+ VPWR VGND sg13g2_mux2_1
XFILLER_25_833 VPWR VGND sg13g2_fill_1
XFILLER_25_877 VPWR VGND sg13g2_fill_1
XFILLER_24_376 VPWR VGND sg13g2_decap_8
XFILLER_24_387 VPWR VGND sg13g2_fill_2
XFILLER_25_888 VPWR VGND sg13g2_decap_8
XFILLER_40_869 VPWR VGND sg13g2_decap_4
XFILLER_3_203 VPWR VGND sg13g2_decap_4
XFILLER_0_910 VPWR VGND sg13g2_decap_8
XFILLER_48_936 VPWR VGND sg13g2_decap_8
XFILLER_47_413 VPWR VGND sg13g2_decap_8
XFILLER_0_987 VPWR VGND sg13g2_decap_8
XFILLER_19_72 VPWR VGND sg13g2_decap_8
XFILLER_47_468 VPWR VGND sg13g2_decap_8
XFILLER_34_107 VPWR VGND sg13g2_fill_2
XFILLER_34_129 VPWR VGND sg13g2_decap_8
XFILLER_43_630 VPWR VGND sg13g2_decap_8
XFILLER_16_877 VPWR VGND sg13g2_decap_8
XFILLER_42_151 VPWR VGND sg13g2_decap_8
XFILLER_42_140 VPWR VGND sg13g2_fill_1
XFILLER_30_346 VPWR VGND sg13g2_fill_1
XFILLER_31_858 VPWR VGND sg13g2_decap_8
X_3360_ VGND VPWR _1076_ _1077_ _1078_ _1072_ sg13g2_a21oi_1
XFILLER_3_792 VPWR VGND sg13g2_fill_1
X_5030_ net206 VGND VPWR _0487_ videogen.test_lut_thingy.pixel_feeder_inst.row\[58\]\[3\]
+ _0124_ sg13g2_dfrbpq_1
X_3291_ _1009_ videogen.fancy_shader.video_x\[2\] videogen.fancy_shader.shader_counter_reg\[2\]
+ VPWR VGND sg13g2_xnor2_1
XFILLER_39_936 VPWR VGND sg13g2_fill_2
XFILLER_38_413 VPWR VGND sg13g2_decap_8
X_4984__298 VPWR VGND net298 sg13g2_tiehi
XFILLER_38_479 VPWR VGND sg13g2_decap_8
XFILLER_47_991 VPWR VGND sg13g2_decap_8
XFILLER_34_630 VPWR VGND sg13g2_decap_8
XFILLER_34_641 VPWR VGND sg13g2_fill_2
XFILLER_34_652 VPWR VGND sg13g2_fill_2
XFILLER_22_836 VPWR VGND sg13g2_decap_8
X_4814_ net163 VGND VPWR _0275_ videogen.test_lut_thingy.pixel_feeder_inst.row\[20\]\[1\]
+ _0006_ sg13g2_dfrbpq_1
XFILLER_33_195 VPWR VGND sg13g2_decap_8
X_4745_ net671 net715 _0209_ VPWR VGND sg13g2_nor2_1
XFILLER_31_18 VPWR VGND sg13g2_decap_8
X_4676_ net687 net731 _0140_ VPWR VGND sg13g2_nor2_1
X_3627_ videogen.test_lut_thingy.pixel_feeder_inst.row\[10\]\[2\] net591 _1345_ VPWR
+ VGND sg13g2_nor2_1
Xoutput18 net18 uo_out[5] VPWR VGND sg13g2_buf_1
X_3558_ net614 VPWR _1276_ VGND _1264_ _1275_ sg13g2_o21ai_1
XFILLER_1_729 VPWR VGND sg13g2_decap_8
X_3489_ _1015_ _1199_ _1203_ _1207_ VPWR VGND sg13g2_nor3_1
X_5159_ net311 VGND VPWR _0616_ serialize.tmds_parallel_b\[3\] net651 sg13g2_dfrbpq_1
XFILLER_29_413 VPWR VGND sg13g2_decap_4
XFILLER_38_991 VPWR VGND sg13g2_decap_8
XFILLER_16_129 VPWR VGND sg13g2_decap_4
XFILLER_25_652 VPWR VGND sg13g2_decap_8
XFILLER_40_600 VPWR VGND sg13g2_decap_4
XFILLER_13_825 VPWR VGND sg13g2_fill_1
XFILLER_25_663 VPWR VGND sg13g2_decap_8
XFILLER_40_633 VPWR VGND sg13g2_decap_4
XFILLER_8_317 VPWR VGND sg13g2_decap_8
XFILLER_12_368 VPWR VGND sg13g2_decap_4
X_4875__54 VPWR VGND net54 sg13g2_tiehi
XFILLER_0_784 VPWR VGND sg13g2_decap_8
XFILLER_29_980 VPWR VGND sg13g2_decap_8
XFILLER_28_490 VPWR VGND sg13g2_fill_1
XFILLER_44_972 VPWR VGND sg13g2_decap_8
X_2860_ net789 videogen.test_lut_thingy.pixel_feeder_inst.row\[58\]\[1\] _0793_ _0485_
+ VPWR VGND sg13g2_mux2_1
XFILLER_30_143 VPWR VGND sg13g2_decap_4
XFILLER_31_655 VPWR VGND sg13g2_decap_8
X_2791_ videogen.test_lut_thingy.pixel_feeder_inst.row\[39\]\[0\] net795 _0779_ _0549_
+ VPWR VGND sg13g2_mux2_1
X_4530_ VPWR _0659_ _2179_ VGND sg13g2_inv_1
X_4461_ _2139_ _0688_ hsync VPWR VGND sg13g2_nand2_1
X_3412_ _1100_ _1113_ _1129_ _1130_ VPWR VGND sg13g2_or3_1
X_4392_ VPWR _2074_ _2073_ VGND sg13g2_inv_1
X_3343_ _1061_ _1041_ _1060_ VPWR VGND sg13g2_xnor2_1
Xfanout808 rst_n net808 VPWR VGND sg13g2_buf_2
X_3274_ videogen.fancy_shader.video_x\[0\] videogen.fancy_shader.video_y\[0\] _0992_
+ VPWR VGND sg13g2_xor2_1
X_5013_ net240 VGND VPWR _0470_ videogen.test_lut_thingy.pixel_feeder_inst.row\[60\]\[2\]
+ _0107_ sg13g2_dfrbpq_1
XFILLER_38_298 VPWR VGND sg13g2_decap_8
XFILLER_41_419 VPWR VGND sg13g2_decap_4
XFILLER_10_828 VPWR VGND sg13g2_fill_2
X_2989_ videogen.test_lut_thingy.pixel_feeder_inst.row\[37\]\[0\] net795 _0821_ _0323_
+ VPWR VGND sg13g2_mux2_1
X_4728_ net679 net723 _0192_ VPWR VGND sg13g2_nor2_1
XFILLER_5_309 VPWR VGND sg13g2_decap_8
X_4659_ net675 net719 _0123_ VPWR VGND sg13g2_nor2_1
XFILLER_1_504 VPWR VGND sg13g2_decap_8
XFILLER_16_51 VPWR VGND sg13g2_fill_2
XFILLER_26_983 VPWR VGND sg13g2_decap_8
XFILLER_41_942 VPWR VGND sg13g2_decap_4
XFILLER_25_493 VPWR VGND sg13g2_fill_1
XFILLER_41_964 VPWR VGND sg13g2_decap_8
XFILLER_12_143 VPWR VGND sg13g2_decap_4
XFILLER_34_1019 VPWR VGND sg13g2_decap_8
XFILLER_12_176 VPWR VGND sg13g2_decap_8
XFILLER_12_187 VPWR VGND sg13g2_fill_2
XFILLER_13_699 VPWR VGND sg13g2_fill_2
XFILLER_5_832 VPWR VGND sg13g2_fill_1
XFILLER_5_821 VPWR VGND sg13g2_fill_2
XFILLER_4_342 VPWR VGND sg13g2_fill_2
XFILLER_4_331 VPWR VGND sg13g2_decap_8
XFILLER_4_320 VPWR VGND sg13g2_fill_1
XFILLER_0_570 VPWR VGND sg13g2_decap_8
XFILLER_48_563 VPWR VGND sg13g2_decap_8
XFILLER_36_736 VPWR VGND sg13g2_fill_1
XFILLER_35_246 VPWR VGND sg13g2_decap_8
X_3961_ VPWR _0365_ _1672_ VGND sg13g2_inv_1
XFILLER_35_257 VPWR VGND sg13g2_fill_2
X_2912_ videogen.test_lut_thingy.pixel_feeder_inst.row\[11\]\[2\] net781 _0806_ _0446_
+ VPWR VGND sg13g2_mux2_1
XFILLER_16_471 VPWR VGND sg13g2_decap_8
X_3892_ VPWR VGND _1601_ _1598_ _1600_ _1594_ _1606_ _1597_ sg13g2_a221oi_1
XFILLER_32_975 VPWR VGND sg13g2_decap_8
X_2843_ videogen.test_lut_thingy.pixel_feeder_inst.row\[27\]\[3\] net764 _0790_ _0508_
+ VPWR VGND sg13g2_mux2_1
XFILLER_31_474 VPWR VGND sg13g2_fill_1
XFILLER_31_485 VPWR VGND sg13g2_fill_2
X_2774_ videogen.test_lut_thingy.pixel_feeder_inst.row\[45\]\[2\] net773 _0776_ _0563_
+ VPWR VGND sg13g2_mux2_1
X_4513_ _2171_ net659 net467 net663 green_tmds_par\[2\] VPWR VGND sg13g2_a22oi_1
XFILLER_8_670 VPWR VGND sg13g2_decap_8
X_4444_ _2080_ VPWR _2124_ VGND tmds_blue.dc_balancing_reg\[3\] _2081_ sg13g2_o21ai_1
Xfanout605 green\[0\] net605 VPWR VGND sg13g2_buf_8
X_4375_ VGND VPWR green\[0\] net609 _0490_ net760 sg13g2_a21oi_1
X_3326_ _1044_ net611 videogen.fancy_shader.shader_counter_reg\[6\] VPWR VGND sg13g2_xnor2_1
Xfanout638 net657 net638 VPWR VGND sg13g2_buf_8
Xfanout627 net630 net627 VPWR VGND sg13g2_buf_8
Xfanout616 videogen.test_lut_thingy.pixel_feeder_inst.h_pix\[4\] net616 VPWR VGND
+ sg13g2_buf_8
Xfanout649 net656 net649 VPWR VGND sg13g2_buf_8
X_3257_ _0980_ VPWR _0352_ VGND _0674_ _0879_ sg13g2_o21ai_1
XFILLER_39_574 VPWR VGND sg13g2_decap_4
XFILLER_39_563 VPWR VGND sg13g2_decap_8
X_3188_ _0935_ videogen.test_lut_thingy.pixel_feeder_inst.h_counter\[2\] _0934_ VPWR
+ VGND sg13g2_xnor2_1
XFILLER_2_1028 VPWR VGND sg13g2_fill_1
XFILLER_26_202 VPWR VGND sg13g2_decap_8
XFILLER_26_235 VPWR VGND sg13g2_fill_2
XFILLER_10_614 VPWR VGND sg13g2_fill_1
XFILLER_22_474 VPWR VGND sg13g2_fill_1
XFILLER_23_986 VPWR VGND sg13g2_decap_8
XFILLER_10_658 VPWR VGND sg13g2_fill_2
XFILLER_2_802 VPWR VGND sg13g2_decap_8
XFILLER_2_879 VPWR VGND sg13g2_decap_8
XFILLER_49_338 VPWR VGND sg13g2_decap_8
XFILLER_1_389 VPWR VGND sg13g2_fill_2
XFILLER_40_1012 VPWR VGND sg13g2_decap_8
XFILLER_45_544 VPWR VGND sg13g2_decap_8
XFILLER_27_61 VPWR VGND sg13g2_decap_8
XFILLER_45_588 VPWR VGND sg13g2_fill_2
XFILLER_45_577 VPWR VGND sg13g2_decap_4
XFILLER_14_942 VPWR VGND sg13g2_decap_8
XFILLER_32_227 VPWR VGND sg13g2_fill_1
XFILLER_5_684 VPWR VGND sg13g2_fill_1
XFILLER_4_161 VPWR VGND sg13g2_decap_4
X_4160_ VPWR _1871_ _1870_ VGND sg13g2_inv_1
X_3111_ _0834_ _0883_ _0295_ VPWR VGND sg13g2_nor2_1
XFILLER_1_890 VPWR VGND sg13g2_decap_8
XFILLER_49_861 VPWR VGND sg13g2_decap_8
X_4091_ net543 _1800_ _1798_ _1802_ VPWR VGND sg13g2_a21o_1
X_3042_ VGND VPWR net595 net14 _0718_ net553 sg13g2_a21oi_2
X_4993_ net280 VGND VPWR _0450_ videogen.test_lut_thingy.pixel_feeder_inst.row\[0\]\[2\]
+ _0087_ sg13g2_dfrbpq_1
XFILLER_17_780 VPWR VGND sg13g2_decap_4
X_3944_ _1653_ _1656_ _1658_ VPWR VGND _1584_ sg13g2_nand3b_1
XFILLER_32_750 VPWR VGND sg13g2_fill_1
X_3875_ VPWR _1589_ _1588_ VGND sg13g2_inv_1
XFILLER_32_783 VPWR VGND sg13g2_fill_2
X_2826_ videogen.test_lut_thingy.pixel_feeder_inst.row\[54\]\[0\] net801 _0786_ _0521_
+ VPWR VGND sg13g2_mux2_1
XFILLER_20_989 VPWR VGND sg13g2_decap_8
X_2757_ videogen.test_lut_thingy.pixel_feeder_inst.row\[42\]\[1\] net784 _0770_ _0574_
+ VPWR VGND sg13g2_mux2_1
X_2688_ _0744_ net603 _0743_ VPWR VGND sg13g2_nand2_2
X_4427_ _2107_ _2095_ _2106_ VPWR VGND sg13g2_nand2_1
XFILLER_48_49 VPWR VGND sg13g2_decap_8
X_4358_ VGND VPWR _1993_ _2046_ _2047_ _2027_ sg13g2_a21oi_1
XFILLER_47_809 VPWR VGND sg13g2_decap_8
X_3309_ _1024_ VPWR _1027_ VGND _1023_ _1025_ sg13g2_o21ai_1
X_4289_ _1989_ _0957_ _1918_ VPWR VGND sg13g2_nand2b_1
XFILLER_39_382 VPWR VGND sg13g2_fill_2
XFILLER_15_706 VPWR VGND sg13g2_decap_8
XFILLER_15_739 VPWR VGND sg13g2_decap_8
XFILLER_10_444 VPWR VGND sg13g2_fill_1
XFILLER_22_282 VPWR VGND sg13g2_decap_8
XFILLER_7_927 VPWR VGND sg13g2_decap_8
XFILLER_11_978 VPWR VGND sg13g2_decap_8
XFILLER_2_621 VPWR VGND sg13g2_decap_4
XFILLER_2_643 VPWR VGND sg13g2_decap_8
XFILLER_1_142 VPWR VGND sg13g2_decap_8
XFILLER_49_157 VPWR VGND sg13g2_fill_1
XFILLER_49_135 VPWR VGND sg13g2_decap_8
XFILLER_46_842 VPWR VGND sg13g2_decap_8
XFILLER_14_750 VPWR VGND sg13g2_decap_8
XFILLER_13_260 VPWR VGND sg13g2_fill_1
XFILLER_14_761 VPWR VGND sg13g2_fill_2
XFILLER_13_293 VPWR VGND sg13g2_fill_1
XFILLER_14_794 VPWR VGND sg13g2_decap_8
XFILLER_9_253 VPWR VGND sg13g2_decap_8
X_3660_ videogen.test_lut_thingy.pixel_feeder_inst.row\[58\]\[2\] net585 _1378_ VPWR
+ VGND sg13g2_nor2_1
X_3591_ videogen.test_lut_thingy.pixel_feeder_inst.row\[12\]\[3\] net583 _1309_ VPWR
+ VGND sg13g2_nor2_1
X_2611_ VPWR _0684_ tmds_green.dc_balancing_reg\[3\] VGND sg13g2_inv_1
XFILLER_5_470 VPWR VGND sg13g2_fill_1
X_4212_ tmds_red.dc_balancing_reg\[4\] _1913_ _1916_ _1917_ _1918_ VPWR VGND sg13g2_nor4_1
X_5192_ net384 VGND VPWR _0649_ serialize.shift_reg_g\[2\] clknet_3_7__leaf_clk_regs
+ sg13g2_dfrbpq_1
X_4143_ VGND VPWR _1158_ _1850_ _1854_ _1853_ sg13g2_a21oi_1
X_5009__248 VPWR VGND net248 sg13g2_tiehi
X_4074_ VPWR VGND _1779_ _1769_ _1777_ _1674_ _1785_ _1677_ sg13g2_a221oi_1
XFILLER_37_831 VPWR VGND sg13g2_decap_8
XFILLER_37_820 VPWR VGND sg13g2_decap_8
X_3025_ net552 VPWR _0841_ VGND videogen.test_lut_thingy.pixel_feeder_inst.state\[0\]
+ _0840_ sg13g2_o21ai_1
XFILLER_36_330 VPWR VGND sg13g2_fill_2
XFILLER_24_514 VPWR VGND sg13g2_fill_2
X_4976_ net314 VGND VPWR _0433_ videogen.test_lut_thingy.pixel_feeder_inst.row\[31\]\[1\]
+ _0070_ sg13g2_dfrbpq_1
X_3927_ _1633_ VPWR _1641_ VGND _1631_ _1635_ sg13g2_o21ai_1
Xclkload6 clknet_3_6__leaf_clk_regs clkload6/X VPWR VGND sg13g2_buf_1
X_4994__278 VPWR VGND net278 sg13g2_tiehi
X_3858_ VGND VPWR _1542_ _1555_ _1575_ _1574_ sg13g2_a21oi_1
X_3789_ videogen.test_lut_thingy.pixel_feeder_inst.row\[8\]\[1\] net582 _1507_ VPWR
+ VGND sg13g2_nor2_1
XFILLER_4_908 VPWR VGND sg13g2_decap_8
X_2809_ videogen.test_lut_thingy.pixel_feeder_inst.row\[51\]\[2\] net775 _0783_ _0535_
+ VPWR VGND sg13g2_mux2_1
XFILLER_46_149 VPWR VGND sg13g2_fill_1
XFILLER_27_330 VPWR VGND sg13g2_fill_2
XFILLER_43_867 VPWR VGND sg13g2_fill_2
XFILLER_42_344 VPWR VGND sg13g2_fill_2
XFILLER_23_580 VPWR VGND sg13g2_fill_2
XFILLER_40_72 VPWR VGND sg13g2_fill_1
XFILLER_6_278 VPWR VGND sg13g2_decap_8
XFILLER_6_245 VPWR VGND sg13g2_decap_8
XFILLER_3_930 VPWR VGND sg13g2_decap_8
XFILLER_41_9 VPWR VGND sg13g2_fill_1
XFILLER_2_440 VPWR VGND sg13g2_fill_1
XFILLER_49_70 VPWR VGND sg13g2_decap_4
XFILLER_38_617 VPWR VGND sg13g2_decap_8
XFILLER_19_864 VPWR VGND sg13g2_fill_1
XFILLER_46_694 VPWR VGND sg13g2_decap_4
X_4830_ net133 VGND VPWR _0291_ videogen.test_lut_thingy.pixel_feeder_inst.row\[18\]\[3\]
+ _0020_ sg13g2_dfrbpq_1
X_4761_ net690 net734 _0225_ VPWR VGND sg13g2_nor2_1
XFILLER_14_1028 VPWR VGND sg13g2_fill_1
X_4692_ net695 net739 _0156_ VPWR VGND sg13g2_nor2_1
X_3712_ _1426_ _1427_ _1428_ _1429_ _1430_ VPWR VGND sg13g2_nor4_1
X_3643_ net620 _1355_ _1360_ _1361_ VPWR VGND sg13g2_nor3_1
X_3574_ videogen.test_lut_thingy.pixel_feeder_inst.row\[29\]\[3\] net559 _1292_ VPWR
+ VGND sg13g2_nor2_1
Xhold18 serialize.shift_reg_g\[5\] VPWR VGND net464 sg13g2_dlygate4sd3_1
Xhold29 serialize.shift_reg_r\[3\] VPWR VGND net475 sg13g2_dlygate4sd3_1
X_5175_ net211 VGND VPWR _0632_ videogen.test_lut_thingy.pixel_feeder_inst.row\[23\]\[1\]
+ _0250_ sg13g2_dfrbpq_1
X_4126_ VPWR VGND _1834_ _1825_ _1830_ _1826_ _1837_ _1827_ sg13g2_a221oi_1
X_4057_ VPWR VGND _1761_ _1764_ _1758_ _1679_ _1768_ _1680_ sg13g2_a221oi_1
XFILLER_43_119 VPWR VGND sg13g2_fill_1
X_3008_ videogen.test_lut_thingy.pixel_feeder_inst.row\[20\]\[1\] net789 _0825_ _0275_
+ VPWR VGND sg13g2_mux2_1
XFILLER_40_848 VPWR VGND sg13g2_decap_8
X_4959_ net348 VGND VPWR _0416_ videogen.test_lut_thingy.pixel_feeder_inst.row\[36\]\[0\]
+ _0053_ sg13g2_dfrbpq_1
XFILLER_24_399 VPWR VGND sg13g2_fill_1
XFILLER_10_42 VPWR VGND sg13g2_fill_1
XFILLER_0_966 VPWR VGND sg13g2_decap_8
XFILLER_48_915 VPWR VGND sg13g2_decap_8
XFILLER_19_95 VPWR VGND sg13g2_fill_1
XFILLER_15_300 VPWR VGND sg13g2_fill_1
XFILLER_35_50 VPWR VGND sg13g2_fill_2
XFILLER_37_1028 VPWR VGND sg13g2_fill_1
XFILLER_37_1017 VPWR VGND sg13g2_decap_8
XFILLER_15_399 VPWR VGND sg13g2_fill_1
XFILLER_30_314 VPWR VGND sg13g2_fill_1
XFILLER_31_837 VPWR VGND sg13g2_fill_2
XFILLER_7_532 VPWR VGND sg13g2_decap_4
XFILLER_11_594 VPWR VGND sg13g2_fill_2
X_3290_ _1005_ VPWR _1008_ VGND _0987_ _1006_ sg13g2_o21ai_1
XFILLER_2_292 VPWR VGND sg13g2_decap_8
XFILLER_25_4 VPWR VGND sg13g2_fill_1
XFILLER_38_458 VPWR VGND sg13g2_fill_1
XFILLER_20_1010 VPWR VGND sg13g2_decap_8
XFILLER_47_970 VPWR VGND sg13g2_decap_8
XFILLER_21_303 VPWR VGND sg13g2_decap_8
XFILLER_22_815 VPWR VGND sg13g2_decap_8
XFILLER_33_141 VPWR VGND sg13g2_fill_1
X_4813_ net165 VGND VPWR _0274_ videogen.test_lut_thingy.pixel_feeder_inst.row\[20\]\[0\]
+ _0005_ sg13g2_dfrbpq_1
X_4744_ net680 net724 _0208_ VPWR VGND sg13g2_nor2_1
XFILLER_30_881 VPWR VGND sg13g2_fill_2
X_4675_ net687 net731 _0139_ VPWR VGND sg13g2_nor2_1
X_3626_ net598 VPWR _1344_ VGND videogen.test_lut_thingy.pixel_feeder_inst.row\[11\]\[2\]
+ net572 sg13g2_o21ai_1
Xoutput19 net19 uo_out[6] VPWR VGND sg13g2_buf_1
X_3557_ _0678_ VPWR _1275_ VGND _1269_ _1274_ sg13g2_o21ai_1
X_3488_ _1206_ _1194_ _1197_ VPWR VGND sg13g2_xnor2_1
X_5158_ net315 VGND VPWR _0615_ blue_tmds_par\[2\] net648 sg13g2_dfrbpq_1
XFILLER_5_1015 VPWR VGND sg13g2_decap_8
X_4109_ VPWR VGND _1808_ _1815_ _1814_ _1807_ _1820_ _1810_ sg13g2_a221oi_1
X_5089_ net366 VGND VPWR _0546_ videogen.test_lut_thingy.pixel_feeder_inst.row\[48\]\[1\]
+ _0174_ sg13g2_dfrbpq_1
XFILLER_44_428 VPWR VGND sg13g2_fill_2
XFILLER_44_417 VPWR VGND sg13g2_decap_8
XFILLER_44_406 VPWR VGND sg13g2_fill_1
XFILLER_38_970 VPWR VGND sg13g2_decap_8
XFILLER_40_645 VPWR VGND sg13g2_fill_1
XFILLER_24_174 VPWR VGND sg13g2_decap_4
XFILLER_12_347 VPWR VGND sg13g2_fill_1
XFILLER_40_689 VPWR VGND sg13g2_decap_8
XFILLER_20_391 VPWR VGND sg13g2_fill_2
XFILLER_4_524 VPWR VGND sg13g2_fill_1
XFILLER_21_41 VPWR VGND sg13g2_decap_8
XFILLER_21_52 VPWR VGND sg13g2_fill_1
XFILLER_0_763 VPWR VGND sg13g2_decap_8
X_5081__401 VPWR VGND net401 sg13g2_tiehi
XFILLER_36_929 VPWR VGND sg13g2_fill_1
XFILLER_44_951 VPWR VGND sg13g2_decap_8
XFILLER_16_620 VPWR VGND sg13g2_fill_2
XFILLER_43_483 VPWR VGND sg13g2_fill_2
X_2790_ videogen.test_lut_thingy.pixel_feeder_inst.row\[39\]\[1\] net784 _0779_ _0550_
+ VPWR VGND sg13g2_mux2_1
XFILLER_30_166 VPWR VGND sg13g2_decap_4
XFILLER_8_852 VPWR VGND sg13g2_decap_8
X_4460_ net555 _2138_ _0496_ VPWR VGND sg13g2_nor2_1
X_4391_ _2072_ VPWR _2073_ VGND _2063_ _2067_ sg13g2_o21ai_1
X_3411_ _1129_ net550 _1121_ _1110_ net549 VPWR VGND sg13g2_a22oi_1
X_3342_ VGND VPWR _1043_ _1059_ _1060_ _1042_ sg13g2_a21oi_1
Xfanout809 net810 net809 VPWR VGND sg13g2_buf_8
X_3273_ _0991_ videogen.fancy_shader.video_y\[0\] net637 VPWR VGND sg13g2_xnor2_1
X_5086__378 VPWR VGND net378 sg13g2_tiehi
X_5012_ net242 VGND VPWR _0469_ videogen.test_lut_thingy.pixel_feeder_inst.row\[60\]\[1\]
+ _0106_ sg13g2_dfrbpq_1
XFILLER_38_233 VPWR VGND sg13g2_fill_1
X_5162__299 VPWR VGND net299 sg13g2_tiehi
XFILLER_34_450 VPWR VGND sg13g2_fill_1
XFILLER_21_100 VPWR VGND sg13g2_fill_1
XFILLER_22_612 VPWR VGND sg13g2_decap_8
XFILLER_34_494 VPWR VGND sg13g2_fill_1
XFILLER_35_995 VPWR VGND sg13g2_decap_8
X_2988_ videogen.test_lut_thingy.pixel_feeder_inst.row\[37\]\[1\] net788 _0821_ _0324_
+ VPWR VGND sg13g2_mux2_1
XFILLER_21_166 VPWR VGND sg13g2_decap_8
X_4727_ net669 net713 _0191_ VPWR VGND sg13g2_nor2_1
X_4658_ net693 net737 _0122_ VPWR VGND sg13g2_nor2_1
X_3609_ net1 _1326_ _1327_ VPWR VGND sg13g2_nor2_1
X_4589_ net670 net714 _0053_ VPWR VGND sg13g2_nor2_1
XFILLER_49_509 VPWR VGND sg13g2_decap_8
XFILLER_45_704 VPWR VGND sg13g2_fill_1
XFILLER_44_258 VPWR VGND sg13g2_decap_8
XFILLER_25_461 VPWR VGND sg13g2_fill_1
XFILLER_26_962 VPWR VGND sg13g2_decap_8
XFILLER_16_63 VPWR VGND sg13g2_fill_2
XFILLER_13_656 VPWR VGND sg13g2_decap_8
X_5035__200 VPWR VGND net200 sg13g2_tiehi
XFILLER_9_627 VPWR VGND sg13g2_fill_1
XFILLER_32_40 VPWR VGND sg13g2_fill_2
XFILLER_5_899 VPWR VGND sg13g2_decap_8
XFILLER_4_398 VPWR VGND sg13g2_fill_2
XFILLER_48_542 VPWR VGND sg13g2_decap_8
XFILLER_16_450 VPWR VGND sg13g2_decap_8
XFILLER_17_984 VPWR VGND sg13g2_decap_8
X_3960_ net807 VPWR _1672_ VGND _1663_ _1671_ sg13g2_o21ai_1
XFILLER_23_409 VPWR VGND sg13g2_decap_8
X_2911_ videogen.test_lut_thingy.pixel_feeder_inst.row\[11\]\[3\] net770 _0806_ _0447_
+ VPWR VGND sg13g2_mux2_1
XFILLER_16_494 VPWR VGND sg13g2_decap_8
X_3891_ _1596_ _1598_ _1602_ _1605_ VPWR VGND sg13g2_nor3_1
XFILLER_32_954 VPWR VGND sg13g2_decap_8
X_2842_ _0735_ _0750_ _0790_ VPWR VGND sg13g2_nor2_2
X_2773_ videogen.test_lut_thingy.pixel_feeder_inst.row\[45\]\[3\] net761 _0776_ _0564_
+ VPWR VGND sg13g2_mux2_1
X_4512_ VPWR _0650_ _2170_ VGND sg13g2_inv_1
X_4443_ _2103_ VPWR _2123_ VGND _2105_ _2107_ sg13g2_o21ai_1
Xfanout606 net607 net606 VPWR VGND sg13g2_buf_8
X_4374_ net759 _2059_ _0489_ VPWR VGND sg13g2_nor2_1
X_3325_ VGND VPWR _1043_ videogen.fancy_shader.shader_counter_reg\[6\] net611 sg13g2_or2_1
Xfanout639 net640 net639 VPWR VGND sg13g2_buf_8
Xfanout617 net618 net617 VPWR VGND sg13g2_buf_8
Xfanout628 net630 net628 VPWR VGND sg13g2_buf_8
X_3256_ _0877_ _0965_ net807 _0980_ VPWR VGND _0979_ sg13g2_nand4_1
X_3187_ _0931_ _0933_ _0934_ _0320_ VPWR VGND sg13g2_nor3_1
X_4843__118 VPWR VGND net118 sg13g2_tiehi
X_4862__80 VPWR VGND net80 sg13g2_tiehi
XFILLER_23_965 VPWR VGND sg13g2_decap_8
X_5019__228 VPWR VGND net228 sg13g2_tiehi
XFILLER_10_626 VPWR VGND sg13g2_decap_8
XFILLER_10_637 VPWR VGND sg13g2_decap_8
XFILLER_2_858 VPWR VGND sg13g2_decap_8
XFILLER_49_306 VPWR VGND sg13g2_fill_1
X_5106__289 VPWR VGND net289 sg13g2_tiehi
XFILLER_18_759 VPWR VGND sg13g2_fill_1
XFILLER_14_921 VPWR VGND sg13g2_decap_8
XFILLER_14_998 VPWR VGND sg13g2_decap_8
XFILLER_40_272 VPWR VGND sg13g2_decap_4
XFILLER_9_468 VPWR VGND sg13g2_decap_8
XFILLER_4_173 VPWR VGND sg13g2_fill_1
XFILLER_4_33 VPWR VGND sg13g2_decap_8
XFILLER_4_44 VPWR VGND sg13g2_fill_2
X_3110_ net806 VPWR _0883_ VGND videogen.fancy_shader.video_x\[3\] _0833_ sg13g2_o21ai_1
XFILLER_49_840 VPWR VGND sg13g2_decap_8
X_4090_ _1801_ _1594_ _1697_ VPWR VGND sg13g2_xnor2_1
X_3041_ VGND VPWR net594 net13 _0724_ net553 sg13g2_a21oi_2
XFILLER_24_718 VPWR VGND sg13g2_decap_8
X_4992_ net282 VGND VPWR _0449_ videogen.test_lut_thingy.pixel_feeder_inst.row\[0\]\[1\]
+ _0086_ sg13g2_dfrbpq_1
XFILLER_17_792 VPWR VGND sg13g2_fill_2
X_3943_ VGND VPWR _1650_ _1652_ _1657_ _1656_ sg13g2_a21oi_1
X_3874_ _1588_ net550 _1587_ VPWR VGND sg13g2_xnor2_1
XFILLER_17_1026 VPWR VGND sg13g2_fill_2
XFILLER_32_762 VPWR VGND sg13g2_decap_8
X_2825_ videogen.test_lut_thingy.pixel_feeder_inst.row\[54\]\[1\] net785 _0786_ _0522_
+ VPWR VGND sg13g2_mux2_1
XFILLER_20_968 VPWR VGND sg13g2_decap_8
XFILLER_31_294 VPWR VGND sg13g2_decap_8
X_2756_ videogen.test_lut_thingy.pixel_feeder_inst.row\[42\]\[2\] net773 _0770_ _0575_
+ VPWR VGND sg13g2_mux2_1
X_2687_ _0743_ _0742_ VPWR VGND sg13g2_inv_2
X_4426_ _2071_ VPWR _2106_ VGND _2083_ _2094_ sg13g2_o21ai_1
XFILLER_48_28 VPWR VGND sg13g2_decap_8
X_4357_ _2046_ _2018_ _2045_ VPWR VGND sg13g2_xnor2_1
X_3308_ videogen.fancy_shader.shader_counter_reg\[5\] videogen.fancy_shader.video_x\[5\]
+ _1026_ VPWR VGND sg13g2_xor2_1
XFILLER_24_1019 VPWR VGND sg13g2_decap_8
X_4288_ _0958_ _1925_ _0376_ VPWR VGND sg13g2_nor2_1
XFILLER_39_350 VPWR VGND sg13g2_fill_1
X_3239_ VGND VPWR videogen.fancy_shader.video_y\[3\] _0966_ _0346_ _0968_ sg13g2_a21oi_1
XFILLER_42_548 VPWR VGND sg13g2_decap_8
XFILLER_7_906 VPWR VGND sg13g2_decap_8
XFILLER_11_957 VPWR VGND sg13g2_decap_8
XFILLER_13_42 VPWR VGND sg13g2_decap_8
XFILLER_23_795 VPWR VGND sg13g2_decap_8
X_4819__153 VPWR VGND net153 sg13g2_tiehi
XFILLER_10_489 VPWR VGND sg13g2_decap_4
X_5032__203 VPWR VGND net203 sg13g2_tiehi
X_4936__377 VPWR VGND net377 sg13g2_tiehi
XFILLER_49_114 VPWR VGND sg13g2_decap_8
XFILLER_49_169 VPWR VGND sg13g2_decap_8
XFILLER_46_821 VPWR VGND sg13g2_decap_8
XFILLER_45_353 VPWR VGND sg13g2_fill_1
XFILLER_18_578 VPWR VGND sg13g2_decap_8
XFILLER_46_898 VPWR VGND sg13g2_decap_8
X_5193__376 VPWR VGND net376 sg13g2_tiehi
XFILLER_9_221 VPWR VGND sg13g2_decap_8
X_3590_ videogen.test_lut_thingy.pixel_feeder_inst.row\[13\]\[3\] net563 _1308_ VPWR
+ VGND sg13g2_nor2_1
XFILLER_10_990 VPWR VGND sg13g2_decap_8
X_2610_ _0683_ net605 VPWR VGND sg13g2_inv_2
XFILLER_47_1019 VPWR VGND sg13g2_decap_8
XFILLER_6_983 VPWR VGND sg13g2_decap_8
XFILLER_5_460 VPWR VGND sg13g2_fill_1
X_4211_ tmds_red.dc_balancing_reg\[0\] tmds_red.dc_balancing_reg\[1\] tmds_red.dc_balancing_reg\[3\]
+ tmds_red.dc_balancing_reg\[2\] _1917_ VPWR VGND sg13g2_nor4_1
X_5191_ net395 VGND VPWR _0648_ serialize.shift_reg_g\[1\] clknet_3_5__leaf_clk_regs
+ sg13g2_dfrbpq_1
X_4142_ _1842_ _1839_ _1853_ VPWR VGND sg13g2_xor2_1
X_4073_ _1784_ _1777_ _1783_ VPWR VGND sg13g2_nand2_1
XFILLER_49_692 VPWR VGND sg13g2_decap_8
X_3024_ _0840_ _0838_ _0839_ _0832_ _0828_ VPWR VGND sg13g2_a22oi_1
X_4975_ net316 VGND VPWR _0432_ videogen.test_lut_thingy.pixel_feeder_inst.row\[31\]\[0\]
+ _0069_ sg13g2_dfrbpq_1
X_3926_ VPWR _1640_ _1639_ VGND sg13g2_inv_1
Xclkload7 VPWR clkload7/Y clknet_3_7__leaf_clk_regs VGND sg13g2_inv_1
XFILLER_20_765 VPWR VGND sg13g2_decap_8
X_3857_ _1567_ _1573_ _1574_ VPWR VGND sg13g2_nor2_1
X_3788_ net619 VPWR _1506_ VGND videogen.test_lut_thingy.pixel_feeder_inst.row\[9\]\[1\]
+ net562 sg13g2_o21ai_1
X_2808_ videogen.test_lut_thingy.pixel_feeder_inst.row\[51\]\[3\] net763 _0783_ _0536_
+ VPWR VGND sg13g2_mux2_1
X_2739_ videogen.test_lut_thingy.pixel_feeder_inst.row\[3\]\[1\] net790 _0764_ _0586_
+ VPWR VGND sg13g2_mux2_1
X_4409_ net606 _2079_ _2090_ VPWR VGND sg13g2_nor2_1
XFILLER_8_1013 VPWR VGND sg13g2_decap_8
XFILLER_46_106 VPWR VGND sg13g2_fill_2
XFILLER_27_320 VPWR VGND sg13g2_decap_4
XFILLER_28_832 VPWR VGND sg13g2_decap_8
XFILLER_43_813 VPWR VGND sg13g2_decap_8
XFILLER_15_548 VPWR VGND sg13g2_fill_1
XFILLER_27_397 VPWR VGND sg13g2_decap_8
XFILLER_24_52 VPWR VGND sg13g2_decap_8
XFILLER_24_63 VPWR VGND sg13g2_fill_1
XFILLER_3_986 VPWR VGND sg13g2_decap_8
XFILLER_49_93 VPWR VGND sg13g2_decap_8
XFILLER_37_139 VPWR VGND sg13g2_decap_4
XFILLER_1_78 VPWR VGND sg13g2_fill_2
XFILLER_33_301 VPWR VGND sg13g2_decap_8
XFILLER_34_835 VPWR VGND sg13g2_decap_8
XFILLER_42_890 VPWR VGND sg13g2_decap_8
X_4760_ net699 net743 _0224_ VPWR VGND sg13g2_nor2_1
X_4691_ net695 net739 _0155_ VPWR VGND sg13g2_nor2_1
X_3711_ videogen.test_lut_thingy.pixel_feeder_inst.row\[35\]\[1\] net568 _1429_ VPWR
+ VGND sg13g2_nor2_1
X_3642_ _1356_ _1357_ _1358_ _1359_ _1360_ VPWR VGND sg13g2_nor4_1
X_3573_ videogen.test_lut_thingy.pixel_feeder_inst.row\[30\]\[3\] net588 _1291_ VPWR
+ VGND sg13g2_nor2_1
XFILLER_46_0 VPWR VGND sg13g2_decap_8
Xhold19 serialize.shift_reg_g\[7\] VPWR VGND net465 sg13g2_dlygate4sd3_1
X_5174_ net219 VGND VPWR _0631_ videogen.test_lut_thingy.pixel_feeder_inst.row\[23\]\[0\]
+ _0249_ sg13g2_dfrbpq_1
X_4125_ _1836_ _1828_ _1835_ VPWR VGND sg13g2_nand2_1
XFILLER_37_651 VPWR VGND sg13g2_fill_1
X_4056_ VGND VPWR _1760_ _1763_ _1767_ _1682_ sg13g2_a21oi_1
X_3007_ videogen.test_lut_thingy.pixel_feeder_inst.row\[20\]\[2\] net778 _0825_ _0276_
+ VPWR VGND sg13g2_mux2_1
XFILLER_24_312 VPWR VGND sg13g2_decap_4
XFILLER_24_323 VPWR VGND sg13g2_fill_1
XFILLER_12_507 VPWR VGND sg13g2_decap_8
X_4958_ net349 VGND VPWR _0415_ tmds_green.dc_balancing_reg\[4\] net650 sg13g2_dfrbpq_2
X_4896__431 VPWR VGND net431 sg13g2_tiehi
X_5172__235 VPWR VGND net235 sg13g2_tiehi
X_4889_ net441 VGND VPWR _0350_ videogen.fancy_shader.video_y\[7\] net643 sg13g2_dfrbpq_2
X_3909_ _1621_ _1622_ _1623_ VPWR VGND sg13g2_nor2_1
XFILLER_20_551 VPWR VGND sg13g2_decap_4
XFILLER_20_595 VPWR VGND sg13g2_decap_4
XFILLER_10_21 VPWR VGND sg13g2_decap_8
XFILLER_3_238 VPWR VGND sg13g2_decap_4
XFILLER_0_945 VPWR VGND sg13g2_decap_8
XFILLER_19_128 VPWR VGND sg13g2_decap_8
XFILLER_47_448 VPWR VGND sg13g2_decap_8
XFILLER_15_312 VPWR VGND sg13g2_decap_8
XFILLER_27_194 VPWR VGND sg13g2_decap_8
XFILLER_43_676 VPWR VGND sg13g2_decap_8
XFILLER_42_131 VPWR VGND sg13g2_decap_8
XFILLER_15_378 VPWR VGND sg13g2_decap_8
XFILLER_7_511 VPWR VGND sg13g2_decap_8
XFILLER_7_577 VPWR VGND sg13g2_decap_4
XFILLER_3_783 VPWR VGND sg13g2_decap_8
XFILLER_2_271 VPWR VGND sg13g2_decap_8
XFILLER_18_4 VPWR VGND sg13g2_decap_4
XFILLER_18_172 VPWR VGND sg13g2_decap_8
XFILLER_34_621 VPWR VGND sg13g2_fill_1
XFILLER_34_654 VPWR VGND sg13g2_fill_1
X_4812_ net166 VGND VPWR _0273_ serialize.shift_reg_c\[4\] clknet_3_2__leaf_clk_regs
+ sg13g2_dfrbpq_1
X_4743_ net680 net724 _0207_ VPWR VGND sg13g2_nor2_1
X_4839__123 VPWR VGND net123 sg13g2_tiehi
X_4674_ net688 net731 _0138_ VPWR VGND sg13g2_nor2_1
X_3625_ _1339_ _1340_ _1341_ _1342_ _1343_ VPWR VGND sg13g2_nor4_1
X_3556_ net621 VPWR _1274_ VGND _1270_ _1273_ sg13g2_o21ai_1
X_3487_ VGND VPWR _1015_ _1202_ _1205_ _1204_ sg13g2_a21oi_1
X_5157_ net319 VGND VPWR _0614_ blue_tmds_par\[1\] net652 sg13g2_dfrbpq_1
X_4108_ _1818_ _1817_ _1811_ _1819_ VPWR VGND sg13g2_a21o_1
X_5088_ net370 VGND VPWR _0545_ videogen.test_lut_thingy.pixel_feeder_inst.row\[48\]\[0\]
+ _0173_ sg13g2_dfrbpq_1
XFILLER_37_470 VPWR VGND sg13g2_fill_1
X_4039_ _1730_ VPWR _1750_ VGND _1734_ _1738_ sg13g2_o21ai_1
XFILLER_25_621 VPWR VGND sg13g2_decap_8
XFILLER_13_805 VPWR VGND sg13g2_decap_8
XFILLER_24_131 VPWR VGND sg13g2_decap_8
XFILLER_24_153 VPWR VGND sg13g2_decap_8
XFILLER_40_613 VPWR VGND sg13g2_fill_1
XFILLER_40_657 VPWR VGND sg13g2_fill_1
XFILLER_20_370 VPWR VGND sg13g2_decap_8
X_5029__208 VPWR VGND net208 sg13g2_tiehi
XFILLER_0_742 VPWR VGND sg13g2_decap_8
XFILLER_47_278 VPWR VGND sg13g2_decap_8
XFILLER_46_61 VPWR VGND sg13g2_decap_8
XFILLER_44_930 VPWR VGND sg13g2_decap_8
XFILLER_28_470 VPWR VGND sg13g2_fill_2
XFILLER_16_665 VPWR VGND sg13g2_fill_2
XFILLER_8_875 VPWR VGND sg13g2_fill_1
XFILLER_7_352 VPWR VGND sg13g2_decap_4
X_4390_ _2072_ tmds_blue.dc_balancing_reg\[1\] _2069_ VPWR VGND sg13g2_xnor2_1
X_3410_ _1114_ _1126_ _1015_ _1128_ VPWR VGND sg13g2_nand3_1
X_3341_ _1050_ VPWR _1059_ VGND _1054_ _1058_ sg13g2_o21ai_1
X_3272_ videogen.fancy_shader.shader_counter_reg\[0\] net613 _0990_ VPWR VGND sg13g2_xor2_1
X_5011_ net244 VGND VPWR _0468_ videogen.test_lut_thingy.pixel_feeder_inst.row\[60\]\[0\]
+ _0105_ sg13g2_dfrbpq_1
XFILLER_35_974 VPWR VGND sg13g2_decap_8
XFILLER_21_134 VPWR VGND sg13g2_decap_8
X_2987_ videogen.test_lut_thingy.pixel_feeder_inst.row\[37\]\[2\] net773 _0821_ _0325_
+ VPWR VGND sg13g2_mux2_1
X_4726_ net668 net712 _0190_ VPWR VGND sg13g2_nor2_1
X_4893__434 VPWR VGND net434 sg13g2_tiehi
X_4657_ net675 net719 _0121_ VPWR VGND sg13g2_nor2_1
X_3608_ _1326_ _1277_ _1325_ videogen.test_lut_thingy.gol_counter_reg\[3\] _0689_
+ VPWR VGND sg13g2_a22oi_1
X_4588_ net710 net753 _0052_ VPWR VGND sg13g2_nor2_1
X_3539_ videogen.test_lut_thingy.pixel_feeder_inst.row\[43\]\[3\] net567 _1257_ VPWR
+ VGND sg13g2_nor2_1
XFILLER_27_1017 VPWR VGND sg13g2_decap_8
XFILLER_27_1028 VPWR VGND sg13g2_fill_1
X_5209_ net148 VGND VPWR _0666_ videogen.test_lut_thingy.pixel_feeder_inst.row\[21\]\[2\]
+ _0259_ sg13g2_dfrbpq_1
XFILLER_26_941 VPWR VGND sg13g2_decap_8
XFILLER_25_484 VPWR VGND sg13g2_decap_8
XFILLER_13_646 VPWR VGND sg13g2_fill_1
XFILLER_41_999 VPWR VGND sg13g2_decap_8
XFILLER_40_476 VPWR VGND sg13g2_fill_2
XFILLER_40_465 VPWR VGND sg13g2_decap_8
XFILLER_8_149 VPWR VGND sg13g2_decap_8
XFILLER_21_690 VPWR VGND sg13g2_decap_8
XFILLER_5_823 VPWR VGND sg13g2_fill_1
XFILLER_32_96 VPWR VGND sg13g2_fill_2
XFILLER_4_388 VPWR VGND sg13g2_fill_2
XFILLER_4_377 VPWR VGND sg13g2_fill_2
XFILLER_48_521 VPWR VGND sg13g2_decap_8
XFILLER_48_598 VPWR VGND sg13g2_decap_8
XFILLER_16_440 VPWR VGND sg13g2_fill_1
XFILLER_17_963 VPWR VGND sg13g2_decap_8
X_2910_ _0750_ _0803_ _0806_ VPWR VGND sg13g2_nor2_2
XFILLER_43_281 VPWR VGND sg13g2_fill_2
X_3890_ _1596_ _1598_ _1604_ VPWR VGND sg13g2_nor2_1
X_2841_ videogen.test_lut_thingy.pixel_feeder_inst.row\[35\]\[0\] net796 _0789_ _0509_
+ VPWR VGND sg13g2_mux2_1
XFILLER_31_465 VPWR VGND sg13g2_decap_8
XFILLER_31_487 VPWR VGND sg13g2_fill_1
X_2772_ _0758_ _0765_ _0776_ VPWR VGND sg13g2_nor2_2
X_4511_ _2170_ net661 net464 net666 green_tmds_par\[1\] VPWR VGND sg13g2_a22oi_1
X_4836__126 VPWR VGND net126 sg13g2_tiehi
X_4442_ _2104_ _2120_ _2096_ _2122_ VPWR VGND sg13g2_nand3_1
X_4373_ _0688_ _1994_ _2059_ VPWR VGND sg13g2_nor2_1
Xfanout607 net608 net607 VPWR VGND sg13g2_buf_2
X_3324_ net611 videogen.fancy_shader.shader_counter_reg\[6\] _1042_ VPWR VGND sg13g2_and2_1
Xfanout618 videogen.test_lut_thingy.pixel_feeder_inst.h_pix\[3\] net618 VPWR VGND
+ sg13g2_buf_8
Xfanout629 net630 net629 VPWR VGND sg13g2_buf_8
XFILLER_39_510 VPWR VGND sg13g2_fill_2
X_3255_ _0979_ videogen.fancy_shader.video_y\[9\] _0977_ VPWR VGND sg13g2_xnor2_1
X_3186_ videogen.test_lut_thingy.pixel_feeder_inst.h_counter\[1\] _0828_ _0934_ VPWR
+ VGND sg13g2_and2_1
XFILLER_2_1019 VPWR VGND sg13g2_decap_8
XFILLER_26_237 VPWR VGND sg13g2_fill_1
XFILLER_23_944 VPWR VGND sg13g2_decap_8
XFILLER_33_1021 VPWR VGND sg13g2_decap_8
X_4709_ net683 net727 _0173_ VPWR VGND sg13g2_nor2_1
XFILLER_2_837 VPWR VGND sg13g2_decap_8
XFILLER_49_318 VPWR VGND sg13g2_decap_8
XFILLER_45_502 VPWR VGND sg13g2_fill_2
XFILLER_18_738 VPWR VGND sg13g2_decap_8
XFILLER_18_749 VPWR VGND sg13g2_fill_1
XFILLER_45_568 VPWR VGND sg13g2_decap_4
XFILLER_26_793 VPWR VGND sg13g2_decap_8
XFILLER_40_240 VPWR VGND sg13g2_decap_8
XFILLER_9_403 VPWR VGND sg13g2_decap_8
XFILLER_9_414 VPWR VGND sg13g2_fill_1
XFILLER_14_977 VPWR VGND sg13g2_decap_8
XFILLER_4_130 VPWR VGND sg13g2_fill_1
X_3040_ VGND VPWR net594 net10 _0849_ net553 sg13g2_a21oi_2
XFILLER_36_502 VPWR VGND sg13g2_decap_8
XFILLER_49_896 VPWR VGND sg13g2_decap_8
XFILLER_48_395 VPWR VGND sg13g2_decap_8
X_4991_ net284 VGND VPWR _0448_ videogen.test_lut_thingy.pixel_feeder_inst.row\[0\]\[0\]
+ _0085_ sg13g2_dfrbpq_1
XFILLER_17_1005 VPWR VGND sg13g2_decap_8
X_3942_ _1656_ _1640_ _1646_ VPWR VGND sg13g2_xnor2_1
X_3873_ _1052_ _1582_ _1587_ VPWR VGND sg13g2_nor2_1
X_2824_ videogen.test_lut_thingy.pixel_feeder_inst.row\[54\]\[2\] net778 _0786_ _0523_
+ VPWR VGND sg13g2_mux2_1
XFILLER_20_947 VPWR VGND sg13g2_decap_8
X_2755_ videogen.test_lut_thingy.pixel_feeder_inst.row\[42\]\[3\] net763 _0770_ _0576_
+ VPWR VGND sg13g2_mux2_1
X_2686_ _0742_ _0691_ _0738_ VPWR VGND sg13g2_nand2_2
X_4425_ VPWR _2105_ _2104_ VGND sg13g2_inv_1
X_4356_ _2045_ _2032_ _2043_ VPWR VGND sg13g2_xnor2_1
X_3307_ _1025_ net636 videogen.fancy_shader.shader_counter_reg\[4\] VPWR VGND sg13g2_nand2_1
X_4287_ VGND VPWR red\[0\] _1987_ _0375_ _1988_ sg13g2_a21oi_1
X_3238_ net806 VPWR _0968_ VGND videogen.fancy_shader.video_y\[3\] _0967_ sg13g2_o21ai_1
X_3169_ _0922_ _0895_ _0899_ VPWR VGND sg13g2_nand2b_1
XFILLER_27_535 VPWR VGND sg13g2_decap_4
XFILLER_27_579 VPWR VGND sg13g2_fill_2
X_5175__211 VPWR VGND net211 sg13g2_tiehi
XFILLER_23_774 VPWR VGND sg13g2_decap_8
XFILLER_11_936 VPWR VGND sg13g2_decap_8
XFILLER_6_417 VPWR VGND sg13g2_decap_8
XFILLER_10_457 VPWR VGND sg13g2_decap_4
XFILLER_13_76 VPWR VGND sg13g2_fill_1
XFILLER_2_656 VPWR VGND sg13g2_fill_2
XFILLER_1_177 VPWR VGND sg13g2_decap_8
XFILLER_46_800 VPWR VGND sg13g2_decap_8
XFILLER_38_40 VPWR VGND sg13g2_decap_8
XFILLER_18_524 VPWR VGND sg13g2_fill_2
XFILLER_46_877 VPWR VGND sg13g2_decap_8
XFILLER_14_730 VPWR VGND sg13g2_fill_1
XFILLER_13_251 VPWR VGND sg13g2_decap_8
X_5154__339 VPWR VGND net339 sg13g2_tiehi
XFILLER_14_785 VPWR VGND sg13g2_fill_1
XFILLER_6_962 VPWR VGND sg13g2_decap_8
X_4833__129 VPWR VGND net129 sg13g2_tiehi
X_4210_ _1912_ _1915_ _1916_ VPWR VGND sg13g2_and2_1
X_5190_ net403 VGND VPWR _0647_ serialize.shift_reg_g\[0\] clknet_3_5__leaf_clk_regs
+ sg13g2_dfrbpq_1
X_4141_ net1 _1851_ _1852_ VPWR VGND sg13g2_and2_1
X_4072_ _1776_ VPWR _1783_ VGND _1771_ _1779_ sg13g2_o21ai_1
XFILLER_49_671 VPWR VGND sg13g2_decap_8
X_3023_ _0681_ _0700_ _0839_ VPWR VGND sg13g2_and2_1
XFILLER_36_310 VPWR VGND sg13g2_decap_4
XFILLER_36_332 VPWR VGND sg13g2_fill_1
XFILLER_36_354 VPWR VGND sg13g2_decap_8
X_4974_ net318 VGND VPWR _0431_ videogen.test_lut_thingy.pixel_feeder_inst.row\[9\]\[3\]
+ _0068_ sg13g2_dfrbpq_1
XFILLER_17_590 VPWR VGND sg13g2_fill_2
X_3925_ _1639_ _1143_ _1582_ VPWR VGND sg13g2_xnor2_1
XFILLER_20_733 VPWR VGND sg13g2_decap_8
XFILLER_32_593 VPWR VGND sg13g2_decap_4
X_3856_ net614 VPWR _1573_ VGND net615 _1572_ sg13g2_o21ai_1
XFILLER_20_799 VPWR VGND sg13g2_fill_2
X_3787_ net598 _1499_ _1504_ _1505_ VPWR VGND sg13g2_nor3_1
X_2807_ _0750_ _0752_ _0783_ VPWR VGND sg13g2_nor2_2
XFILLER_30_1024 VPWR VGND sg13g2_decap_4
X_2738_ videogen.test_lut_thingy.pixel_feeder_inst.row\[3\]\[2\] net780 _0764_ _0587_
+ VPWR VGND sg13g2_mux2_1
X_4408_ _2088_ _2087_ _2089_ VPWR VGND sg13g2_xor2_1
X_2669_ _0706_ VPWR _0733_ VGND net622 net580 sg13g2_o21ai_1
X_4339_ net554 VPWR _2029_ VGND _2026_ _2028_ sg13g2_o21ai_1
XFILLER_47_619 VPWR VGND sg13g2_decap_8
XFILLER_28_800 VPWR VGND sg13g2_fill_2
XFILLER_39_181 VPWR VGND sg13g2_decap_8
XFILLER_27_332 VPWR VGND sg13g2_fill_1
XFILLER_28_866 VPWR VGND sg13g2_fill_2
XFILLER_28_888 VPWR VGND sg13g2_fill_2
XFILLER_28_899 VPWR VGND sg13g2_decap_8
XFILLER_42_346 VPWR VGND sg13g2_fill_1
XFILLER_23_582 VPWR VGND sg13g2_fill_1
XFILLER_10_243 VPWR VGND sg13g2_decap_8
XFILLER_7_704 VPWR VGND sg13g2_fill_1
XFILLER_24_86 VPWR VGND sg13g2_fill_1
XFILLER_10_276 VPWR VGND sg13g2_decap_4
XFILLER_3_965 VPWR VGND sg13g2_decap_8
XFILLER_2_475 VPWR VGND sg13g2_fill_2
Xfanout790 net792 net790 VPWR VGND sg13g2_buf_8
XFILLER_1_35 VPWR VGND sg13g2_decap_8
XFILLER_19_822 VPWR VGND sg13g2_decap_8
XFILLER_37_107 VPWR VGND sg13g2_fill_1
X_5008__250 VPWR VGND net250 sg13g2_tiehi
XFILLER_19_844 VPWR VGND sg13g2_fill_1
XFILLER_19_877 VPWR VGND sg13g2_decap_8
XFILLER_33_346 VPWR VGND sg13g2_fill_1
XFILLER_34_858 VPWR VGND sg13g2_decap_8
X_3710_ videogen.test_lut_thingy.pixel_feeder_inst.row\[34\]\[1\] net588 _1428_ VPWR
+ VGND sg13g2_nor2_1
XFILLER_14_1019 VPWR VGND sg13g2_decap_8
X_4690_ net678 net722 _0154_ VPWR VGND sg13g2_nor2_1
X_4993__280 VPWR VGND net280 sg13g2_tiehi
X_3641_ videogen.test_lut_thingy.pixel_feeder_inst.row\[16\]\[2\] net582 _1359_ VPWR
+ VGND sg13g2_nor2_1
X_3572_ videogen.test_lut_thingy.pixel_feeder_inst.row\[28\]\[3\] net578 _1290_ VPWR
+ VGND sg13g2_nor2_1
X_5137__99 VPWR VGND net99 sg13g2_tiehi
X_5089__366 VPWR VGND net366 sg13g2_tiehi
X_5173_ net227 VGND VPWR _0630_ videogen.test_lut_thingy.pixel_feeder_inst.row\[24\]\[3\]
+ _0248_ sg13g2_dfrbpq_1
XFILLER_39_0 VPWR VGND sg13g2_decap_8
X_4124_ _1835_ _1830_ _1834_ VPWR VGND sg13g2_nand2_1
X_5165__287 VPWR VGND net287 sg13g2_tiehi
Xinput1 ui_in[0] net1 VPWR VGND sg13g2_buf_2
XFILLER_28_118 VPWR VGND sg13g2_fill_2
X_4055_ _1681_ _1765_ _1766_ VPWR VGND sg13g2_nor2_1
X_3006_ videogen.test_lut_thingy.pixel_feeder_inst.row\[20\]\[3\] net767 _0825_ _0277_
+ VPWR VGND sg13g2_mux2_1
XFILLER_24_346 VPWR VGND sg13g2_fill_2
X_4957_ net350 VGND VPWR _0414_ tmds_green.dc_balancing_reg\[3\] net650 sg13g2_dfrbpq_2
X_3908_ VGND VPWR _1607_ _1620_ _1622_ _1596_ sg13g2_a21oi_1
X_4888_ net443 VGND VPWR _0349_ videogen.fancy_shader.video_y\[6\] net643 sg13g2_dfrbpq_1
X_3839_ _1532_ VPWR _1556_ VGND videogen.test_lut_thingy.pixel_feeder_inst.row\[52\]\[0\]
+ net580 sg13g2_o21ai_1
XFILLER_0_924 VPWR VGND sg13g2_decap_8
XFILLER_47_427 VPWR VGND sg13g2_decap_8
XFILLER_19_42 VPWR VGND sg13g2_decap_8
XFILLER_19_86 VPWR VGND sg13g2_decap_8
XFILLER_28_630 VPWR VGND sg13g2_decap_8
XFILLER_16_803 VPWR VGND sg13g2_decap_4
XFILLER_27_162 VPWR VGND sg13g2_decap_8
XFILLER_28_685 VPWR VGND sg13g2_decap_8
XFILLER_43_644 VPWR VGND sg13g2_decap_4
XFILLER_15_324 VPWR VGND sg13g2_decap_8
XFILLER_15_335 VPWR VGND sg13g2_fill_1
XFILLER_27_173 VPWR VGND sg13g2_fill_2
XFILLER_35_30 VPWR VGND sg13g2_fill_2
XFILLER_31_839 VPWR VGND sg13g2_fill_1
XFILLER_39_928 VPWR VGND sg13g2_fill_1
XFILLER_38_427 VPWR VGND sg13g2_decap_8
XFILLER_34_600 VPWR VGND sg13g2_fill_1
X_4811_ net167 VGND VPWR _0272_ serialize.shift_reg_c\[3\] clknet_3_2__leaf_clk_regs
+ sg13g2_dfrbpq_1
XFILLER_33_132 VPWR VGND sg13g2_decap_8
XFILLER_33_154 VPWR VGND sg13g2_decap_8
X_4742_ net670 net715 _0206_ VPWR VGND sg13g2_nor2_1
X_5070__57 VPWR VGND net57 sg13g2_tiehi
X_4673_ net677 net721 _0137_ VPWR VGND sg13g2_nor2_1
XFILLER_30_883 VPWR VGND sg13g2_fill_1
X_3624_ videogen.test_lut_thingy.pixel_feeder_inst.row\[12\]\[2\] net583 _1342_ VPWR
+ VGND sg13g2_nor2_1
X_3555_ _1272_ VPWR _1273_ VGND videogen.test_lut_thingy.pixel_feeder_inst.row\[45\]\[3\]
+ net557 sg13g2_o21ai_1
XFILLER_0_209 VPWR VGND sg13g2_decap_8
X_3486_ _1015_ _1203_ _1204_ VPWR VGND sg13g2_nor2_1
X_5156_ net323 VGND VPWR _0613_ blue_tmds_par\[0\] net654 sg13g2_dfrbpq_1
XFILLER_45_909 VPWR VGND sg13g2_decap_8
X_4107_ _1813_ VPWR _1818_ VGND _1803_ _1806_ sg13g2_o21ai_1
XFILLER_29_438 VPWR VGND sg13g2_decap_4
X_5087_ net374 VGND VPWR _0544_ videogen.test_lut_thingy.pixel_feeder_inst.row\[4\]\[3\]
+ _0172_ sg13g2_dfrbpq_1
X_4038_ _1749_ _1740_ _1748_ VPWR VGND sg13g2_nand2_1
XFILLER_25_677 VPWR VGND sg13g2_decap_8
XFILLER_20_393 VPWR VGND sg13g2_fill_1
XFILLER_21_894 VPWR VGND sg13g2_fill_2
XFILLER_21_76 VPWR VGND sg13g2_fill_1
XFILLER_21_98 VPWR VGND sg13g2_fill_2
XFILLER_43_1012 VPWR VGND sg13g2_decap_8
XFILLER_47_213 VPWR VGND sg13g2_fill_2
XFILLER_0_798 VPWR VGND sg13g2_decap_8
XFILLER_47_246 VPWR VGND sg13g2_decap_4
X_5109__277 VPWR VGND net277 sg13g2_tiehi
XFILLER_15_110 VPWR VGND sg13g2_fill_2
XFILLER_16_633 VPWR VGND sg13g2_decap_8
XFILLER_29_994 VPWR VGND sg13g2_decap_8
XFILLER_44_986 VPWR VGND sg13g2_decap_8
XFILLER_7_34 VPWR VGND sg13g2_fill_2
XFILLER_12_894 VPWR VGND sg13g2_decap_8
X_3340_ VPWR _1058_ _1057_ VGND sg13g2_inv_1
X_5010_ net246 VGND VPWR _0467_ videogen.test_lut_thingy.pixel_feeder_inst.row\[61\]\[3\]
+ _0104_ sg13g2_dfrbpq_1
X_3271_ _0989_ net613 videogen.fancy_shader.shader_counter_reg\[0\] VPWR VGND sg13g2_nand2_1
XFILLER_35_953 VPWR VGND sg13g2_decap_8
XFILLER_34_485 VPWR VGND sg13g2_fill_2
XFILLER_22_669 VPWR VGND sg13g2_fill_1
X_2986_ videogen.test_lut_thingy.pixel_feeder_inst.row\[37\]\[3\] net762 _0821_ _0326_
+ VPWR VGND sg13g2_mux2_1
X_4725_ net668 net712 _0189_ VPWR VGND sg13g2_nor2_1
X_4656_ net674 net718 _0120_ VPWR VGND sg13g2_nor2_1
X_4587_ net710 net753 _0051_ VPWR VGND sg13g2_nor2_1
X_3607_ _0689_ _1324_ _1325_ VPWR VGND sg13g2_nor2_1
X_3538_ videogen.test_lut_thingy.pixel_feeder_inst.row\[42\]\[3\] net587 _1256_ VPWR
+ VGND sg13g2_nor2_1
XFILLER_1_518 VPWR VGND sg13g2_decap_8
X_3469_ net547 _1081_ _1187_ VPWR VGND sg13g2_nor2_1
X_5208_ net190 VGND VPWR _0665_ videogen.test_lut_thingy.pixel_feeder_inst.row\[21\]\[1\]
+ _0258_ sg13g2_dfrbpq_1
X_5139_ net83 VGND VPWR _0596_ videogen.test_lut_thingy.pixel_feeder_inst.row\[63\]\[3\]
+ _0224_ sg13g2_dfrbpq_1
XFILLER_29_213 VPWR VGND sg13g2_fill_2
XFILLER_29_257 VPWR VGND sg13g2_decap_4
XFILLER_44_238 VPWR VGND sg13g2_fill_2
XFILLER_41_901 VPWR VGND sg13g2_fill_1
XFILLER_41_934 VPWR VGND sg13g2_decap_4
XFILLER_40_411 VPWR VGND sg13g2_fill_2
XFILLER_40_400 VPWR VGND sg13g2_decap_8
XFILLER_16_65 VPWR VGND sg13g2_fill_1
XFILLER_16_87 VPWR VGND sg13g2_decap_8
XFILLER_26_997 VPWR VGND sg13g2_decap_8
XFILLER_16_98 VPWR VGND sg13g2_fill_1
XFILLER_41_978 VPWR VGND sg13g2_decap_8
XFILLER_8_117 VPWR VGND sg13g2_decap_8
XFILLER_32_53 VPWR VGND sg13g2_decap_4
XFILLER_10_1011 VPWR VGND sg13g2_decap_8
XFILLER_48_500 VPWR VGND sg13g2_decap_8
XFILLER_0_584 VPWR VGND sg13g2_decap_8
XFILLER_48_577 VPWR VGND sg13g2_decap_8
XFILLER_35_227 VPWR VGND sg13g2_fill_2
XFILLER_17_942 VPWR VGND sg13g2_decap_8
XFILLER_32_901 VPWR VGND sg13g2_fill_1
XFILLER_31_444 VPWR VGND sg13g2_fill_2
X_2840_ videogen.test_lut_thingy.pixel_feeder_inst.row\[35\]\[1\] net787 _0789_ _0510_
+ VPWR VGND sg13g2_mux2_1
XFILLER_32_989 VPWR VGND sg13g2_decap_8
X_2771_ videogen.test_lut_thingy.pixel_feeder_inst.row\[44\]\[0\] net794 _0774_ _0565_
+ VPWR VGND sg13g2_mux2_1
XFILLER_12_680 VPWR VGND sg13g2_fill_1
X_4510_ VPWR _0649_ _2169_ VGND sg13g2_inv_1
X_4441_ _2120_ _2096_ _2108_ _2121_ VPWR VGND sg13g2_a21o_1
XFILLER_8_684 VPWR VGND sg13g2_decap_8
X_4372_ VGND VPWR _0685_ net610 _0488_ net759 sg13g2_a21oi_1
X_3323_ _1041_ videogen.fancy_shader.video_y\[7\] videogen.fancy_shader.shader_counter_reg\[7\]
+ VPWR VGND sg13g2_xnor2_1
Xfanout619 net620 net619 VPWR VGND sg13g2_buf_8
Xfanout608 blue\[0\] net608 VPWR VGND sg13g2_buf_1
X_3254_ _0351_ _0978_ _0879_ _0976_ _0675_ VPWR VGND sg13g2_a22oi_1
X_3185_ videogen.test_lut_thingy.pixel_feeder_inst.h_counter\[1\] _0828_ _0933_ VPWR
+ VGND sg13g2_nor2_1
XFILLER_27_706 VPWR VGND sg13g2_fill_2
XFILLER_23_923 VPWR VGND sg13g2_decap_8
XFILLER_35_783 VPWR VGND sg13g2_decap_4
XFILLER_22_433 VPWR VGND sg13g2_decap_4
XFILLER_33_1000 VPWR VGND sg13g2_decap_8
X_2969_ videogen.test_lut_thingy.pixel_feeder_inst.row\[17\]\[0\] net803 _0817_ _0391_
+ VPWR VGND sg13g2_mux2_1
X_5134__134 VPWR VGND net134 sg13g2_tiehi
X_4708_ net706 net750 _0172_ VPWR VGND sg13g2_nor2_1
XFILLER_2_816 VPWR VGND sg13g2_decap_8
X_4639_ net699 net743 _0103_ VPWR VGND sg13g2_nor2_1
XFILLER_1_337 VPWR VGND sg13g2_decap_8
XFILLER_40_1026 VPWR VGND sg13g2_fill_2
XFILLER_17_227 VPWR VGND sg13g2_decap_8
XFILLER_27_97 VPWR VGND sg13g2_decap_8
XFILLER_32_219 VPWR VGND sg13g2_fill_2
XFILLER_41_720 VPWR VGND sg13g2_fill_2
XFILLER_14_956 VPWR VGND sg13g2_decap_8
XFILLER_9_426 VPWR VGND sg13g2_decap_8
XFILLER_13_444 VPWR VGND sg13g2_fill_2
XFILLER_9_437 VPWR VGND sg13g2_decap_8
XFILLER_5_665 VPWR VGND sg13g2_decap_8
XFILLER_49_875 VPWR VGND sg13g2_decap_8
X_5046__183 VPWR VGND net183 sg13g2_tiehi
XFILLER_17_750 VPWR VGND sg13g2_fill_1
X_4990_ net286 VGND VPWR _0447_ videogen.test_lut_thingy.pixel_feeder_inst.row\[11\]\[3\]
+ _0084_ sg13g2_dfrbpq_1
X_4842__120 VPWR VGND net120 sg13g2_tiehi
XFILLER_17_794 VPWR VGND sg13g2_fill_1
X_3941_ _1655_ _1584_ _1654_ VPWR VGND sg13g2_nand2_1
XFILLER_32_731 VPWR VGND sg13g2_fill_2
X_3872_ _1586_ _1015_ _1585_ VPWR VGND sg13g2_xnor2_1
XFILLER_17_1028 VPWR VGND sg13g2_fill_1
XFILLER_20_926 VPWR VGND sg13g2_decap_8
X_2823_ videogen.test_lut_thingy.pixel_feeder_inst.row\[54\]\[3\] net767 _0786_ _0524_
+ VPWR VGND sg13g2_mux2_1
XFILLER_31_263 VPWR VGND sg13g2_decap_8
X_2754_ _0765_ _0769_ _0770_ VPWR VGND sg13g2_nor2_2
X_5018__230 VPWR VGND net230 sg13g2_tiehi
XFILLER_8_470 VPWR VGND sg13g2_fill_1
XFILLER_9_993 VPWR VGND sg13g2_decap_8
X_2685_ videogen.test_lut_thingy.pixel_feeder_inst.row\[24\]\[0\] net797 _0741_ _0627_
+ VPWR VGND sg13g2_mux2_1
X_4424_ _2102_ _2101_ _2104_ VPWR VGND sg13g2_xor2_1
X_4355_ VGND VPWR _2044_ _2043_ _2032_ sg13g2_or2_1
X_3306_ _1024_ videogen.fancy_shader.video_x\[5\] videogen.fancy_shader.shader_counter_reg\[5\]
+ VPWR VGND sg13g2_nand2_1
X_4286_ _0957_ VPWR _1988_ VGND red\[0\] _1987_ sg13g2_o21ai_1
X_3237_ _0967_ videogen.fancy_shader.video_y\[2\] _0850_ _0877_ VPWR VGND sg13g2_and3_1
X_3168_ _0843_ _0921_ _0314_ VPWR VGND sg13g2_nor2_1
XFILLER_42_506 VPWR VGND sg13g2_fill_2
X_3099_ _0873_ _0875_ _0876_ VPWR VGND sg13g2_nor2b_1
XFILLER_23_731 VPWR VGND sg13g2_fill_2
XFILLER_11_915 VPWR VGND sg13g2_decap_8
XFILLER_22_296 VPWR VGND sg13g2_decap_4
XFILLER_13_88 VPWR VGND sg13g2_decap_8
XFILLER_8_4 VPWR VGND sg13g2_decap_8
XFILLER_2_679 VPWR VGND sg13g2_decap_8
XFILLER_1_156 VPWR VGND sg13g2_decap_8
XFILLER_49_149 VPWR VGND sg13g2_decap_4
XFILLER_46_856 VPWR VGND sg13g2_decap_8
XFILLER_45_388 VPWR VGND sg13g2_fill_1
XFILLER_33_517 VPWR VGND sg13g2_decap_8
XFILLER_26_591 VPWR VGND sg13g2_decap_4
XFILLER_33_539 VPWR VGND sg13g2_fill_2
XFILLER_41_561 VPWR VGND sg13g2_fill_1
XFILLER_41_550 VPWR VGND sg13g2_decap_8
XFILLER_6_941 VPWR VGND sg13g2_decap_8
XFILLER_5_484 VPWR VGND sg13g2_decap_8
X_4140_ _1843_ VPWR _1851_ VGND _1847_ _1850_ sg13g2_o21ai_1
XFILLER_49_650 VPWR VGND sg13g2_decap_8
X_4071_ _1780_ _1781_ _1782_ VPWR VGND sg13g2_nor2b_1
XFILLER_23_1021 VPWR VGND sg13g2_decap_8
X_3022_ videogen.fancy_shader.video_x\[6\] _0837_ _0838_ VPWR VGND sg13g2_and2_1
XFILLER_37_845 VPWR VGND sg13g2_decap_4
X_4973_ net320 VGND VPWR _0430_ videogen.test_lut_thingy.pixel_feeder_inst.row\[9\]\[2\]
+ _0067_ sg13g2_dfrbpq_1
X_3924_ _1636_ _1586_ _1638_ VPWR VGND sg13g2_xor2_1
X_3855_ net617 _1568_ _1569_ _1571_ _1570_ net596 _1572_ VPWR VGND sg13g2_mux4_1
X_3786_ _1500_ _1501_ _1502_ _1503_ _1504_ VPWR VGND sg13g2_nor4_1
XFILLER_30_1003 VPWR VGND sg13g2_decap_8
X_2806_ videogen.test_lut_thingy.pixel_feeder_inst.row\[50\]\[0\] net797 _0782_ _0537_
+ VPWR VGND sg13g2_mux2_1
X_2737_ videogen.test_lut_thingy.pixel_feeder_inst.row\[3\]\[3\] net769 _0764_ _0588_
+ VPWR VGND sg13g2_mux2_1
X_2668_ _0707_ _0715_ _0732_ VPWR VGND sg13g2_nor2_2
X_4407_ net606 _2071_ _2088_ VPWR VGND sg13g2_nor2_1
X_2599_ VPWR _0672_ videogen.test_lut_thingy.pixel_feeder_inst.row\[61\]\[1\] VGND
+ sg13g2_inv_1
X_4338_ _2028_ net605 _2027_ VPWR VGND sg13g2_nand2_1
X_4269_ _1972_ VPWR _1973_ VGND _1919_ _1963_ sg13g2_o21ai_1
XFILLER_46_108 VPWR VGND sg13g2_fill_1
XFILLER_11_712 VPWR VGND sg13g2_decap_8
XFILLER_23_561 VPWR VGND sg13g2_fill_1
XFILLER_7_727 VPWR VGND sg13g2_decap_4
XFILLER_40_31 VPWR VGND sg13g2_decap_4
XFILLER_10_288 VPWR VGND sg13g2_fill_2
XFILLER_3_944 VPWR VGND sg13g2_decap_8
X_4832__130 VPWR VGND net130 sg13g2_tiehi
XFILLER_46_1010 VPWR VGND sg13g2_decap_8
XFILLER_1_14 VPWR VGND sg13g2_decap_8
Xfanout791 net792 net791 VPWR VGND sg13g2_buf_1
Xfanout780 net781 net780 VPWR VGND sg13g2_buf_8
XFILLER_34_815 VPWR VGND sg13g2_fill_2
XFILLER_34_826 VPWR VGND sg13g2_decap_4
XFILLER_33_336 VPWR VGND sg13g2_decap_4
XFILLER_33_358 VPWR VGND sg13g2_fill_1
X_3640_ videogen.test_lut_thingy.pixel_feeder_inst.row\[19\]\[2\] net571 _1358_ VPWR
+ VGND sg13g2_nor2_1
X_3571_ net623 VPWR _1289_ VGND videogen.test_lut_thingy.pixel_feeder_inst.row\[31\]\[3\]
+ net568 sg13g2_o21ai_1
X_5172_ net235 VGND VPWR _0629_ videogen.test_lut_thingy.pixel_feeder_inst.row\[24\]\[2\]
+ _0247_ sg13g2_dfrbpq_1
X_4123_ _1822_ VPWR _1834_ VGND _1831_ _1833_ sg13g2_o21ai_1
X_4054_ VGND VPWR _1758_ _1761_ _1765_ _1764_ sg13g2_a21oi_1
Xinput2 ui_in[1] net2 VPWR VGND sg13g2_buf_2
XFILLER_37_631 VPWR VGND sg13g2_decap_4
X_3005_ _0727_ _0772_ _0825_ VPWR VGND sg13g2_nor2_2
XFILLER_25_804 VPWR VGND sg13g2_fill_2
XFILLER_25_826 VPWR VGND sg13g2_decap_8
X_4956_ net351 VGND VPWR _0413_ tmds_green.dc_balancing_reg\[2\] net650 sg13g2_dfrbpq_2
X_4887_ net445 VGND VPWR _0348_ videogen.fancy_shader.video_y\[5\] net643 sg13g2_dfrbpq_2
X_3907_ _1621_ _1596_ _1607_ _1620_ VPWR VGND sg13g2_and3_1
XFILLER_20_520 VPWR VGND sg13g2_decap_8
XFILLER_32_391 VPWR VGND sg13g2_fill_2
X_3838_ VGND VPWR net616 _1554_ _1555_ videogen.test_lut_thingy.pixel_feeder_inst.h_pix\[5\]
+ sg13g2_a21oi_1
XFILLER_4_719 VPWR VGND sg13g2_fill_2
X_3769_ _1483_ _1484_ _1485_ _1486_ _1487_ VPWR VGND sg13g2_nor4_1
XFILLER_0_903 VPWR VGND sg13g2_decap_8
XFILLER_48_929 VPWR VGND sg13g2_decap_8
XFILLER_47_406 VPWR VGND sg13g2_decap_8
XFILLER_19_65 VPWR VGND sg13g2_decap_8
XFILLER_28_675 VPWR VGND sg13g2_decap_4
XFILLER_43_623 VPWR VGND sg13g2_decap_8
XFILLER_3_752 VPWR VGND sg13g2_decap_4
XFILLER_47_984 VPWR VGND sg13g2_decap_8
XFILLER_20_1024 VPWR VGND sg13g2_decap_4
XFILLER_34_612 VPWR VGND sg13g2_decap_8
X_4810_ net168 VGND VPWR _0271_ serialize.shift_reg_c\[2\] clknet_3_3__leaf_clk_regs
+ sg13g2_dfrbpq_1
XFILLER_22_829 VPWR VGND sg13g2_decap_8
XFILLER_33_188 VPWR VGND sg13g2_decap_8
XFILLER_34_689 VPWR VGND sg13g2_fill_2
X_4741_ net671 net715 _0205_ VPWR VGND sg13g2_nor2_1
X_4672_ net685 net729 _0136_ VPWR VGND sg13g2_nor2_1
X_3623_ videogen.test_lut_thingy.pixel_feeder_inst.row\[15\]\[2\] net573 _1341_ VPWR
+ VGND sg13g2_nor2_1
X_3554_ VGND VPWR _0671_ _0713_ _1272_ _1271_ sg13g2_a21oi_1
X_3485_ _1200_ _1202_ _1203_ VPWR VGND sg13g2_and2_1
X_4869__66 VPWR VGND net66 sg13g2_tiehi
X_4884__36 VPWR VGND net36 sg13g2_tiehi
X_5155_ net331 VGND VPWR _0612_ videogen.test_lut_thingy.pixel_feeder_inst.row\[59\]\[3\]
+ _0240_ sg13g2_dfrbpq_1
XFILLER_29_406 VPWR VGND sg13g2_fill_2
XFILLER_29_428 VPWR VGND sg13g2_decap_4
X_4106_ _1807_ VPWR _1817_ VGND _1811_ _1815_ sg13g2_o21ai_1
X_5086_ net378 VGND VPWR _0543_ videogen.test_lut_thingy.pixel_feeder_inst.row\[4\]\[2\]
+ _0171_ sg13g2_dfrbpq_1
XFILLER_38_984 VPWR VGND sg13g2_decap_8
X_4037_ _1733_ _1744_ _1748_ VPWR VGND sg13g2_nor2_1
X_4939_ net371 VGND VPWR _0400_ videogen.test_lut_thingy.pixel_feeder_inst.row\[14\]\[1\]
+ _0046_ sg13g2_dfrbpq_1
XFILLER_21_862 VPWR VGND sg13g2_decap_4
XFILLER_20_361 VPWR VGND sg13g2_fill_1
XFILLER_48_726 VPWR VGND sg13g2_fill_1
XFILLER_0_777 VPWR VGND sg13g2_decap_8
XFILLER_48_759 VPWR VGND sg13g2_fill_1
XFILLER_29_973 VPWR VGND sg13g2_decap_8
XFILLER_44_965 VPWR VGND sg13g2_decap_8
XFILLER_31_648 VPWR VGND sg13g2_decap_8
XFILLER_8_811 VPWR VGND sg13g2_fill_2
XFILLER_12_851 VPWR VGND sg13g2_decap_8
XFILLER_30_147 VPWR VGND sg13g2_fill_2
XFILLER_7_321 VPWR VGND sg13g2_fill_2
X_5116__249 VPWR VGND net249 sg13g2_tiehi
XFILLER_8_899 VPWR VGND sg13g2_decap_4
XFILLER_8_866 VPWR VGND sg13g2_decap_4
X_3270_ net637 videogen.fancy_shader.shader_counter_reg\[0\] _0988_ VPWR VGND sg13g2_xor2_1
XFILLER_30_5 VPWR VGND sg13g2_fill_1
XFILLER_39_759 VPWR VGND sg13g2_decap_4
XFILLER_38_225 VPWR VGND sg13g2_fill_2
X_4962__342 VPWR VGND net342 sg13g2_tiehi
XFILLER_22_626 VPWR VGND sg13g2_decap_4
X_4724_ net674 net718 _0188_ VPWR VGND sg13g2_nor2_1
X_2985_ _0712_ _0755_ _0821_ VPWR VGND sg13g2_nor2_2
X_4655_ net674 net718 _0119_ VPWR VGND sg13g2_nor2_1
X_4586_ net708 net752 _0050_ VPWR VGND sg13g2_nor2_1
X_4852__100 VPWR VGND net100 sg13g2_tiehi
X_3606_ net614 _1300_ _1323_ _1324_ VPWR VGND sg13g2_nor3_1
X_3537_ videogen.test_lut_thingy.pixel_feeder_inst.row\[40\]\[3\] net577 _1255_ VPWR
+ VGND sg13g2_nor2_1
X_3468_ _1186_ _1179_ _1182_ VPWR VGND sg13g2_xnor2_1
X_5028__210 VPWR VGND net210 sg13g2_tiehi
X_3399_ _1117_ _1115_ _1116_ VPWR VGND sg13g2_xnor2_1
X_5207_ net215 VGND VPWR _0664_ videogen.test_lut_thingy.pixel_feeder_inst.row\[21\]\[0\]
+ _0257_ sg13g2_dfrbpq_1
X_5138_ net91 VGND VPWR _0595_ videogen.test_lut_thingy.pixel_feeder_inst.row\[63\]\[2\]
+ _0223_ sg13g2_dfrbpq_1
XFILLER_17_409 VPWR VGND sg13g2_fill_1
XFILLER_16_11 VPWR VGND sg13g2_fill_1
X_5069_ net61 VGND VPWR _0526_ videogen.test_lut_thingy.pixel_feeder_inst.row\[53\]\[1\]
+ _0154_ sg13g2_dfrbpq_1
XFILLER_26_976 VPWR VGND sg13g2_decap_8
XFILLER_41_957 VPWR VGND sg13g2_decap_8
XFILLER_5_814 VPWR VGND sg13g2_decap_8
XFILLER_32_98 VPWR VGND sg13g2_fill_1
XFILLER_4_379 VPWR VGND sg13g2_fill_1
XFILLER_0_563 VPWR VGND sg13g2_decap_8
XFILLER_48_556 VPWR VGND sg13g2_decap_8
X_4829__135 VPWR VGND net135 sg13g2_tiehi
XFILLER_17_921 VPWR VGND sg13g2_decap_8
X_5196__343 VPWR VGND net343 sg13g2_tiehi
XFILLER_17_998 VPWR VGND sg13g2_decap_8
XFILLER_31_401 VPWR VGND sg13g2_decap_8
XFILLER_43_283 VPWR VGND sg13g2_fill_1
XFILLER_31_412 VPWR VGND sg13g2_fill_2
XFILLER_32_968 VPWR VGND sg13g2_decap_8
X_2770_ videogen.test_lut_thingy.pixel_feeder_inst.row\[44\]\[1\] net784 _0774_ _0566_
+ VPWR VGND sg13g2_mux2_1
X_4440_ net606 _2072_ _2120_ VPWR VGND sg13g2_nor2_1
XFILLER_7_184 VPWR VGND sg13g2_fill_1
XFILLER_4_880 VPWR VGND sg13g2_decap_8
X_4371_ VGND VPWR _2052_ _2058_ _0415_ net555 sg13g2_a21oi_1
X_3322_ VGND VPWR _1040_ videogen.fancy_shader.shader_counter_reg\[7\] videogen.fancy_shader.video_y\[7\]
+ sg13g2_or2_1
Xfanout609 display_enable net609 VPWR VGND sg13g2_buf_8
X_3253_ _0978_ net806 _0977_ VPWR VGND sg13g2_nand2_1
X_3184_ _0828_ _0931_ _0932_ _0319_ VPWR VGND sg13g2_nor3_1
XFILLER_39_556 VPWR VGND sg13g2_decap_8
XFILLER_23_902 VPWR VGND sg13g2_decap_8
XFILLER_34_283 VPWR VGND sg13g2_fill_1
XFILLER_22_467 VPWR VGND sg13g2_decap_8
XFILLER_23_979 VPWR VGND sg13g2_decap_8
X_2968_ videogen.test_lut_thingy.pixel_feeder_inst.row\[17\]\[1\] net790 _0817_ _0392_
+ VPWR VGND sg13g2_mux2_1
X_4707_ net707 net751 _0171_ VPWR VGND sg13g2_nor2_1
X_4638_ net693 net737 _0102_ VPWR VGND sg13g2_nor2_1
X_2899_ _0722_ _0726_ _0718_ _0803_ VPWR VGND sg13g2_nand3_1
X_4569_ net709 net754 _0034_ VPWR VGND sg13g2_nor2_1
XFILLER_40_1005 VPWR VGND sg13g2_decap_8
X_5180__111 VPWR VGND net111 sg13g2_tiehi
XFILLER_45_537 VPWR VGND sg13g2_decap_8
XFILLER_45_504 VPWR VGND sg13g2_fill_1
XFILLER_26_751 VPWR VGND sg13g2_fill_2
XFILLER_43_31 VPWR VGND sg13g2_decap_4
XFILLER_14_935 VPWR VGND sg13g2_decap_8
XFILLER_22_990 VPWR VGND sg13g2_decap_8
XFILLER_4_165 VPWR VGND sg13g2_fill_2
XFILLER_4_154 VPWR VGND sg13g2_decap_8
XFILLER_48_320 VPWR VGND sg13g2_fill_1
XFILLER_1_883 VPWR VGND sg13g2_decap_8
XFILLER_49_854 VPWR VGND sg13g2_decap_8
XFILLER_0_393 VPWR VGND sg13g2_decap_4
XFILLER_36_548 VPWR VGND sg13g2_decap_4
XFILLER_17_773 VPWR VGND sg13g2_decap_8
X_3940_ _1654_ _1650_ _1652_ VPWR VGND sg13g2_xnor2_1
XFILLER_44_592 VPWR VGND sg13g2_fill_2
X_3871_ _1139_ _1582_ _1585_ VPWR VGND sg13g2_nor2_1
XFILLER_31_242 VPWR VGND sg13g2_fill_2
XFILLER_32_776 VPWR VGND sg13g2_decap_8
X_2822_ _0752_ _0756_ _0786_ VPWR VGND sg13g2_nor2_2
XFILLER_9_972 VPWR VGND sg13g2_decap_8
X_2753_ VGND VPWR _0769_ _0768_ net594 sg13g2_or2_1
X_4890__439 VPWR VGND net439 sg13g2_tiehi
X_2684_ videogen.test_lut_thingy.pixel_feeder_inst.row\[24\]\[1\] net786 _0741_ _0628_
+ VPWR VGND sg13g2_mux2_1
X_4423_ _2103_ _2101_ _2102_ VPWR VGND sg13g2_nand2_1
X_5182__79 VPWR VGND net79 sg13g2_tiehi
X_4354_ _2042_ VPWR _2043_ VGND tmds_green.dc_balancing_reg\[2\] _2005_ sg13g2_o21ai_1
X_3305_ videogen.fancy_shader.video_x\[5\] videogen.fancy_shader.shader_counter_reg\[5\]
+ _1023_ VPWR VGND sg13g2_nor2_1
X_4285_ _1987_ _1919_ VPWR VGND _1947_ sg13g2_nand2b_2
X_3236_ net757 _0962_ _0966_ _0345_ VPWR VGND sg13g2_nor3_1
X_3167_ _0920_ net614 _0921_ VPWR VGND sg13g2_xor2_1
X_3098_ _0875_ net483 net452 VPWR VGND sg13g2_nand2_1
XFILLER_23_743 VPWR VGND sg13g2_fill_2
XFILLER_22_264 VPWR VGND sg13g2_fill_1
XFILLER_22_275 VPWR VGND sg13g2_decap_8
XFILLER_10_437 VPWR VGND sg13g2_fill_2
XFILLER_13_56 VPWR VGND sg13g2_decap_4
XFILLER_2_625 VPWR VGND sg13g2_fill_2
XFILLER_1_102 VPWR VGND sg13g2_decap_4
XFILLER_49_128 VPWR VGND sg13g2_fill_2
XFILLER_46_835 VPWR VGND sg13g2_decap_8
XFILLER_45_345 VPWR VGND sg13g2_decap_4
XFILLER_26_581 VPWR VGND sg13g2_decap_4
XFILLER_14_743 VPWR VGND sg13g2_decap_8
XFILLER_9_202 VPWR VGND sg13g2_decap_4
XFILLER_9_246 VPWR VGND sg13g2_decap_8
XFILLER_6_920 VPWR VGND sg13g2_decap_8
XFILLER_6_997 VPWR VGND sg13g2_decap_8
X_4070_ _1777_ _1779_ _1678_ _1781_ VPWR VGND sg13g2_nand3_1
XFILLER_23_1000 VPWR VGND sg13g2_decap_8
X_3021_ _0837_ videogen.fancy_shader.video_x\[5\] net636 _0834_ VPWR VGND sg13g2_and3_1
X_4972_ net322 VGND VPWR _0429_ videogen.test_lut_thingy.pixel_feeder_inst.row\[9\]\[1\]
+ _0066_ sg13g2_dfrbpq_1
X_3923_ _1586_ _1636_ _1637_ VPWR VGND sg13g2_nor2b_1
X_3854_ net631 videogen.test_lut_thingy.pixel_feeder_inst.row\[32\]\[0\] videogen.test_lut_thingy.pixel_feeder_inst.row\[33\]\[0\]
+ videogen.test_lut_thingy.pixel_feeder_inst.row\[34\]\[0\] videogen.test_lut_thingy.pixel_feeder_inst.row\[35\]\[0\]
+ net627 _1571_ VPWR VGND sg13g2_mux4_1
X_2805_ videogen.test_lut_thingy.pixel_feeder_inst.row\[50\]\[1\] net786 _0782_ _0538_
+ VPWR VGND sg13g2_mux2_1
X_3785_ videogen.test_lut_thingy.pixel_feeder_inst.row\[6\]\[1\] net592 _1503_ VPWR
+ VGND sg13g2_nor2_1
X_2736_ _0749_ _0762_ _0764_ VPWR VGND sg13g2_nor2_2
X_2667_ videogen.test_lut_thingy.pixel_feeder_inst.row\[22\]\[0\] net799 _0731_ _0635_
+ VPWR VGND sg13g2_mux2_1
X_4406_ _2085_ _2086_ _2087_ VPWR VGND sg13g2_and2_1
X_2598_ VPWR _0671_ videogen.test_lut_thingy.pixel_feeder_inst.row\[44\]\[3\] VGND
+ sg13g2_inv_1
XFILLER_8_1027 VPWR VGND sg13g2_fill_2
X_4337_ _0685_ _2010_ _2027_ VPWR VGND sg13g2_and2_1
X_4268_ VGND VPWR _1969_ _1971_ _1972_ _1922_ sg13g2_a21oi_1
X_3219_ net551 _0954_ _0955_ _0339_ VPWR VGND sg13g2_nor3_1
XFILLER_39_194 VPWR VGND sg13g2_fill_2
XFILLER_28_868 VPWR VGND sg13g2_fill_1
X_4199_ _1897_ _1894_ _1904_ _1905_ VPWR VGND sg13g2_a21o_1
XFILLER_23_573 VPWR VGND sg13g2_decap_8
XFILLER_7_739 VPWR VGND sg13g2_decap_8
XFILLER_3_923 VPWR VGND sg13g2_decap_8
XFILLER_2_422 VPWR VGND sg13g2_decap_8
XFILLER_49_63 VPWR VGND sg13g2_decap_8
XFILLER_2_477 VPWR VGND sg13g2_fill_1
XFILLER_49_74 VPWR VGND sg13g2_fill_1
Xfanout781 net782 net781 VPWR VGND sg13g2_buf_8
Xfanout770 net772 net770 VPWR VGND sg13g2_buf_8
Xfanout792 net793 net792 VPWR VGND sg13g2_buf_8
XFILLER_46_665 VPWR VGND sg13g2_decap_4
XFILLER_45_131 VPWR VGND sg13g2_fill_1
XFILLER_46_687 VPWR VGND sg13g2_decap_8
XFILLER_42_882 VPWR VGND sg13g2_fill_2
X_3570_ net619 _1282_ _1287_ _1288_ VPWR VGND sg13g2_nor3_1
XFILLER_5_260 VPWR VGND sg13g2_fill_2
X_4889__441 VPWR VGND net441 sg13g2_tiehi
X_5171_ net243 VGND VPWR _0628_ videogen.test_lut_thingy.pixel_feeder_inst.row\[24\]\[1\]
+ _0246_ sg13g2_dfrbpq_1
X_4122_ _1816_ _1807_ _1833_ VPWR VGND sg13g2_xor2_1
X_4053_ VPWR _1764_ _1763_ VGND sg13g2_inv_1
XFILLER_49_481 VPWR VGND sg13g2_decap_8
X_3004_ videogen.test_lut_thingy.pixel_feeder_inst.row\[1\]\[0\] net802 _0824_ _0278_
+ VPWR VGND sg13g2_mux2_1
XFILLER_37_676 VPWR VGND sg13g2_fill_2
X_5073__45 VPWR VGND net45 sg13g2_tiehi
XFILLER_18_890 VPWR VGND sg13g2_fill_1
XFILLER_24_348 VPWR VGND sg13g2_fill_1
X_4955_ net352 VGND VPWR _0412_ tmds_green.dc_balancing_reg\[1\] net646 sg13g2_dfrbpq_2
X_3906_ _1591_ _1610_ _1614_ _1620_ VPWR VGND sg13g2_or3_1
X_4886_ net32 VGND VPWR _0347_ videogen.fancy_shader.video_y\[4\] net643 sg13g2_dfrbpq_2
XFILLER_33_893 VPWR VGND sg13g2_decap_8
X_4972__322 VPWR VGND net322 sg13g2_tiehi
X_3837_ _1547_ _1553_ _1554_ VPWR VGND sg13g2_nor2_1
X_3768_ videogen.test_lut_thingy.pixel_feeder_inst.row\[22\]\[1\] net590 _1486_ VPWR
+ VGND sg13g2_nor2_1
X_2719_ _0735_ _0758_ _0759_ VPWR VGND sg13g2_nor2_2
XFILLER_10_35 VPWR VGND sg13g2_decap_8
XFILLER_10_13 VPWR VGND sg13g2_decap_4
X_4816__159 VPWR VGND net159 sg13g2_tiehi
X_3699_ videogen.test_lut_thingy.pixel_feeder_inst.row\[35\]\[2\] net568 _1417_ VPWR
+ VGND sg13g2_nor2_1
XFILLER_48_908 VPWR VGND sg13g2_decap_8
XFILLER_0_959 VPWR VGND sg13g2_decap_8
XFILLER_16_838 VPWR VGND sg13g2_fill_2
XFILLER_35_32 VPWR VGND sg13g2_fill_1
XFILLER_35_43 VPWR VGND sg13g2_fill_2
XFILLER_42_145 VPWR VGND sg13g2_fill_2
XFILLER_15_348 VPWR VGND sg13g2_fill_2
XFILLER_23_370 VPWR VGND sg13g2_decap_4
XFILLER_24_893 VPWR VGND sg13g2_decap_8
XFILLER_13_1010 VPWR VGND sg13g2_decap_8
XFILLER_7_536 VPWR VGND sg13g2_fill_2
XFILLER_7_525 VPWR VGND sg13g2_decap_8
XFILLER_3_731 VPWR VGND sg13g2_fill_1
XFILLER_2_230 VPWR VGND sg13g2_decap_8
XFILLER_2_241 VPWR VGND sg13g2_fill_2
XFILLER_3_797 VPWR VGND sg13g2_decap_8
XFILLER_20_1003 VPWR VGND sg13g2_decap_8
XFILLER_47_963 VPWR VGND sg13g2_decap_8
XFILLER_46_440 VPWR VGND sg13g2_decap_8
XFILLER_22_808 VPWR VGND sg13g2_decap_8
XFILLER_33_112 VPWR VGND sg13g2_fill_2
XFILLER_15_882 VPWR VGND sg13g2_decap_8
XFILLER_42_690 VPWR VGND sg13g2_fill_2
X_4740_ net680 net724 _0204_ VPWR VGND sg13g2_nor2_1
X_4671_ net685 net729 _0135_ VPWR VGND sg13g2_nor2_1
X_3622_ videogen.test_lut_thingy.pixel_feeder_inst.row\[14\]\[2\] net592 _1340_ VPWR
+ VGND sg13g2_nor2_1
X_3553_ videogen.test_lut_thingy.pixel_feeder_inst.row\[47\]\[3\] net565 _1271_ VPWR
+ VGND sg13g2_nor2_1
XFILLER_44_0 VPWR VGND sg13g2_decap_4
X_3484_ _1202_ _1181_ _1201_ VPWR VGND sg13g2_xnor2_1
X_5154_ net339 VGND VPWR _0611_ videogen.test_lut_thingy.pixel_feeder_inst.row\[59\]\[2\]
+ _0239_ sg13g2_dfrbpq_1
XFILLER_5_1008 VPWR VGND sg13g2_decap_8
X_4105_ VGND VPWR _1816_ _1815_ _1811_ sg13g2_or2_1
XFILLER_2_80 VPWR VGND sg13g2_fill_1
X_5085_ net382 VGND VPWR _0542_ videogen.test_lut_thingy.pixel_feeder_inst.row\[4\]\[1\]
+ _0170_ sg13g2_dfrbpq_1
XFILLER_38_963 VPWR VGND sg13g2_decap_8
X_4036_ VGND VPWR _1729_ _1735_ _1747_ _1746_ sg13g2_a21oi_1
XFILLER_24_112 VPWR VGND sg13g2_decap_8
X_5057__109 VPWR VGND net109 sg13g2_tiehi
XFILLER_12_307 VPWR VGND sg13g2_decap_4
XFILLER_24_167 VPWR VGND sg13g2_decap_8
XFILLER_24_178 VPWR VGND sg13g2_fill_1
XFILLER_36_1010 VPWR VGND sg13g2_decap_8
X_4938_ net373 VGND VPWR _0399_ videogen.test_lut_thingy.pixel_feeder_inst.row\[14\]\[0\]
+ _0045_ sg13g2_dfrbpq_1
XFILLER_20_340 VPWR VGND sg13g2_fill_1
X_4869_ net66 VGND VPWR _0330_ videogen.test_lut_thingy.pixel_feeder_inst.row\[34\]\[3\]
+ _0028_ sg13g2_dfrbpq_1
XFILLER_21_896 VPWR VGND sg13g2_fill_1
XFILLER_0_756 VPWR VGND sg13g2_decap_8
XFILLER_29_952 VPWR VGND sg13g2_decap_8
XFILLER_16_602 VPWR VGND sg13g2_fill_2
XFILLER_16_613 VPWR VGND sg13g2_decap_8
XFILLER_44_944 VPWR VGND sg13g2_decap_8
XFILLER_15_123 VPWR VGND sg13g2_decap_4
XFILLER_43_465 VPWR VGND sg13g2_decap_4
XFILLER_15_167 VPWR VGND sg13g2_decap_4
XFILLER_30_159 VPWR VGND sg13g2_fill_2
XFILLER_8_845 VPWR VGND sg13g2_decap_8
XFILLER_7_36 VPWR VGND sg13g2_fill_1
XFILLER_7_47 VPWR VGND sg13g2_decap_8
XFILLER_7_399 VPWR VGND sg13g2_decap_8
XFILLER_16_4 VPWR VGND sg13g2_decap_8
XFILLER_35_911 VPWR VGND sg13g2_fill_2
XFILLER_46_270 VPWR VGND sg13g2_decap_4
XFILLER_34_432 VPWR VGND sg13g2_decap_4
XFILLER_35_988 VPWR VGND sg13g2_decap_8
X_2984_ videogen.test_lut_thingy.pixel_feeder_inst.row\[34\]\[0\] net798 _0820_ _0327_
+ VPWR VGND sg13g2_mux2_1
XFILLER_34_487 VPWR VGND sg13g2_fill_1
X_4723_ net669 net713 _0187_ VPWR VGND sg13g2_nor2_1
XFILLER_21_148 VPWR VGND sg13g2_decap_4
X_4654_ net675 net719 _0118_ VPWR VGND sg13g2_nor2_1
XFILLER_30_693 VPWR VGND sg13g2_decap_8
X_4585_ net704 net748 _0049_ VPWR VGND sg13g2_nor2_1
X_3605_ net616 _1311_ _1322_ _1323_ VPWR VGND sg13g2_nor3_1
X_3536_ net618 VPWR _1254_ VGND videogen.test_lut_thingy.pixel_feeder_inst.row\[41\]\[3\]
+ net558 sg13g2_o21ai_1
X_3467_ VPWR VGND _1178_ _1182_ _1177_ _1088_ _1185_ _1089_ sg13g2_a221oi_1
X_5206_ net223 VGND VPWR net448 clockdiv.q0 clknet_3_0__leaf_clk_regs sg13g2_dfrbpq_2
X_3398_ _1056_ _1054_ _1116_ VPWR VGND sg13g2_xor2_1
X_5137_ net99 VGND VPWR _0594_ videogen.test_lut_thingy.pixel_feeder_inst.row\[63\]\[1\]
+ _0222_ sg13g2_dfrbpq_1
XFILLER_29_226 VPWR VGND sg13g2_decap_4
X_5068_ net65 VGND VPWR _0525_ videogen.test_lut_thingy.pixel_feeder_inst.row\[53\]\[0\]
+ _0153_ sg13g2_dfrbpq_1
X_4019_ _1730_ _1716_ _1725_ VPWR VGND sg13g2_xnor2_1
XFILLER_16_34 VPWR VGND sg13g2_fill_2
XFILLER_25_443 VPWR VGND sg13g2_decap_8
XFILLER_26_955 VPWR VGND sg13g2_decap_8
XFILLER_25_454 VPWR VGND sg13g2_decap_8
XFILLER_25_498 VPWR VGND sg13g2_decap_8
XFILLER_0_542 VPWR VGND sg13g2_decap_8
XFILLER_48_535 VPWR VGND sg13g2_decap_8
X_5085__382 VPWR VGND net382 sg13g2_tiehi
X_4856__92 VPWR VGND net92 sg13g2_tiehi
X_4871__62 VPWR VGND net62 sg13g2_tiehi
XFILLER_29_782 VPWR VGND sg13g2_decap_8
XFILLER_17_977 VPWR VGND sg13g2_decap_8
XFILLER_32_947 VPWR VGND sg13g2_fill_2
XFILLER_40_991 VPWR VGND sg13g2_decap_8
XFILLER_12_671 VPWR VGND sg13g2_decap_8
X_4370_ VGND VPWR _1993_ _2057_ _2058_ _2027_ sg13g2_a21oi_1
X_3321_ videogen.fancy_shader.video_y\[7\] videogen.fancy_shader.shader_counter_reg\[7\]
+ _1039_ VPWR VGND sg13g2_and2_1
X_3252_ VGND VPWR _0977_ _0853_ _0694_ sg13g2_or2_1
X_3183_ videogen.test_lut_thingy.pixel_feeder_inst.h_counter\[0\] net552 _0932_ VPWR
+ VGND sg13g2_nor2_1
XFILLER_23_958 VPWR VGND sg13g2_decap_8
XFILLER_34_262 VPWR VGND sg13g2_decap_8
XFILLER_10_619 VPWR VGND sg13g2_decap_8
X_2967_ videogen.test_lut_thingy.pixel_feeder_inst.row\[17\]\[2\] net781 _0817_ _0393_
+ VPWR VGND sg13g2_mux2_1
X_4706_ net706 net750 _0170_ VPWR VGND sg13g2_nor2_1
X_2898_ videogen.test_lut_thingy.pixel_feeder_inst.row\[7\]\[0\] net802 _0802_ _0456_
+ VPWR VGND sg13g2_mux2_1
X_5185__55 VPWR VGND net55 sg13g2_tiehi
X_4637_ net694 net738 _0101_ VPWR VGND sg13g2_nor2_1
X_4568_ net704 net748 _0033_ VPWR VGND sg13g2_nor2_1
X_4499_ _2164_ net658 net478 net663 serialize.tmds_parallel_b\[5\] VPWR VGND sg13g2_a22oi_1
X_3519_ videogen.test_lut_thingy.pixel_feeder_inst.row\[60\]\[3\] net580 _1237_ VPWR
+ VGND sg13g2_nor2_1
XFILLER_40_1028 VPWR VGND sg13g2_fill_1
XFILLER_27_44 VPWR VGND sg13g2_decap_4
XFILLER_25_273 VPWR VGND sg13g2_fill_2
XFILLER_26_785 VPWR VGND sg13g2_fill_2
XFILLER_13_446 VPWR VGND sg13g2_fill_1
XFILLER_40_265 VPWR VGND sg13g2_decap_8
XFILLER_5_623 VPWR VGND sg13g2_fill_1
XFILLER_1_862 VPWR VGND sg13g2_decap_8
XFILLER_49_833 VPWR VGND sg13g2_decap_8
XFILLER_0_350 VPWR VGND sg13g2_decap_8
XFILLER_36_516 VPWR VGND sg13g2_decap_4
XFILLER_16_262 VPWR VGND sg13g2_fill_2
XFILLER_17_1019 VPWR VGND sg13g2_decap_8
X_3870_ _1584_ _1155_ _1583_ VPWR VGND sg13g2_xnor2_1
XFILLER_32_755 VPWR VGND sg13g2_decap_8
X_2821_ videogen.test_lut_thingy.pixel_feeder_inst.row\[53\]\[0\] net801 _0785_ _0525_
+ VPWR VGND sg13g2_mux2_1
XFILLER_9_951 VPWR VGND sg13g2_decap_8
X_2752_ _0768_ _0738_ VPWR VGND net571 sg13g2_nand2b_2
X_4422_ _2082_ VPWR _2102_ VGND blue\[1\] _2081_ sg13g2_o21ai_1
X_2683_ videogen.test_lut_thingy.pixel_feeder_inst.row\[24\]\[2\] net775 _0741_ _0629_
+ VPWR VGND sg13g2_mux2_1
X_4353_ _0683_ VPWR _2042_ VGND green\[7\] green\[6\] sg13g2_o21ai_1
X_3304_ _1022_ videogen.fancy_shader.video_x\[6\] videogen.fancy_shader.shader_counter_reg\[6\]
+ VPWR VGND sg13g2_xnor2_1
X_4284_ VGND VPWR _1984_ _1986_ _0374_ _0958_ sg13g2_a21oi_1
X_3235_ VGND VPWR _0852_ _0965_ _0966_ _0878_ sg13g2_a21oi_1
XFILLER_39_343 VPWR VGND sg13g2_decap_8
X_3166_ _0313_ _0842_ _0919_ _0920_ VPWR VGND sg13g2_and3_1
XFILLER_27_516 VPWR VGND sg13g2_fill_1
X_3097_ net452 net658 _0286_ VPWR VGND sg13g2_nor2b_1
XFILLER_42_519 VPWR VGND sg13g2_fill_2
XFILLER_42_508 VPWR VGND sg13g2_fill_1
X_5105__293 VPWR VGND net293 sg13g2_tiehi
X_3999_ _1710_ net547 _1709_ VPWR VGND sg13g2_xnor2_1
XFILLER_22_254 VPWR VGND sg13g2_decap_4
XFILLER_23_788 VPWR VGND sg13g2_decap_8
XFILLER_13_35 VPWR VGND sg13g2_decap_8
XFILLER_49_107 VPWR VGND sg13g2_decap_8
X_4982__302 VPWR VGND net302 sg13g2_tiehi
XFILLER_38_54 VPWR VGND sg13g2_fill_2
XFILLER_46_814 VPWR VGND sg13g2_decap_8
XFILLER_45_302 VPWR VGND sg13g2_decap_8
XFILLER_38_76 VPWR VGND sg13g2_decap_4
XFILLER_26_560 VPWR VGND sg13g2_fill_2
XFILLER_13_221 VPWR VGND sg13g2_decap_4
XFILLER_10_983 VPWR VGND sg13g2_decap_8
XFILLER_6_976 VPWR VGND sg13g2_decap_8
XFILLER_5_442 VPWR VGND sg13g2_decap_8
XFILLER_48_7 VPWR VGND sg13g2_decap_8
XFILLER_1_681 VPWR VGND sg13g2_fill_1
XFILLER_49_685 VPWR VGND sg13g2_decap_8
X_3020_ videogen.fancy_shader.video_x\[6\] videogen.fancy_shader.video_x\[5\] _0836_
+ VPWR VGND sg13g2_and2_1
X_4971_ net324 VGND VPWR _0428_ videogen.test_lut_thingy.pixel_feeder_inst.row\[9\]\[0\]
+ _0065_ sg13g2_dfrbpq_1
X_3922_ _1635_ VPWR _1636_ VGND _1631_ _1633_ sg13g2_o21ai_1
X_4959__348 VPWR VGND net348 sg13g2_tiehi
X_3853_ net631 videogen.test_lut_thingy.pixel_feeder_inst.row\[40\]\[0\] videogen.test_lut_thingy.pixel_feeder_inst.row\[41\]\[0\]
+ videogen.test_lut_thingy.pixel_feeder_inst.row\[42\]\[0\] videogen.test_lut_thingy.pixel_feeder_inst.row\[43\]\[0\]
+ net627 _1570_ VPWR VGND sg13g2_mux4_1
XFILLER_20_703 VPWR VGND sg13g2_fill_2
XFILLER_20_747 VPWR VGND sg13g2_decap_4
X_2804_ videogen.test_lut_thingy.pixel_feeder_inst.row\[50\]\[2\] net775 _0782_ _0539_
+ VPWR VGND sg13g2_mux2_1
X_3784_ videogen.test_lut_thingy.pixel_feeder_inst.row\[7\]\[1\] net573 _1502_ VPWR
+ VGND sg13g2_nor2_1
X_2735_ videogen.test_lut_thingy.pixel_feeder_inst.row\[6\]\[0\] net800 _0763_ _0589_
+ VPWR VGND sg13g2_mux2_1
X_2666_ videogen.test_lut_thingy.pixel_feeder_inst.row\[22\]\[1\] net789 _0731_ _0636_
+ VPWR VGND sg13g2_mux2_1
X_4405_ _2083_ _2084_ _2070_ _2086_ VPWR VGND sg13g2_nand3_1
XFILLER_8_1006 VPWR VGND sg13g2_decap_8
XFILLER_5_91 VPWR VGND sg13g2_decap_4
X_4336_ _2026_ _2025_ _2011_ _2019_ _2009_ VPWR VGND sg13g2_a22oi_1
X_4849__106 VPWR VGND net106 sg13g2_tiehi
X_4267_ _1920_ _1970_ _1971_ VPWR VGND sg13g2_nor2_1
X_3218_ videogen.fancy_shader.shader_counter_reg\[8\] _0952_ _0955_ VPWR VGND sg13g2_and2_1
XFILLER_27_302 VPWR VGND sg13g2_decap_4
XFILLER_28_825 VPWR VGND sg13g2_decap_8
X_4198_ _1875_ net544 _1904_ VPWR VGND sg13g2_and2_1
X_3149_ _0909_ videogen.test_lut_thingy.pixel_feeder_inst.v_pix\[5\] _0908_ VPWR VGND
+ sg13g2_xnor2_1
XFILLER_27_313 VPWR VGND sg13g2_decap_8
XFILLER_10_257 VPWR VGND sg13g2_fill_2
XFILLER_6_217 VPWR VGND sg13g2_fill_2
XFILLER_3_902 VPWR VGND sg13g2_decap_8
XFILLER_3_979 VPWR VGND sg13g2_decap_8
XFILLER_49_42 VPWR VGND sg13g2_decap_8
XFILLER_49_86 VPWR VGND sg13g2_decap_8
Xfanout760 _0677_ net760 VPWR VGND sg13g2_buf_8
Xfanout771 net772 net771 VPWR VGND sg13g2_buf_1
Xfanout793 ui_in[5] net793 VPWR VGND sg13g2_buf_8
Xfanout782 net783 net782 VPWR VGND sg13g2_buf_8
XFILLER_34_817 VPWR VGND sg13g2_fill_1
XFILLER_45_187 VPWR VGND sg13g2_fill_2
XFILLER_33_316 VPWR VGND sg13g2_decap_8
XFILLER_41_393 VPWR VGND sg13g2_fill_1
XFILLER_41_371 VPWR VGND sg13g2_decap_8
X_5119__237 VPWR VGND net237 sg13g2_tiehi
XFILLER_6_751 VPWR VGND sg13g2_fill_1
XFILLER_10_791 VPWR VGND sg13g2_decap_8
X_5170_ net251 VGND VPWR _0627_ videogen.test_lut_thingy.pixel_feeder_inst.row\[24\]\[0\]
+ _0245_ sg13g2_dfrbpq_1
X_4121_ VGND VPWR _1821_ _1824_ _1832_ _1831_ sg13g2_a21oi_1
XFILLER_49_460 VPWR VGND sg13g2_decap_8
X_4052_ _1762_ _1752_ _1753_ _1763_ VPWR VGND sg13g2_a21o_1
XFILLER_37_611 VPWR VGND sg13g2_fill_1
X_3003_ videogen.test_lut_thingy.pixel_feeder_inst.row\[1\]\[1\] net790 _0824_ _0279_
+ VPWR VGND sg13g2_mux2_1
XFILLER_25_806 VPWR VGND sg13g2_fill_1
XFILLER_24_316 VPWR VGND sg13g2_fill_2
X_5096__329 VPWR VGND net329 sg13g2_tiehi
X_4954_ net353 VGND VPWR _0411_ red_tmds_par\[9\] net652 sg13g2_dfrbpq_1
X_3905_ _1607_ _1609_ _1589_ _1619_ VPWR VGND _1616_ sg13g2_nand4_1
XFILLER_20_500 VPWR VGND sg13g2_decap_8
X_4885_ net34 VGND VPWR _0346_ videogen.fancy_shader.video_y\[3\] net644 sg13g2_dfrbpq_2
XFILLER_20_555 VPWR VGND sg13g2_fill_2
X_3836_ VGND VPWR _1549_ _1552_ _1553_ net620 sg13g2_a21oi_1
XFILLER_20_588 VPWR VGND sg13g2_decap_8
XFILLER_20_599 VPWR VGND sg13g2_fill_2
X_3767_ videogen.test_lut_thingy.pixel_feeder_inst.row\[21\]\[1\] net561 _1485_ VPWR
+ VGND sg13g2_nor2_1
X_2718_ _0691_ _0711_ net604 _0758_ VPWR VGND sg13g2_nand3_1
X_3698_ videogen.test_lut_thingy.pixel_feeder_inst.row\[32\]\[2\] net578 _1416_ VPWR
+ VGND sg13g2_nor2_1
X_2649_ _0721_ _0706_ _0720_ VPWR VGND sg13g2_nand2_1
XFILLER_0_938 VPWR VGND sg13g2_decap_8
X_4319_ _2009_ _2007_ _2008_ VPWR VGND sg13g2_nand2_1
XFILLER_28_611 VPWR VGND sg13g2_decap_8
XFILLER_42_102 VPWR VGND sg13g2_fill_2
XFILLER_15_305 VPWR VGND sg13g2_decap_8
XFILLER_28_699 VPWR VGND sg13g2_decap_8
XFILLER_31_809 VPWR VGND sg13g2_fill_1
XFILLER_24_850 VPWR VGND sg13g2_fill_1
XFILLER_35_77 VPWR VGND sg13g2_fill_2
XFILLER_3_721 VPWR VGND sg13g2_decap_4
XFILLER_3_776 VPWR VGND sg13g2_decap_8
XFILLER_2_253 VPWR VGND sg13g2_decap_8
XFILLER_2_264 VPWR VGND sg13g2_decap_8
XFILLER_25_9 VPWR VGND sg13g2_decap_8
XFILLER_47_942 VPWR VGND sg13g2_decap_8
XFILLER_18_8 VPWR VGND sg13g2_fill_2
Xfanout590 net593 net590 VPWR VGND sg13g2_buf_8
XFILLER_46_485 VPWR VGND sg13g2_fill_2
XFILLER_18_165 VPWR VGND sg13g2_decap_8
XFILLER_18_187 VPWR VGND sg13g2_decap_4
XFILLER_33_146 VPWR VGND sg13g2_decap_4
X_4670_ net685 net729 _0134_ VPWR VGND sg13g2_nor2_1
X_3621_ net625 VPWR _1339_ VGND videogen.test_lut_thingy.pixel_feeder_inst.row\[13\]\[2\]
+ net563 sg13g2_o21ai_1
X_3552_ net618 VPWR _1270_ VGND videogen.test_lut_thingy.pixel_feeder_inst.row\[46\]\[3\]
+ net586 sg13g2_o21ai_1
X_3483_ VGND VPWR _1194_ _1196_ _1201_ _1191_ sg13g2_a21oi_1
X_5153_ net347 VGND VPWR _0610_ videogen.test_lut_thingy.pixel_feeder_inst.row\[59\]\[1\]
+ _0238_ sg13g2_dfrbpq_1
XFILLER_37_0 VPWR VGND sg13g2_decap_8
X_4104_ VPWR VGND _1813_ _1808_ _1812_ net543 _1815_ _1804_ sg13g2_a221oi_1
XFILLER_29_408 VPWR VGND sg13g2_fill_1
X_5084_ net386 VGND VPWR _0541_ videogen.test_lut_thingy.pixel_feeder_inst.row\[4\]\[0\]
+ _0169_ sg13g2_dfrbpq_1
X_4035_ VGND VPWR _1735_ _1737_ _1746_ _1729_ sg13g2_a21oi_1
XFILLER_24_124 VPWR VGND sg13g2_decap_8
XFILLER_24_146 VPWR VGND sg13g2_decap_8
X_4937_ net375 VGND VPWR _0398_ videogen.test_lut_thingy.pixel_feeder_inst.row\[16\]\[3\]
+ _0044_ sg13g2_dfrbpq_1
X_5176__194 VPWR VGND net194 sg13g2_tiehi
XFILLER_32_190 VPWR VGND sg13g2_decap_8
X_4868_ net68 VGND VPWR _0329_ videogen.test_lut_thingy.pixel_feeder_inst.row\[34\]\[2\]
+ _0027_ sg13g2_dfrbpq_1
XFILLER_20_352 VPWR VGND sg13g2_decap_8
X_3819_ net634 videogen.test_lut_thingy.pixel_feeder_inst.row\[0\]\[0\] videogen.test_lut_thingy.pixel_feeder_inst.row\[1\]\[0\]
+ videogen.test_lut_thingy.pixel_feeder_inst.row\[2\]\[0\] videogen.test_lut_thingy.pixel_feeder_inst.row\[3\]\[0\]
+ net629 _1536_ VPWR VGND sg13g2_mux4_1
X_4799_ net178 VGND VPWR _0261_ clockdiv.q1 clknet_3_0__leaf_clk_regs sg13g2_dfrbpq_2
XFILLER_0_702 VPWR VGND sg13g2_fill_1
XFILLER_43_1026 VPWR VGND sg13g2_fill_2
XFILLER_44_923 VPWR VGND sg13g2_decap_8
X_5005__256 VPWR VGND net256 sg13g2_tiehi
XFILLER_16_658 VPWR VGND sg13g2_decap_8
XFILLER_31_628 VPWR VGND sg13g2_fill_2
XFILLER_8_813 VPWR VGND sg13g2_fill_1
XFILLER_11_341 VPWR VGND sg13g2_decap_8
XFILLER_7_323 VPWR VGND sg13g2_fill_1
XFILLER_7_345 VPWR VGND sg13g2_decap_8
X_4990__286 VPWR VGND net286 sg13g2_tiehi
XFILLER_3_584 VPWR VGND sg13g2_decap_4
XFILLER_38_238 VPWR VGND sg13g2_decap_8
XFILLER_38_249 VPWR VGND sg13g2_fill_1
XFILLER_4_1020 VPWR VGND sg13g2_decap_8
XFILLER_19_463 VPWR VGND sg13g2_decap_4
XFILLER_19_496 VPWR VGND sg13g2_decap_4
XFILLER_35_967 VPWR VGND sg13g2_decap_8
XFILLER_21_105 VPWR VGND sg13g2_decap_4
X_2983_ videogen.test_lut_thingy.pixel_feeder_inst.row\[34\]\[1\] net787 _0820_ _0328_
+ VPWR VGND sg13g2_mux2_1
X_4722_ net668 net712 _0186_ VPWR VGND sg13g2_nor2_1
X_4653_ net675 net719 _0117_ VPWR VGND sg13g2_nor2_1
X_4584_ net708 net753 _0048_ VPWR VGND sg13g2_nor2_1
X_3604_ net619 _1316_ _1321_ _1322_ VPWR VGND sg13g2_nor3_1
X_3535_ _0678_ _1241_ _1252_ _1253_ VPWR VGND sg13g2_nor3_1
X_3466_ _1180_ _1183_ _1184_ VPWR VGND _1179_ sg13g2_nand3b_1
X_5205_ net231 VGND VPWR _0662_ serialize.shift_reg_r\[7\] clknet_3_4__leaf_clk_regs
+ sg13g2_dfrbpq_1
X_3397_ _1115_ _1031_ _1033_ VPWR VGND sg13g2_xnor2_1
X_5136_ net107 VGND VPWR _0593_ videogen.test_lut_thingy.pixel_feeder_inst.row\[63\]\[0\]
+ _0221_ sg13g2_dfrbpq_1
X_5067_ net69 VGND VPWR _0524_ videogen.test_lut_thingy.pixel_feeder_inst.row\[54\]\[3\]
+ _0152_ sg13g2_dfrbpq_1
X_4018_ _1727_ _1726_ _1728_ _1729_ VPWR VGND sg13g2_a21o_1
XFILLER_25_400 VPWR VGND sg13g2_fill_2
XFILLER_37_282 VPWR VGND sg13g2_fill_1
XFILLER_37_271 VPWR VGND sg13g2_decap_8
XFILLER_25_422 VPWR VGND sg13g2_decap_8
XFILLER_26_934 VPWR VGND sg13g2_decap_8
XFILLER_41_915 VPWR VGND sg13g2_decap_4
XFILLER_12_127 VPWR VGND sg13g2_decap_4
XFILLER_13_628 VPWR VGND sg13g2_decap_8
XFILLER_13_639 VPWR VGND sg13g2_decap_8
X_5188__31 VPWR VGND net31 sg13g2_tiehi
XFILLER_21_683 VPWR VGND sg13g2_decap_8
XFILLER_10_1025 VPWR VGND sg13g2_decap_4
XFILLER_0_521 VPWR VGND sg13g2_decap_8
XFILLER_48_514 VPWR VGND sg13g2_decap_8
XFILLER_0_598 VPWR VGND sg13g2_decap_8
XFILLER_29_761 VPWR VGND sg13g2_fill_2
XFILLER_16_422 VPWR VGND sg13g2_decap_8
XFILLER_17_956 VPWR VGND sg13g2_decap_8
XFILLER_43_274 VPWR VGND sg13g2_decap_8
XFILLER_31_458 VPWR VGND sg13g2_decap_8
XFILLER_40_970 VPWR VGND sg13g2_decap_8
XFILLER_7_120 VPWR VGND sg13g2_decap_8
XFILLER_11_193 VPWR VGND sg13g2_decap_4
X_3320_ _1038_ _1019_ _1037_ VPWR VGND sg13g2_xnor2_1
XFILLER_3_381 VPWR VGND sg13g2_decap_8
X_3251_ _0350_ net806 _0975_ _0976_ VPWR VGND sg13g2_and3_1
XFILLER_39_503 VPWR VGND sg13g2_decap_8
X_3182_ _0931_ _0842_ _0911_ VPWR VGND sg13g2_nand2_2
XFILLER_19_260 VPWR VGND sg13g2_decap_8
XFILLER_19_271 VPWR VGND sg13g2_fill_2
XFILLER_23_937 VPWR VGND sg13g2_decap_8
XFILLER_34_296 VPWR VGND sg13g2_decap_4
X_2966_ videogen.test_lut_thingy.pixel_feeder_inst.row\[17\]\[3\] net770 _0817_ _0394_
+ VPWR VGND sg13g2_mux2_1
XFILLER_33_1014 VPWR VGND sg13g2_decap_8
X_2897_ videogen.test_lut_thingy.pixel_feeder_inst.row\[7\]\[1\] net792 _0802_ _0457_
+ VPWR VGND sg13g2_mux2_1
X_4705_ net706 net750 _0169_ VPWR VGND sg13g2_nor2_1
X_4636_ net699 net743 _0100_ VPWR VGND sg13g2_nor2_1
X_4567_ net708 net753 _0032_ VPWR VGND sg13g2_nor2_1
X_4498_ VPWR _0643_ _2163_ VGND sg13g2_inv_1
X_3518_ net620 VPWR _1236_ VGND videogen.test_lut_thingy.pixel_feeder_inst.row\[62\]\[3\]
+ net593 sg13g2_o21ai_1
X_4969__328 VPWR VGND net328 sg13g2_tiehi
X_3449_ _1167_ _1153_ _1166_ VPWR VGND sg13g2_xnor2_1
XFILLER_18_709 VPWR VGND sg13g2_fill_2
X_5119_ net237 VGND VPWR _0576_ videogen.test_lut_thingy.pixel_feeder_inst.row\[42\]\[3\]
+ _0204_ sg13g2_dfrbpq_1
XFILLER_26_775 VPWR VGND sg13g2_decap_4
XFILLER_40_211 VPWR VGND sg13g2_decap_8
XFILLER_40_233 VPWR VGND sg13g2_decap_8
XFILLER_40_288 VPWR VGND sg13g2_fill_2
XFILLER_1_841 VPWR VGND sg13g2_decap_8
XFILLER_49_812 VPWR VGND sg13g2_decap_8
XFILLER_49_889 VPWR VGND sg13g2_decap_8
XFILLER_48_355 VPWR VGND sg13g2_fill_2
XFILLER_48_388 VPWR VGND sg13g2_decap_8
XFILLER_1_1023 VPWR VGND sg13g2_decap_4
XFILLER_44_583 VPWR VGND sg13g2_fill_1
XFILLER_16_296 VPWR VGND sg13g2_decap_8
XFILLER_9_930 VPWR VGND sg13g2_decap_8
X_2820_ videogen.test_lut_thingy.pixel_feeder_inst.row\[53\]\[1\] net785 _0785_ _0526_
+ VPWR VGND sg13g2_mux2_1
X_2751_ videogen.test_lut_thingy.pixel_feeder_inst.row\[41\]\[0\] net794 _0767_ _0577_
+ VPWR VGND sg13g2_mux2_1
X_2682_ videogen.test_lut_thingy.pixel_feeder_inst.row\[24\]\[3\] net764 _0741_ _0630_
+ VPWR VGND sg13g2_mux2_1
X_4421_ _2101_ tmds_blue.dc_balancing_reg\[3\] _2081_ VPWR VGND sg13g2_xnor2_1
X_4352_ _2039_ _2040_ _2011_ _2041_ VPWR VGND sg13g2_nand3_1
X_3303_ VGND VPWR _1021_ videogen.fancy_shader.shader_counter_reg\[6\] videogen.fancy_shader.video_x\[6\]
+ sg13g2_or2_1
X_4283_ _1986_ _1985_ _1920_ _1979_ _1923_ VPWR VGND sg13g2_a22oi_1
X_3234_ _0963_ _0964_ _0892_ _0965_ VPWR VGND sg13g2_nand3_1
XFILLER_39_322 VPWR VGND sg13g2_fill_1
X_3165_ _0920_ net616 _0918_ VPWR VGND sg13g2_nand2_1
X_3096_ net454 net658 _0273_ VPWR VGND sg13g2_and2_1
XFILLER_27_539 VPWR VGND sg13g2_fill_1
XFILLER_23_723 VPWR VGND sg13g2_decap_4
XFILLER_23_745 VPWR VGND sg13g2_fill_1
XFILLER_23_767 VPWR VGND sg13g2_decap_8
X_3998_ _1709_ _1690_ _1696_ VPWR VGND sg13g2_xnor2_1
XFILLER_11_929 VPWR VGND sg13g2_decap_8
XFILLER_10_439 VPWR VGND sg13g2_fill_1
X_2949_ videogen.test_lut_thingy.pixel_feeder_inst.row\[36\]\[0\] net795 _0813_ _0416_
+ VPWR VGND sg13g2_mux2_1
X_4619_ net704 net748 _0083_ VPWR VGND sg13g2_nor2_1
X_5112__265 VPWR VGND net265 sg13g2_tiehi
X_5082__397 VPWR VGND net397 sg13g2_tiehi
XFILLER_26_550 VPWR VGND sg13g2_decap_4
XFILLER_41_520 VPWR VGND sg13g2_decap_8
XFILLER_41_575 VPWR VGND sg13g2_fill_1
XFILLER_10_962 VPWR VGND sg13g2_decap_8
XFILLER_6_955 VPWR VGND sg13g2_decap_8
XFILLER_5_498 VPWR VGND sg13g2_fill_2
XFILLER_0_181 VPWR VGND sg13g2_decap_8
XFILLER_49_664 VPWR VGND sg13g2_decap_8
XFILLER_36_314 VPWR VGND sg13g2_fill_2
XFILLER_36_347 VPWR VGND sg13g2_decap_8
XFILLER_17_561 VPWR VGND sg13g2_fill_1
X_4970_ net326 VGND VPWR _0427_ videogen.test_lut_thingy.pixel_feeder_inst.row\[32\]\[3\]
+ _0064_ sg13g2_dfrbpq_1
X_3921_ _1635_ _1624_ _1634_ VPWR VGND sg13g2_nand2_1
XFILLER_32_520 VPWR VGND sg13g2_fill_2
X_3852_ net631 videogen.test_lut_thingy.pixel_feeder_inst.row\[44\]\[0\] videogen.test_lut_thingy.pixel_feeder_inst.row\[45\]\[0\]
+ videogen.test_lut_thingy.pixel_feeder_inst.row\[46\]\[0\] videogen.test_lut_thingy.pixel_feeder_inst.row\[47\]\[0\]
+ net627 _1569_ VPWR VGND sg13g2_mux4_1
XFILLER_32_553 VPWR VGND sg13g2_fill_1
X_2803_ videogen.test_lut_thingy.pixel_feeder_inst.row\[50\]\[3\] net763 _0782_ _0540_
+ VPWR VGND sg13g2_mux2_1
XFILLER_32_597 VPWR VGND sg13g2_fill_2
X_3783_ videogen.test_lut_thingy.pixel_feeder_inst.row\[5\]\[1\] net563 _1501_ VPWR
+ VGND sg13g2_nor2_1
XFILLER_30_1017 VPWR VGND sg13g2_decap_8
X_2734_ videogen.test_lut_thingy.pixel_feeder_inst.row\[6\]\[1\] net793 _0763_ _0590_
+ VPWR VGND sg13g2_mux2_1
XFILLER_30_1028 VPWR VGND sg13g2_fill_1
X_2665_ videogen.test_lut_thingy.pixel_feeder_inst.row\[22\]\[2\] net778 _0731_ _0637_
+ VPWR VGND sg13g2_mux2_1
X_4404_ _2084_ _2070_ _2083_ _2085_ VPWR VGND sg13g2_a21o_1
XFILLER_5_70 VPWR VGND sg13g2_decap_8
X_4335_ _2025_ _2023_ _2024_ VPWR VGND sg13g2_xnor2_1
X_4266_ _1936_ _1967_ _1970_ VPWR VGND sg13g2_nor2_1
XFILLER_39_141 VPWR VGND sg13g2_fill_2
X_3217_ VGND VPWR net807 _0952_ _0954_ videogen.fancy_shader.shader_counter_reg\[8\]
+ sg13g2_a21oi_1
X_4197_ _1903_ tmds_red.dc_balancing_reg\[1\] _1902_ VPWR VGND sg13g2_xnor2_1
XFILLER_39_174 VPWR VGND sg13g2_decap_8
X_3148_ _0894_ _0907_ _0908_ _0307_ VPWR VGND sg13g2_nor3_1
XFILLER_28_859 VPWR VGND sg13g2_decap_8
X_5076__33 VPWR VGND net33 sg13g2_tiehi
XFILLER_39_196 VPWR VGND sg13g2_fill_1
X_3079_ _0840_ _0846_ _0000_ VPWR VGND sg13g2_nor2_1
XFILLER_24_35 VPWR VGND sg13g2_fill_2
X_5077__444 VPWR VGND net444 sg13g2_tiehi
XFILLER_11_726 VPWR VGND sg13g2_decap_4
XFILLER_23_597 VPWR VGND sg13g2_decap_4
XFILLER_10_236 VPWR VGND sg13g2_decap_8
XFILLER_6_207 VPWR VGND sg13g2_decap_4
XFILLER_11_759 VPWR VGND sg13g2_decap_8
XFILLER_10_269 VPWR VGND sg13g2_fill_2
XFILLER_49_21 VPWR VGND sg13g2_decap_8
XFILLER_46_1024 VPWR VGND sg13g2_decap_4
XFILLER_6_4 VPWR VGND sg13g2_decap_8
XFILLER_3_958 VPWR VGND sg13g2_decap_8
XFILLER_2_468 VPWR VGND sg13g2_decap_8
Xfanout750 net751 net750 VPWR VGND sg13g2_buf_8
XFILLER_1_28 VPWR VGND sg13g2_decap_8
Xfanout761 net762 net761 VPWR VGND sg13g2_buf_8
Xfanout794 net796 net794 VPWR VGND sg13g2_buf_8
Xfanout783 ui_in[6] net783 VPWR VGND sg13g2_buf_8
Xfanout772 ui_in[7] net772 VPWR VGND sg13g2_buf_8
XFILLER_46_645 VPWR VGND sg13g2_fill_2
XFILLER_34_807 VPWR VGND sg13g2_decap_4
X_4921__404 VPWR VGND net404 sg13g2_tiehi
X_5043__189 VPWR VGND net189 sg13g2_tiehi
XFILLER_14_597 VPWR VGND sg13g2_fill_2
XFILLER_6_730 VPWR VGND sg13g2_decap_8
X_5015__236 VPWR VGND net236 sg13g2_tiehi
X_5130__184 VPWR VGND net184 sg13g2_tiehi
XFILLER_2_991 VPWR VGND sg13g2_decap_8
X_4120_ VPWR VGND _1822_ _1821_ _1819_ _1791_ _1831_ _1792_ sg13g2_a221oi_1
X_5126__209 VPWR VGND net209 sg13g2_tiehi
XFILLER_1_490 VPWR VGND sg13g2_decap_8
X_4051_ _1762_ _1747_ _1749_ VPWR VGND sg13g2_nand2_1
X_3002_ videogen.test_lut_thingy.pixel_feeder_inst.row\[1\]\[2\] net780 _0824_ _0280_
+ VPWR VGND sg13g2_mux2_1
X_4953_ net354 VGND VPWR _0410_ red_tmds_par\[8\] net650 sg13g2_dfrbpq_1
X_3904_ _1588_ _1610_ _1617_ _1618_ VPWR VGND sg13g2_nor3_1
X_4884_ net36 VGND VPWR _0345_ videogen.fancy_shader.video_y\[2\] net644 sg13g2_dfrbpq_2
X_3835_ _1551_ VPWR _1552_ VGND videogen.test_lut_thingy.pixel_feeder_inst.row\[17\]\[0\]
+ net561 sg13g2_o21ai_1
X_3766_ videogen.test_lut_thingy.pixel_feeder_inst.row\[23\]\[1\] net570 _1484_ VPWR
+ VGND sg13g2_nor2_1
X_2717_ videogen.test_lut_thingy.pixel_feeder_inst.row\[38\]\[0\] net794 _0757_ _0601_
+ VPWR VGND sg13g2_mux2_1
X_3697_ videogen.test_lut_thingy.pixel_feeder_inst.row\[33\]\[2\] net559 _1415_ VPWR
+ VGND sg13g2_nor2_1
X_2648_ _0720_ net614 _0717_ VPWR VGND sg13g2_xnor2_1
XFILLER_0_917 VPWR VGND sg13g2_decap_8
X_4318_ tmds_green.dc_balancing_reg\[1\] green\[7\] _2008_ VPWR VGND sg13g2_nor2b_1
XFILLER_19_35 VPWR VGND sg13g2_decap_8
X_4249_ _1953_ _1914_ _1952_ VPWR VGND sg13g2_nand2_1
XFILLER_19_79 VPWR VGND sg13g2_decap_8
XFILLER_16_807 VPWR VGND sg13g2_fill_1
XFILLER_27_111 VPWR VGND sg13g2_decap_8
XFILLER_27_122 VPWR VGND sg13g2_fill_2
XFILLER_27_155 VPWR VGND sg13g2_decap_8
XFILLER_43_648 VPWR VGND sg13g2_fill_1
XFILLER_43_637 VPWR VGND sg13g2_decap_8
XFILLER_27_188 VPWR VGND sg13g2_fill_2
XFILLER_35_45 VPWR VGND sg13g2_fill_1
XFILLER_42_158 VPWR VGND sg13g2_fill_2
XFILLER_11_545 VPWR VGND sg13g2_decap_4
XFILLER_23_394 VPWR VGND sg13g2_fill_2
XFILLER_3_700 VPWR VGND sg13g2_fill_1
X_5088__370 VPWR VGND net370 sg13g2_tiehi
X_4949__359 VPWR VGND net359 sg13g2_tiehi
XFILLER_47_921 VPWR VGND sg13g2_decap_8
Xfanout580 net584 net580 VPWR VGND sg13g2_buf_8
Xfanout591 net593 net591 VPWR VGND sg13g2_buf_8
X_5164__291 VPWR VGND net291 sg13g2_tiehi
XFILLER_19_656 VPWR VGND sg13g2_fill_1
XFILLER_47_998 VPWR VGND sg13g2_decap_8
XFILLER_33_125 VPWR VGND sg13g2_decap_8
XFILLER_34_637 VPWR VGND sg13g2_decap_4
XFILLER_33_169 VPWR VGND sg13g2_fill_1
XFILLER_42_692 VPWR VGND sg13g2_fill_1
XFILLER_42_681 VPWR VGND sg13g2_fill_1
XFILLER_14_372 VPWR VGND sg13g2_decap_8
XFILLER_30_810 VPWR VGND sg13g2_decap_4
XFILLER_30_821 VPWR VGND sg13g2_decap_8
X_3620_ net619 _1332_ _1337_ _1338_ VPWR VGND sg13g2_nor3_1
X_3551_ _1265_ _1266_ _1267_ _1268_ _1269_ VPWR VGND sg13g2_nor4_1
XFILLER_6_582 VPWR VGND sg13g2_fill_1
X_3482_ _1194_ _1197_ _1016_ _1200_ VPWR VGND _1198_ sg13g2_nand4_1
X_4815__161 VPWR VGND net161 sg13g2_tiehi
X_4932__385 VPWR VGND net385 sg13g2_tiehi
X_5152_ net364 VGND VPWR _0609_ videogen.test_lut_thingy.pixel_feeder_inst.row\[59\]\[0\]
+ _0237_ sg13g2_dfrbpq_1
X_4103_ _1813_ _1812_ _1805_ _1814_ VPWR VGND sg13g2_a21o_1
XFILLER_38_910 VPWR VGND sg13g2_fill_2
X_5083_ net393 VGND VPWR _0540_ videogen.test_lut_thingy.pixel_feeder_inst.row\[50\]\[3\]
+ _0168_ sg13g2_dfrbpq_1
XFILLER_49_291 VPWR VGND sg13g2_decap_8
X_4034_ VPWR _1745_ _1744_ VGND sg13g2_inv_1
XFILLER_38_998 VPWR VGND sg13g2_decap_8
X_4936_ net377 VGND VPWR _0397_ videogen.test_lut_thingy.pixel_feeder_inst.row\[16\]\[2\]
+ _0043_ sg13g2_dfrbpq_1
XFILLER_33_681 VPWR VGND sg13g2_decap_8
XFILLER_33_692 VPWR VGND sg13g2_fill_2
X_4867_ net70 VGND VPWR _0328_ videogen.test_lut_thingy.pixel_feeder_inst.row\[34\]\[1\]
+ _0026_ sg13g2_dfrbpq_1
X_3818_ net625 VPWR _1535_ VGND _1533_ _1534_ sg13g2_o21ai_1
X_4798_ net700 net744 _0260_ VPWR VGND sg13g2_nor2_1
X_3749_ _1466_ VPWR _1467_ VGND videogen.test_lut_thingy.pixel_feeder_inst.row\[60\]\[1\]
+ net580 sg13g2_o21ai_1
XFILLER_21_69 VPWR VGND sg13g2_decap_8
XFILLER_43_1005 VPWR VGND sg13g2_decap_8
XFILLER_46_33 VPWR VGND sg13g2_fill_1
XFILLER_46_22 VPWR VGND sg13g2_decap_8
XFILLER_29_987 VPWR VGND sg13g2_decap_8
X_4979__308 VPWR VGND net308 sg13g2_tiehi
XFILLER_16_626 VPWR VGND sg13g2_decap_8
XFILLER_44_979 VPWR VGND sg13g2_decap_8
XFILLER_43_489 VPWR VGND sg13g2_decap_4
XFILLER_12_821 VPWR VGND sg13g2_decap_8
XFILLER_12_865 VPWR VGND sg13g2_fill_2
XFILLER_7_27 VPWR VGND sg13g2_decap_8
X_4955__352 VPWR VGND net352 sg13g2_tiehi
X_5203__247 VPWR VGND net247 sg13g2_tiehi
XFILLER_35_924 VPWR VGND sg13g2_fill_2
XFILLER_47_795 VPWR VGND sg13g2_decap_8
XFILLER_34_478 VPWR VGND sg13g2_decap_8
X_2982_ videogen.test_lut_thingy.pixel_feeder_inst.row\[34\]\[2\] net777 _0820_ _0329_
+ VPWR VGND sg13g2_mux2_1
X_4721_ net668 net712 _0185_ VPWR VGND sg13g2_nor2_1
X_4652_ net674 net718 _0116_ VPWR VGND sg13g2_nor2_1
X_3603_ _1317_ _1318_ _1319_ _1320_ _1321_ VPWR VGND sg13g2_nor4_1
X_4583_ net708 net754 _0047_ VPWR VGND sg13g2_nor2_1
X_3534_ net621 _1246_ _1251_ _1252_ VPWR VGND sg13g2_nor3_1
X_3465_ net549 _1182_ _1183_ VPWR VGND sg13g2_nor2_1
X_5204_ net239 VGND VPWR _0661_ serialize.shift_reg_r\[6\] clknet_3_4__leaf_clk_regs
+ sg13g2_dfrbpq_1
X_3396_ _1114_ _1106_ _1110_ VPWR VGND sg13g2_xnor2_1
X_5135_ net115 VGND VPWR _0592_ videogen.test_lut_thingy.pixel_feeder_inst.row\[6\]\[3\]
+ _0220_ sg13g2_dfrbpq_1
X_5066_ net73 VGND VPWR _0523_ videogen.test_lut_thingy.pixel_feeder_inst.row\[54\]\[2\]
+ _0151_ sg13g2_dfrbpq_1
XFILLER_38_784 VPWR VGND sg13g2_fill_1
XFILLER_37_250 VPWR VGND sg13g2_decap_8
X_5108__281 VPWR VGND net281 sg13g2_tiehi
X_4017_ _1728_ _1715_ _1720_ _1722_ VPWR VGND sg13g2_and3_1
XFILLER_25_412 VPWR VGND sg13g2_fill_1
XFILLER_16_36 VPWR VGND sg13g2_fill_1
XFILLER_16_47 VPWR VGND sg13g2_decap_4
XFILLER_25_467 VPWR VGND sg13g2_decap_4
XFILLER_41_927 VPWR VGND sg13g2_decap_8
X_4919_ net408 VGND VPWR _0380_ videogen.test_lut_thingy.pixel_feeder_inst.row\[13\]\[0\]
+ _0029_ sg13g2_dfrbpq_1
XFILLER_40_448 VPWR VGND sg13g2_decap_4
XFILLER_32_46 VPWR VGND sg13g2_decap_8
XFILLER_20_161 VPWR VGND sg13g2_decap_8
XFILLER_20_172 VPWR VGND sg13g2_fill_1
XFILLER_32_57 VPWR VGND sg13g2_fill_2
XFILLER_10_1004 VPWR VGND sg13g2_decap_8
XFILLER_4_338 VPWR VGND sg13g2_decap_4
XFILLER_0_500 VPWR VGND sg13g2_decap_8
XFILLER_0_577 VPWR VGND sg13g2_decap_8
XFILLER_16_401 VPWR VGND sg13g2_decap_4
XFILLER_17_935 VPWR VGND sg13g2_decap_8
XFILLER_16_445 VPWR VGND sg13g2_fill_1
XFILLER_43_264 VPWR VGND sg13g2_fill_2
X_5157__319 VPWR VGND net319 sg13g2_tiehi
XFILLER_16_478 VPWR VGND sg13g2_fill_2
XFILLER_32_949 VPWR VGND sg13g2_fill_1
XFILLER_31_437 VPWR VGND sg13g2_decap_8
X_4918__409 VPWR VGND net409 sg13g2_tiehi
XFILLER_8_677 VPWR VGND sg13g2_decap_8
XFILLER_22_90 VPWR VGND sg13g2_decap_8
XFILLER_4_894 VPWR VGND sg13g2_decap_8
XFILLER_3_360 VPWR VGND sg13g2_decap_8
X_3250_ videogen.fancy_shader.video_y\[6\] videogen.fancy_shader.video_y\[5\] videogen.fancy_shader.video_y\[7\]
+ _0976_ VPWR VGND _0971_ sg13g2_nand4_1
XFILLER_26_1011 VPWR VGND sg13g2_decap_8
XFILLER_39_526 VPWR VGND sg13g2_fill_2
X_3181_ _0922_ _0930_ _0318_ VPWR VGND sg13g2_nor2_1
XFILLER_19_250 VPWR VGND sg13g2_fill_1
XFILLER_47_570 VPWR VGND sg13g2_decap_8
XFILLER_23_916 VPWR VGND sg13g2_decap_8
XFILLER_35_776 VPWR VGND sg13g2_decap_8
XFILLER_22_437 VPWR VGND sg13g2_fill_2
X_2965_ _0727_ _0742_ _0817_ VPWR VGND sg13g2_nor2_2
X_4704_ net681 net725 _0168_ VPWR VGND sg13g2_nor2_1
X_2896_ videogen.test_lut_thingy.pixel_feeder_inst.row\[7\]\[2\] net780 _0802_ _0458_
+ VPWR VGND sg13g2_mux2_1
XFILLER_31_993 VPWR VGND sg13g2_decap_8
XFILLER_8_70 VPWR VGND sg13g2_fill_2
X_4635_ net699 net743 _0099_ VPWR VGND sg13g2_nor2_1
X_4566_ net708 net752 _0031_ VPWR VGND sg13g2_nor2_1
XFILLER_2_809 VPWR VGND sg13g2_decap_8
X_3517_ _1231_ _1232_ _1233_ _1234_ _1235_ VPWR VGND sg13g2_nor4_1
X_4497_ _2163_ net658 net473 net667 blue_tmds_par\[2\] VPWR VGND sg13g2_a22oi_1
X_3448_ _1166_ _1127_ _1134_ VPWR VGND sg13g2_xnor2_1
X_3379_ VGND VPWR _1082_ _1090_ _1097_ net548 sg13g2_a21oi_1
XFILLER_40_1019 VPWR VGND sg13g2_decap_8
X_5118_ net241 VGND VPWR _0575_ videogen.test_lut_thingy.pixel_feeder_inst.row\[42\]\[2\]
+ _0203_ sg13g2_dfrbpq_1
X_5049_ net154 VGND VPWR _0506_ videogen.test_lut_thingy.pixel_feeder_inst.row\[27\]\[1\]
+ _0134_ sg13g2_dfrbpq_1
XFILLER_26_721 VPWR VGND sg13g2_decap_8
XFILLER_27_68 VPWR VGND sg13g2_fill_2
XFILLER_41_702 VPWR VGND sg13g2_decap_8
XFILLER_13_404 VPWR VGND sg13g2_fill_1
XFILLER_14_949 VPWR VGND sg13g2_decap_8
XFILLER_25_275 VPWR VGND sg13g2_fill_1
XFILLER_26_787 VPWR VGND sg13g2_fill_1
XFILLER_13_426 VPWR VGND sg13g2_decap_4
XFILLER_9_419 VPWR VGND sg13g2_decap_8
XFILLER_21_470 VPWR VGND sg13g2_fill_2
XFILLER_4_113 VPWR VGND sg13g2_fill_2
XFILLER_49_1022 VPWR VGND sg13g2_decap_8
X_4952__355 VPWR VGND net355 sg13g2_tiehi
XFILLER_1_820 VPWR VGND sg13g2_decap_8
XFILLER_1_897 VPWR VGND sg13g2_decap_8
XFILLER_49_868 VPWR VGND sg13g2_decap_8
XFILLER_1_1002 VPWR VGND sg13g2_decap_8
XFILLER_17_743 VPWR VGND sg13g2_decap_8
XFILLER_16_264 VPWR VGND sg13g2_fill_1
XFILLER_32_724 VPWR VGND sg13g2_decap_8
XFILLER_20_919 VPWR VGND sg13g2_decap_8
XFILLER_13_982 VPWR VGND sg13g2_decap_8
X_2750_ videogen.test_lut_thingy.pixel_feeder_inst.row\[41\]\[1\] net786 _0767_ _0578_
+ VPWR VGND sg13g2_mux2_1
X_2681_ _0735_ _0740_ _0741_ VPWR VGND sg13g2_nor2_2
XFILLER_9_986 VPWR VGND sg13g2_decap_8
XFILLER_12_492 VPWR VGND sg13g2_decap_8
X_5053__136 VPWR VGND net136 sg13g2_tiehi
X_4420_ VGND VPWR _2062_ _2100_ _0494_ _2093_ sg13g2_a21oi_1
X_4351_ _2040_ _2031_ _2038_ VPWR VGND sg13g2_nand2_1
X_5168__267 VPWR VGND net267 sg13g2_tiehi
X_3302_ videogen.fancy_shader.video_x\[6\] videogen.fancy_shader.shader_counter_reg\[6\]
+ _1020_ VPWR VGND sg13g2_and2_1
X_4282_ _1985_ _1962_ _1983_ VPWR VGND sg13g2_xnor2_1
X_3233_ _0674_ videogen.fancy_shader.video_y\[8\] _0851_ _0964_ VPWR VGND sg13g2_nor3_1
X_5025__216 VPWR VGND net216 sg13g2_tiehi
X_3164_ VGND VPWR _0919_ _0918_ net615 sg13g2_or2_1
X_3095_ net449 net659 _0272_ VPWR VGND sg13g2_and2_1
XFILLER_39_378 VPWR VGND sg13g2_decap_4
X_5099__317 VPWR VGND net317 sg13g2_tiehi
XFILLER_22_234 VPWR VGND sg13g2_decap_4
XFILLER_35_595 VPWR VGND sg13g2_fill_1
X_3997_ _1706_ _1707_ _1708_ VPWR VGND sg13g2_nor2_1
XFILLER_13_15 VPWR VGND sg13g2_fill_1
X_2948_ videogen.test_lut_thingy.pixel_feeder_inst.row\[36\]\[1\] net785 _0813_ _0417_
+ VPWR VGND sg13g2_mux2_1
XFILLER_22_289 VPWR VGND sg13g2_decap_8
X_4618_ net703 net747 _0082_ VPWR VGND sg13g2_nor2_1
X_2879_ videogen.test_lut_thingy.pixel_feeder_inst.row\[60\]\[2\] net778 _0797_ _0470_
+ VPWR VGND sg13g2_mux2_1
X_4549_ net695 net739 _0015_ VPWR VGND sg13g2_nor2_1
XFILLER_1_149 VPWR VGND sg13g2_decap_8
X_4908__419 VPWR VGND net419 sg13g2_tiehi
XFILLER_38_56 VPWR VGND sg13g2_fill_1
XFILLER_46_849 VPWR VGND sg13g2_decap_8
XFILLER_14_702 VPWR VGND sg13g2_decap_8
XFILLER_26_562 VPWR VGND sg13g2_fill_1
XFILLER_14_757 VPWR VGND sg13g2_decap_4
XFILLER_16_1010 VPWR VGND sg13g2_decap_8
XFILLER_9_238 VPWR VGND sg13g2_decap_4
XFILLER_10_941 VPWR VGND sg13g2_decap_8
XFILLER_6_934 VPWR VGND sg13g2_decap_8
XFILLER_1_650 VPWR VGND sg13g2_fill_1
XFILLER_49_643 VPWR VGND sg13g2_decap_8
XFILLER_0_160 VPWR VGND sg13g2_decap_8
XFILLER_23_1014 VPWR VGND sg13g2_decap_8
XFILLER_48_175 VPWR VGND sg13g2_fill_2
XFILLER_37_849 VPWR VGND sg13g2_fill_2
XFILLER_37_838 VPWR VGND sg13g2_decap_8
XFILLER_45_871 VPWR VGND sg13g2_decap_8
X_3920_ _1623_ VPWR _1634_ VGND _1618_ _1626_ sg13g2_o21ai_1
X_3851_ net631 videogen.test_lut_thingy.pixel_feeder_inst.row\[36\]\[0\] videogen.test_lut_thingy.pixel_feeder_inst.row\[37\]\[0\]
+ videogen.test_lut_thingy.pixel_feeder_inst.row\[38\]\[0\] videogen.test_lut_thingy.pixel_feeder_inst.row\[39\]\[0\]
+ net627 _1568_ VPWR VGND sg13g2_mux4_1
XFILLER_32_565 VPWR VGND sg13g2_fill_1
X_2802_ _0752_ _0769_ _0782_ VPWR VGND sg13g2_nor2_2
X_3782_ net601 VPWR _1500_ VGND videogen.test_lut_thingy.pixel_feeder_inst.row\[4\]\[1\]
+ net583 sg13g2_o21ai_1
X_2733_ videogen.test_lut_thingy.pixel_feeder_inst.row\[6\]\[2\] net779 _0763_ _0591_
+ VPWR VGND sg13g2_mux2_1
X_2664_ videogen.test_lut_thingy.pixel_feeder_inst.row\[22\]\[3\] net767 _0731_ _0638_
+ VPWR VGND sg13g2_mux2_1
X_4403_ _2084_ _2069_ _2078_ VPWR VGND sg13g2_nand2_2
X_4334_ _2024_ green\[0\] _2001_ VPWR VGND sg13g2_nand2_1
X_4265_ _1969_ _1936_ _1968_ VPWR VGND sg13g2_nand2_1
XFILLER_39_120 VPWR VGND sg13g2_fill_1
X_3216_ net551 _0952_ _0953_ _0338_ VPWR VGND sg13g2_nor3_1
X_4196_ _1902_ _1878_ _1901_ VPWR VGND sg13g2_xnor2_1
X_3147_ _0908_ videogen.test_lut_thingy.pixel_feeder_inst.v_pix\[4\] videogen.test_lut_thingy.pixel_feeder_inst.v_pix\[3\]
+ _0904_ VPWR VGND sg13g2_and3_1
X_4942__365 VPWR VGND net365 sg13g2_tiehi
XFILLER_39_1010 VPWR VGND sg13g2_decap_8
X_4825__141 VPWR VGND net141 sg13g2_tiehi
X_3078_ _0844_ _0871_ _0001_ VPWR VGND sg13g2_nor2_1
XFILLER_23_510 VPWR VGND sg13g2_decap_8
XFILLER_23_554 VPWR VGND sg13g2_decap_8
XFILLER_10_226 VPWR VGND sg13g2_decap_4
XFILLER_40_35 VPWR VGND sg13g2_fill_2
XFILLER_6_219 VPWR VGND sg13g2_fill_1
XFILLER_3_937 VPWR VGND sg13g2_decap_8
XFILLER_46_1003 VPWR VGND sg13g2_decap_8
XFILLER_2_436 VPWR VGND sg13g2_decap_4
Xfanout740 net744 net740 VPWR VGND sg13g2_buf_8
Xfanout751 net755 net751 VPWR VGND sg13g2_buf_8
Xfanout784 net785 net784 VPWR VGND sg13g2_buf_8
Xfanout762 net766 net762 VPWR VGND sg13g2_buf_8
Xfanout773 net774 net773 VPWR VGND sg13g2_buf_8
Xfanout795 net796 net795 VPWR VGND sg13g2_buf_1
XFILLER_27_871 VPWR VGND sg13g2_decap_4
XFILLER_27_882 VPWR VGND sg13g2_fill_2
XFILLER_45_189 VPWR VGND sg13g2_fill_1
XFILLER_26_381 VPWR VGND sg13g2_fill_1
XFILLER_10_771 VPWR VGND sg13g2_fill_2
XFILLER_5_230 VPWR VGND sg13g2_fill_2
XFILLER_6_775 VPWR VGND sg13g2_decap_4
XFILLER_30_90 VPWR VGND sg13g2_decap_4
XFILLER_2_970 VPWR VGND sg13g2_decap_8
X_4050_ _1761_ _1732_ _1759_ VPWR VGND sg13g2_xnor2_1
X_5206__223 VPWR VGND net223 sg13g2_tiehi
XFILLER_37_624 VPWR VGND sg13g2_decap_8
X_3001_ videogen.test_lut_thingy.pixel_feeder_inst.row\[1\]\[3\] net769 _0824_ _0281_
+ VPWR VGND sg13g2_mux2_1
XFILLER_49_495 VPWR VGND sg13g2_decap_8
XFILLER_37_646 VPWR VGND sg13g2_fill_1
X_4809__169 VPWR VGND net169 sg13g2_tiehi
XFILLER_45_690 VPWR VGND sg13g2_fill_1
X_4952_ net355 VGND VPWR _0409_ red_tmds_par\[6\] net651 sg13g2_dfrbpq_1
X_3903_ _1617_ _1591_ _1614_ VPWR VGND sg13g2_xnor2_1
X_4883_ net38 VGND VPWR _0344_ videogen.fancy_shader.video_y\[1\] net655 sg13g2_dfrbpq_2
X_3834_ _1526_ _1527_ _1550_ _1551_ VPWR VGND sg13g2_nor3_1
X_3765_ net601 VPWR _1483_ VGND videogen.test_lut_thingy.pixel_feeder_inst.row\[20\]\[1\]
+ net581 sg13g2_o21ai_1
X_2716_ videogen.test_lut_thingy.pixel_feeder_inst.row\[38\]\[1\] net784 _0757_ _0602_
+ VPWR VGND sg13g2_mux2_1
X_3696_ net602 VPWR _1414_ VGND videogen.test_lut_thingy.pixel_feeder_inst.row\[34\]\[2\]
+ net588 sg13g2_o21ai_1
X_2647_ _0719_ _0717_ VPWR VGND net614 sg13g2_nand2b_2
X_4317_ _2005_ tmds_green.dc_balancing_reg\[2\] _2007_ VPWR VGND sg13g2_xor2_1
X_4248_ _1952_ _1912_ _1913_ VPWR VGND sg13g2_nand2_1
X_4179_ red\[7\] red\[6\] red\[4\] _1885_ VPWR VGND _1877_ sg13g2_nand4_1
XFILLER_43_616 VPWR VGND sg13g2_decap_8
XFILLER_28_668 VPWR VGND sg13g2_fill_2
XFILLER_28_679 VPWR VGND sg13g2_fill_2
XFILLER_13_1024 VPWR VGND sg13g2_decap_4
XFILLER_3_745 VPWR VGND sg13g2_decap_8
XFILLER_2_211 VPWR VGND sg13g2_decap_4
X_4878__48 VPWR VGND net48 sg13g2_tiehi
XFILLER_2_299 VPWR VGND sg13g2_fill_2
XFILLER_47_900 VPWR VGND sg13g2_decap_8
Xfanout570 net571 net570 VPWR VGND sg13g2_buf_8
Xfanout581 net584 net581 VPWR VGND sg13g2_buf_2
Xfanout592 net593 net592 VPWR VGND sg13g2_buf_8
XFILLER_46_410 VPWR VGND sg13g2_fill_2
XFILLER_20_1017 VPWR VGND sg13g2_decap_8
XFILLER_20_1028 VPWR VGND sg13g2_fill_1
XFILLER_47_977 VPWR VGND sg13g2_decap_8
XFILLER_18_145 VPWR VGND sg13g2_fill_2
XFILLER_34_605 VPWR VGND sg13g2_decap_8
XFILLER_27_690 VPWR VGND sg13g2_fill_2
XFILLER_15_852 VPWR VGND sg13g2_decap_8
XFILLER_15_863 VPWR VGND sg13g2_fill_2
XFILLER_25_90 VPWR VGND sg13g2_fill_2
XFILLER_41_170 VPWR VGND sg13g2_decap_4
XFILLER_30_844 VPWR VGND sg13g2_fill_2
XFILLER_30_855 VPWR VGND sg13g2_decap_4
X_3550_ videogen.test_lut_thingy.pixel_feeder_inst.row\[37\]\[3\] net557 _1268_ VPWR
+ VGND sg13g2_nor2_1
X_3481_ _1199_ _1197_ _1198_ VPWR VGND sg13g2_nand2_2
X_5151_ net372 VGND VPWR _0608_ videogen.test_lut_thingy.pixel_feeder_inst.row\[49\]\[3\]
+ _0236_ sg13g2_dfrbpq_1
X_4102_ _1804_ VPWR _1813_ VGND _1797_ net543 sg13g2_o21ai_1
X_5082_ net397 VGND VPWR _0539_ videogen.test_lut_thingy.pixel_feeder_inst.row\[50\]\[2\]
+ _0167_ sg13g2_dfrbpq_1
X_4033_ _1744_ _1015_ _1743_ VPWR VGND sg13g2_xnor2_1
XFILLER_38_977 VPWR VGND sg13g2_decap_8
X_4935_ net379 VGND VPWR _0396_ videogen.test_lut_thingy.pixel_feeder_inst.row\[16\]\[1\]
+ _0042_ sg13g2_dfrbpq_1
XFILLER_36_1024 VPWR VGND sg13g2_decap_4
XFILLER_20_321 VPWR VGND sg13g2_decap_8
XFILLER_21_833 VPWR VGND sg13g2_decap_8
X_4866_ net72 VGND VPWR _0327_ videogen.test_lut_thingy.pixel_feeder_inst.row\[34\]\[0\]
+ _0025_ sg13g2_dfrbpq_1
X_4797_ net700 net744 _0259_ VPWR VGND sg13g2_nor2_1
X_3817_ _1525_ VPWR _1534_ VGND videogen.test_lut_thingy.pixel_feeder_inst.row\[4\]\[0\]
+ net581 sg13g2_o21ai_1
X_3748_ _1466_ _0736_ _0672_ _0691_ _0673_ VPWR VGND sg13g2_a22oi_1
XFILLER_21_48 VPWR VGND sg13g2_decap_4
X_3679_ _0678_ _1385_ _1396_ _1397_ VPWR VGND sg13g2_nor3_2
XFILLER_43_1028 VPWR VGND sg13g2_fill_1
XFILLER_29_966 VPWR VGND sg13g2_decap_8
XFILLER_44_958 VPWR VGND sg13g2_decap_8
XFILLER_24_682 VPWR VGND sg13g2_fill_1
XFILLER_8_804 VPWR VGND sg13g2_decap_8
XFILLER_12_844 VPWR VGND sg13g2_decap_8
XFILLER_8_859 VPWR VGND sg13g2_decap_8
XFILLER_3_542 VPWR VGND sg13g2_decap_8
XFILLER_23_8 VPWR VGND sg13g2_decap_8
XFILLER_46_295 VPWR VGND sg13g2_decap_8
XFILLER_43_991 VPWR VGND sg13g2_decap_8
XFILLER_22_619 VPWR VGND sg13g2_decap_8
X_2981_ videogen.test_lut_thingy.pixel_feeder_inst.row\[34\]\[3\] net766 _0820_ _0330_
+ VPWR VGND sg13g2_mux2_1
X_4720_ net674 net718 _0184_ VPWR VGND sg13g2_nor2_1
X_4651_ net674 net718 _0115_ VPWR VGND sg13g2_nor2_1
XFILLER_30_685 VPWR VGND sg13g2_fill_2
X_3602_ videogen.test_lut_thingy.pixel_feeder_inst.row\[1\]\[3\] net563 _1320_ VPWR
+ VGND sg13g2_nor2_1
X_4582_ net709 net754 _0046_ VPWR VGND sg13g2_nor2_1
X_3533_ _1247_ _1248_ _1249_ _1250_ _1251_ VPWR VGND sg13g2_nor4_1
XFILLER_42_0 VPWR VGND sg13g2_decap_4
X_3464_ _1094_ _1082_ net547 _1182_ VPWR VGND sg13g2_a21o_2
X_5203_ net247 VGND VPWR _0660_ serialize.shift_reg_r\[5\] clknet_3_4__leaf_clk_regs
+ sg13g2_dfrbpq_1
X_3395_ net549 _1110_ _1113_ VPWR VGND sg13g2_nor2_1
X_5134_ net134 VGND VPWR _0591_ videogen.test_lut_thingy.pixel_feeder_inst.row\[6\]\[2\]
+ _0219_ sg13g2_dfrbpq_1
X_5065_ net77 VGND VPWR _0522_ videogen.test_lut_thingy.pixel_feeder_inst.row\[54\]\[1\]
+ _0150_ sg13g2_dfrbpq_1
X_4016_ _1727_ _1710_ _1713_ VPWR VGND sg13g2_xnor2_1
XFILLER_25_402 VPWR VGND sg13g2_fill_1
XFILLER_26_969 VPWR VGND sg13g2_decap_8
XFILLER_34_991 VPWR VGND sg13g2_decap_8
X_4918_ net409 VGND VPWR _0379_ red_tmds_par\[7\] net652 sg13g2_dfrbpq_1
XFILLER_32_36 VPWR VGND sg13g2_decap_4
X_4849_ net106 VGND VPWR _0310_ videogen.test_lut_thingy.pixel_feeder_inst.h_pix\[1\]
+ net639 sg13g2_dfrbpq_1
X_5115__253 VPWR VGND net253 sg13g2_tiehi
XFILLER_0_556 VPWR VGND sg13g2_decap_8
XFILLER_48_549 VPWR VGND sg13g2_decap_8
XFILLER_29_763 VPWR VGND sg13g2_fill_1
XFILLER_16_457 VPWR VGND sg13g2_fill_1
XFILLER_32_906 VPWR VGND sg13g2_fill_1
XFILLER_12_630 VPWR VGND sg13g2_decap_8
X_5092__345 VPWR VGND net345 sg13g2_tiehi
XFILLER_12_696 VPWR VGND sg13g2_fill_2
XFILLER_4_873 VPWR VGND sg13g2_decap_8
X_3180_ VGND VPWR videogen.test_lut_thingy.pixel_feeder_inst.v_counter\[2\] _0928_
+ _0930_ videogen.test_lut_thingy.pixel_feeder_inst.v_counter\[3\] sg13g2_a21oi_1
XFILLER_14_4 VPWR VGND sg13g2_fill_2
XFILLER_34_276 VPWR VGND sg13g2_decap_8
X_2964_ videogen.test_lut_thingy.pixel_feeder_inst.row\[16\]\[0\] net803 _0816_ _0395_
+ VPWR VGND sg13g2_mux2_1
X_4703_ net681 net725 _0167_ VPWR VGND sg13g2_nor2_1
XFILLER_31_972 VPWR VGND sg13g2_decap_8
X_2895_ videogen.test_lut_thingy.pixel_feeder_inst.row\[7\]\[3\] net769 _0802_ _0459_
+ VPWR VGND sg13g2_mux2_1
X_4634_ net693 net738 _0098_ VPWR VGND sg13g2_nor2_1
XFILLER_8_82 VPWR VGND sg13g2_decap_8
X_4565_ net710 net753 _0030_ VPWR VGND sg13g2_nor2_1
X_3516_ videogen.test_lut_thingy.pixel_feeder_inst.row\[55\]\[3\] net571 _1234_ VPWR
+ VGND sg13g2_nor2_1
X_4496_ VPWR _0642_ _2162_ VGND sg13g2_inv_1
X_3447_ _1136_ _1152_ _1158_ _1159_ _1165_ VPWR VGND sg13g2_and4_1
X_3378_ VPWR VGND net548 _1081_ _1095_ _1086_ _1096_ _1087_ sg13g2_a221oi_1
X_5117_ net245 VGND VPWR _0574_ videogen.test_lut_thingy.pixel_feeder_inst.row\[42\]\[1\]
+ _0202_ sg13g2_dfrbpq_1
X_5048_ net158 VGND VPWR _0505_ videogen.test_lut_thingy.pixel_feeder_inst.row\[27\]\[0\]
+ _0133_ sg13g2_dfrbpq_1
X_4853__98 VPWR VGND net98 sg13g2_tiehi
XFILLER_14_928 VPWR VGND sg13g2_decap_8
XFILLER_43_35 VPWR VGND sg13g2_fill_2
XFILLER_43_24 VPWR VGND sg13g2_decap_8
XFILLER_22_983 VPWR VGND sg13g2_decap_8
X_4917__410 VPWR VGND net410 sg13g2_tiehi
XFILLER_49_1001 VPWR VGND sg13g2_decap_8
XFILLER_0_364 VPWR VGND sg13g2_fill_2
XFILLER_1_876 VPWR VGND sg13g2_decap_8
XFILLER_49_847 VPWR VGND sg13g2_decap_8
XFILLER_0_397 VPWR VGND sg13g2_fill_1
XFILLER_29_582 VPWR VGND sg13g2_decap_8
XFILLER_17_755 VPWR VGND sg13g2_decap_4
XFILLER_44_563 VPWR VGND sg13g2_fill_1
XFILLER_13_961 VPWR VGND sg13g2_decap_8
XFILLER_32_769 VPWR VGND sg13g2_decap_8
XFILLER_40_791 VPWR VGND sg13g2_fill_1
XFILLER_12_471 VPWR VGND sg13g2_decap_4
XFILLER_9_965 VPWR VGND sg13g2_decap_8
X_2680_ _0736_ _0738_ net603 _0740_ VPWR VGND sg13g2_nand3_1
X_4350_ VGND VPWR _2039_ _2038_ _2031_ sg13g2_or2_1
X_3301_ _1019_ net635 videogen.fancy_shader.shader_counter_reg\[7\] VPWR VGND sg13g2_xnor2_1
X_4281_ _1984_ _1983_ _1947_ _1978_ _1946_ VPWR VGND sg13g2_a22oi_1
X_3232_ videogen.fancy_shader.video_y\[7\] net611 net612 videogen.fancy_shader.video_y\[4\]
+ _0963_ VPWR VGND sg13g2_nor4_1
X_4968__330 VPWR VGND net330 sg13g2_tiehi
X_3163_ _0843_ _0917_ _0918_ _0312_ VPWR VGND sg13g2_nor3_1
XFILLER_48_880 VPWR VGND sg13g2_decap_8
X_3094_ net453 net659 _0271_ VPWR VGND sg13g2_and2_1
XFILLER_35_552 VPWR VGND sg13g2_decap_4
X_3996_ _1707_ _1691_ _1704_ _1705_ VPWR VGND sg13g2_and3_1
X_2947_ videogen.test_lut_thingy.pixel_feeder_inst.row\[36\]\[2\] net774 _0813_ _0418_
+ VPWR VGND sg13g2_mux2_1
XFILLER_13_49 VPWR VGND sg13g2_decap_8
X_4617_ net705 net749 _0081_ VPWR VGND sg13g2_nor2_1
X_2878_ videogen.test_lut_thingy.pixel_feeder_inst.row\[60\]\[3\] net767 _0797_ _0471_
+ VPWR VGND sg13g2_mux2_1
X_4548_ net701 net745 _0014_ VPWR VGND sg13g2_nor2_1
X_4479_ _2153_ _2064_ _2151_ VPWR VGND sg13g2_nand2_1
XFILLER_46_828 VPWR VGND sg13g2_decap_8
XFILLER_26_585 VPWR VGND sg13g2_fill_1
XFILLER_41_544 VPWR VGND sg13g2_fill_2
XFILLER_9_206 VPWR VGND sg13g2_fill_1
XFILLER_13_235 VPWR VGND sg13g2_fill_2
XFILLER_9_228 VPWR VGND sg13g2_fill_2
XFILLER_10_920 VPWR VGND sg13g2_decap_8
XFILLER_22_780 VPWR VGND sg13g2_decap_8
XFILLER_6_913 VPWR VGND sg13g2_decap_8
XFILLER_10_997 VPWR VGND sg13g2_decap_8
XFILLER_5_456 VPWR VGND sg13g2_decap_4
XFILLER_49_600 VPWR VGND sg13g2_decap_8
XFILLER_49_622 VPWR VGND sg13g2_decap_8
XFILLER_49_699 VPWR VGND sg13g2_fill_2
X_2618__1 VPWR net446 clknet_1_0__leaf_clk VGND sg13g2_inv_1
XFILLER_36_305 VPWR VGND sg13g2_fill_1
X_4928__391 VPWR VGND net391 sg13g2_tiehi
XFILLER_44_393 VPWR VGND sg13g2_fill_1
XFILLER_44_371 VPWR VGND sg13g2_fill_1
X_3850_ VGND VPWR _1558_ _1561_ _1567_ _1566_ sg13g2_a21oi_1
X_3781_ _1495_ _1496_ _1497_ _1498_ _1499_ VPWR VGND sg13g2_nor4_1
X_2801_ videogen.test_lut_thingy.pixel_feeder_inst.row\[4\]\[0\] net802 _0781_ _0541_
+ VPWR VGND sg13g2_mux2_1
X_2732_ videogen.test_lut_thingy.pixel_feeder_inst.row\[6\]\[3\] net768 _0763_ _0592_
+ VPWR VGND sg13g2_mux2_1
X_2663_ _0727_ _0730_ _0731_ VPWR VGND sg13g2_nor2_2
X_4402_ _2083_ tmds_blue.dc_balancing_reg\[2\] _2081_ VPWR VGND sg13g2_xnor2_1
X_4333_ _2023_ _2007_ _2021_ VPWR VGND sg13g2_xnor2_1
X_4264_ _1967_ _1964_ _1968_ VPWR VGND sg13g2_xor2_1
X_3215_ videogen.fancy_shader.shader_counter_reg\[7\] _0951_ _0953_ VPWR VGND sg13g2_nor2_1
X_4195_ _1899_ _1881_ _1901_ VPWR VGND sg13g2_xor2_1
X_3146_ VGND VPWR videogen.test_lut_thingy.pixel_feeder_inst.v_pix\[3\] _0904_ _0907_
+ videogen.test_lut_thingy.pixel_feeder_inst.v_pix\[4\] sg13g2_a21oi_1
XFILLER_28_839 VPWR VGND sg13g2_fill_1
X_3077_ _0871_ net811 _0840_ VPWR VGND sg13g2_nand2_1
X_4907__420 VPWR VGND net420 sg13g2_tiehi
XFILLER_23_566 VPWR VGND sg13g2_decap_8
XFILLER_24_37 VPWR VGND sg13g2_fill_1
XFILLER_24_59 VPWR VGND sg13g2_decap_4
X_3979_ _1085_ _1102_ _1688_ _1690_ VPWR VGND sg13g2_nor3_1
X_4914__413 VPWR VGND net413 sg13g2_tiehi
XFILLER_3_916 VPWR VGND sg13g2_decap_8
XFILLER_49_56 VPWR VGND sg13g2_decap_8
Xfanout741 net742 net741 VPWR VGND sg13g2_buf_8
Xfanout730 net736 net730 VPWR VGND sg13g2_buf_2
Xfanout785 net788 net785 VPWR VGND sg13g2_buf_8
Xfanout774 net783 net774 VPWR VGND sg13g2_buf_8
Xfanout763 net765 net763 VPWR VGND sg13g2_buf_8
Xfanout752 net755 net752 VPWR VGND sg13g2_buf_8
XFILLER_45_102 VPWR VGND sg13g2_decap_8
Xfanout796 net805 net796 VPWR VGND sg13g2_buf_1
XFILLER_46_647 VPWR VGND sg13g2_fill_1
XFILLER_45_124 VPWR VGND sg13g2_decap_8
XFILLER_45_113 VPWR VGND sg13g2_fill_1
XFILLER_46_669 VPWR VGND sg13g2_fill_2
XFILLER_27_850 VPWR VGND sg13g2_decap_4
XFILLER_33_308 VPWR VGND sg13g2_decap_4
XFILLER_42_831 VPWR VGND sg13g2_fill_1
XFILLER_42_897 VPWR VGND sg13g2_fill_2
XFILLER_14_70 VPWR VGND sg13g2_decap_4
XFILLER_14_92 VPWR VGND sg13g2_decap_8
XFILLER_46_7 VPWR VGND sg13g2_decap_4
XFILLER_49_474 VPWR VGND sg13g2_decap_8
XFILLER_37_603 VPWR VGND sg13g2_fill_2
X_3000_ _0742_ _0762_ _0824_ VPWR VGND sg13g2_nor2_2
XFILLER_17_371 VPWR VGND sg13g2_decap_4
X_4951_ net356 VGND VPWR _0408_ red_tmds_par\[4\] net653 sg13g2_dfrbpq_1
X_3902_ _1614_ _1591_ _1616_ VPWR VGND sg13g2_xor2_1
X_4882_ net40 VGND VPWR _0343_ videogen.fancy_shader.video_y\[0\] net655 sg13g2_dfrbpq_2
XFILLER_20_514 VPWR VGND sg13g2_fill_2
X_3833_ net597 VPWR _1550_ VGND videogen.test_lut_thingy.pixel_feeder_inst.row\[16\]\[0\]
+ net580 sg13g2_o21ai_1
XFILLER_33_886 VPWR VGND sg13g2_decap_8
X_3764_ net623 _1476_ _1481_ _1482_ VPWR VGND sg13g2_nor3_1
X_2715_ videogen.test_lut_thingy.pixel_feeder_inst.row\[38\]\[2\] net773 _0757_ _0603_
+ VPWR VGND sg13g2_mux2_1
X_3695_ _1409_ _1410_ _1411_ _1412_ _1413_ VPWR VGND sg13g2_nor4_1
XFILLER_10_28 VPWR VGND sg13g2_decap_8
X_2646_ _0718_ net615 _0716_ VPWR VGND sg13g2_xnor2_1
X_4316_ tmds_green.dc_balancing_reg\[2\] _2005_ _2006_ VPWR VGND sg13g2_nor2_1
X_4247_ VGND VPWR _1903_ _1941_ _1951_ _1940_ sg13g2_a21oi_1
X_4178_ VGND VPWR red\[7\] _1880_ _1884_ _1883_ sg13g2_a21oi_1
X_3129_ net811 VPWR _0894_ VGND _0699_ _0705_ sg13g2_o21ai_1
X_5042__191 VPWR VGND net191 sg13g2_tiehi
XFILLER_36_691 VPWR VGND sg13g2_decap_8
XFILLER_42_138 VPWR VGND sg13g2_fill_2
XFILLER_23_341 VPWR VGND sg13g2_fill_2
XFILLER_23_374 VPWR VGND sg13g2_fill_1
XFILLER_24_886 VPWR VGND sg13g2_decap_8
XFILLER_23_396 VPWR VGND sg13g2_fill_1
XFILLER_7_518 VPWR VGND sg13g2_decap_8
XFILLER_13_1003 VPWR VGND sg13g2_decap_8
Xfanout560 _0737_ net560 VPWR VGND sg13g2_buf_8
Xfanout582 net584 net582 VPWR VGND sg13g2_buf_8
Xfanout593 _0692_ net593 VPWR VGND sg13g2_buf_8
Xfanout571 net574 net571 VPWR VGND sg13g2_buf_8
XFILLER_47_956 VPWR VGND sg13g2_decap_8
X_4808__170 VPWR VGND net170 sg13g2_tiehi
XFILLER_18_179 VPWR VGND sg13g2_decap_4
XFILLER_42_672 VPWR VGND sg13g2_fill_2
X_3480_ _1198_ net550 _1192_ VPWR VGND sg13g2_nand2_1
X_5150_ net380 VGND VPWR _0607_ videogen.test_lut_thingy.pixel_feeder_inst.row\[49\]\[2\]
+ _0235_ sg13g2_dfrbpq_1
X_4101_ net543 VPWR _1812_ VGND _1798_ _1799_ sg13g2_o21ai_1
X_5081_ net401 VGND VPWR _0538_ videogen.test_lut_thingy.pixel_feeder_inst.row\[50\]\[1\]
+ _0166_ sg13g2_dfrbpq_1
XFILLER_49_260 VPWR VGND sg13g2_decap_8
XFILLER_38_923 VPWR VGND sg13g2_fill_1
XFILLER_2_51 VPWR VGND sg13g2_decap_8
XFILLER_2_62 VPWR VGND sg13g2_fill_1
X_4032_ _1742_ _1683_ _1743_ VPWR VGND sg13g2_xor2_1
XFILLER_49_271 VPWR VGND sg13g2_fill_2
XFILLER_37_466 VPWR VGND sg13g2_decap_4
X_4904__423 VPWR VGND net423 sg13g2_tiehi
XFILLER_24_105 VPWR VGND sg13g2_decap_8
XFILLER_25_628 VPWR VGND sg13g2_fill_2
XFILLER_40_609 VPWR VGND sg13g2_decap_4
X_4934_ net381 VGND VPWR _0395_ videogen.test_lut_thingy.pixel_feeder_inst.row\[16\]\[0\]
+ _0041_ sg13g2_dfrbpq_1
XFILLER_36_1003 VPWR VGND sg13g2_decap_8
XFILLER_21_812 VPWR VGND sg13g2_decap_8
X_4865_ net74 VGND VPWR _0326_ videogen.test_lut_thingy.pixel_feeder_inst.row\[37\]\[3\]
+ _0024_ sg13g2_dfrbpq_1
X_4796_ net698 net742 _0258_ VPWR VGND sg13g2_nor2_1
X_3816_ _1524_ VPWR _1533_ VGND videogen.test_lut_thingy.pixel_feeder_inst.row\[7\]\[0\]
+ net570 sg13g2_o21ai_1
X_3747_ net624 VPWR _1465_ VGND videogen.test_lut_thingy.pixel_feeder_inst.row\[63\]\[1\]
+ net571 sg13g2_o21ai_1
XFILLER_20_377 VPWR VGND sg13g2_fill_1
X_3678_ net597 _1390_ _1395_ _1396_ VPWR VGND sg13g2_nor3_1
X_2629_ _0701_ videogen.fancy_shader.video_x\[7\] _0700_ VPWR VGND sg13g2_nand2_1
X_4911__416 VPWR VGND net416 sg13g2_tiehi
XFILLER_0_749 VPWR VGND sg13g2_decap_8
XFILLER_29_901 VPWR VGND sg13g2_decap_8
XFILLER_29_945 VPWR VGND sg13g2_decap_8
XFILLER_46_68 VPWR VGND sg13g2_fill_1
XFILLER_44_937 VPWR VGND sg13g2_decap_8
XFILLER_15_116 VPWR VGND sg13g2_decap_8
XFILLER_28_477 VPWR VGND sg13g2_fill_1
XFILLER_28_488 VPWR VGND sg13g2_fill_2
XFILLER_8_838 VPWR VGND sg13g2_fill_2
XFILLER_11_399 VPWR VGND sg13g2_decap_8
XFILLER_3_521 VPWR VGND sg13g2_decap_8
XFILLER_47_764 VPWR VGND sg13g2_decap_4
XFILLER_46_230 VPWR VGND sg13g2_fill_2
XFILLER_46_274 VPWR VGND sg13g2_fill_1
XFILLER_46_263 VPWR VGND sg13g2_decap_8
XFILLER_34_425 VPWR VGND sg13g2_fill_2
XFILLER_34_436 VPWR VGND sg13g2_fill_2
XFILLER_36_90 VPWR VGND sg13g2_fill_1
XFILLER_43_970 VPWR VGND sg13g2_decap_8
X_2980_ _0755_ _0768_ _0820_ VPWR VGND sg13g2_nor2_2
X_5056__113 VPWR VGND net113 sg13g2_tiehi
XFILLER_15_683 VPWR VGND sg13g2_decap_8
X_4650_ net675 net719 _0114_ VPWR VGND sg13g2_nor2_1
X_3601_ videogen.test_lut_thingy.pixel_feeder_inst.row\[2\]\[3\] net591 _1319_ VPWR
+ VGND sg13g2_nor2_1
X_4581_ net709 net754 _0045_ VPWR VGND sg13g2_nor2_1
X_3532_ videogen.test_lut_thingy.pixel_feeder_inst.row\[56\]\[3\] net576 _1250_ VPWR
+ VGND sg13g2_nor2_1
X_3463_ _1181_ _1180_ VPWR VGND _1179_ sg13g2_nand2b_2
X_5202_ net255 VGND VPWR _0659_ serialize.shift_reg_r\[4\] clknet_3_4__leaf_clk_regs
+ sg13g2_dfrbpq_1
X_3394_ _1112_ _1111_ _1098_ _1109_ net549 VPWR VGND sg13g2_a22oi_1
X_5133_ net144 VGND VPWR _0590_ videogen.test_lut_thingy.pixel_feeder_inst.row\[6\]\[1\]
+ _0218_ sg13g2_dfrbpq_1
XFILLER_35_0 VPWR VGND sg13g2_fill_2
X_4865__74 VPWR VGND net74 sg13g2_tiehi
X_5064_ net81 VGND VPWR _0521_ videogen.test_lut_thingy.pixel_feeder_inst.row\[54\]\[0\]
+ _0149_ sg13g2_dfrbpq_1
XFILLER_29_219 VPWR VGND sg13g2_decap_8
X_4015_ _1716_ _1719_ _1724_ _1726_ VPWR VGND sg13g2_or3_1
X_4880__44 VPWR VGND net44 sg13g2_tiehi
XFILLER_16_16 VPWR VGND sg13g2_fill_2
XFILLER_26_948 VPWR VGND sg13g2_decap_8
XFILLER_16_27 VPWR VGND sg13g2_decap_8
XFILLER_25_436 VPWR VGND sg13g2_decap_8
X_4978__310 VPWR VGND net310 sg13g2_tiehi
XFILLER_34_970 VPWR VGND sg13g2_decap_8
X_4917_ net410 VGND VPWR _0378_ red_tmds_par\[5\] net653 sg13g2_dfrbpq_1
X_4848_ net108 VGND VPWR _0309_ videogen.test_lut_thingy.pixel_feeder_inst.h_pix\[0\]
+ net639 sg13g2_dfrbpq_1
XFILLER_21_642 VPWR VGND sg13g2_decap_4
XFILLER_21_697 VPWR VGND sg13g2_decap_4
X_4779_ net684 net728 _0241_ VPWR VGND sg13g2_nor2_1
XFILLER_4_318 VPWR VGND sg13g2_fill_2
XFILLER_0_535 VPWR VGND sg13g2_decap_8
XFILLER_48_528 VPWR VGND sg13g2_decap_8
X_5122__225 VPWR VGND net225 sg13g2_tiehi
XFILLER_29_742 VPWR VGND sg13g2_decap_8
XFILLER_29_775 VPWR VGND sg13g2_decap_8
XFILLER_29_797 VPWR VGND sg13g2_decap_8
XFILLER_16_436 VPWR VGND sg13g2_decap_4
XFILLER_43_255 VPWR VGND sg13g2_fill_1
X_4805__173 VPWR VGND net173 sg13g2_tiehi
XFILLER_40_984 VPWR VGND sg13g2_decap_8
XFILLER_12_686 VPWR VGND sg13g2_fill_2
XFILLER_7_156 VPWR VGND sg13g2_fill_1
XFILLER_3_340 VPWR VGND sg13g2_decap_8
XFILLER_3_395 VPWR VGND sg13g2_fill_1
X_4812__166 VPWR VGND net166 sg13g2_tiehi
XFILLER_39_528 VPWR VGND sg13g2_fill_1
X_5101__309 VPWR VGND net309 sg13g2_tiehi
XFILLER_19_296 VPWR VGND sg13g2_decap_4
XFILLER_34_222 VPWR VGND sg13g2_fill_2
XFILLER_34_233 VPWR VGND sg13g2_decap_8
XFILLER_34_244 VPWR VGND sg13g2_decap_8
XFILLER_34_255 VPWR VGND sg13g2_decap_8
X_4901__426 VPWR VGND net426 sg13g2_tiehi
X_2963_ videogen.test_lut_thingy.pixel_feeder_inst.row\[16\]\[1\] net790 _0816_ _0396_
+ VPWR VGND sg13g2_mux2_1
X_4702_ net683 net727 _0166_ VPWR VGND sg13g2_nor2_1
X_2894_ _0732_ _0762_ _0802_ VPWR VGND sg13g2_nor2_2
XFILLER_33_1028 VPWR VGND sg13g2_fill_1
X_4633_ net694 net738 _0097_ VPWR VGND sg13g2_nor2_1
X_4564_ net704 net748 _0029_ VPWR VGND sg13g2_nor2_1
X_3515_ videogen.test_lut_thingy.pixel_feeder_inst.row\[52\]\[3\] net580 _1233_ VPWR
+ VGND sg13g2_nor2_1
X_4495_ _2162_ net659 net477 net663 serialize.tmds_parallel_b\[3\] VPWR VGND sg13g2_a22oi_1
X_3446_ _1164_ _1149_ _1163_ VPWR VGND sg13g2_nand2_1
X_3377_ _1095_ _1092_ _1093_ VPWR VGND sg13g2_xnor2_1
X_5116_ net249 VGND VPWR _0573_ videogen.test_lut_thingy.pixel_feeder_inst.row\[42\]\[0\]
+ _0201_ sg13g2_dfrbpq_1
X_5047_ net162 VGND VPWR _0504_ videogen.test_lut_thingy.pixel_feeder_inst.row\[28\]\[3\]
+ _0132_ sg13g2_dfrbpq_1
XFILLER_25_200 VPWR VGND sg13g2_fill_1
XFILLER_27_37 VPWR VGND sg13g2_decap_8
XFILLER_41_726 VPWR VGND sg13g2_fill_2
XFILLER_43_58 VPWR VGND sg13g2_fill_2
XFILLER_40_258 VPWR VGND sg13g2_decap_8
XFILLER_40_247 VPWR VGND sg13g2_decap_4
XFILLER_22_962 VPWR VGND sg13g2_decap_8
X_5039__196 VPWR VGND net196 sg13g2_tiehi
XFILLER_4_126 VPWR VGND sg13g2_decap_4
XFILLER_0_310 VPWR VGND sg13g2_fill_1
XFILLER_0_343 VPWR VGND sg13g2_decap_8
XFILLER_1_855 VPWR VGND sg13g2_decap_8
XFILLER_49_826 VPWR VGND sg13g2_decap_8
XFILLER_48_325 VPWR VGND sg13g2_fill_2
XFILLER_36_509 VPWR VGND sg13g2_decap_8
XFILLER_17_70 VPWR VGND sg13g2_decap_4
XFILLER_13_940 VPWR VGND sg13g2_decap_8
XFILLER_9_944 VPWR VGND sg13g2_decap_8
XFILLER_12_450 VPWR VGND sg13g2_fill_1
XFILLER_33_80 VPWR VGND sg13g2_decap_8
X_3300_ VGND VPWR _1018_ videogen.fancy_shader.shader_counter_reg\[7\] net635 sg13g2_or2_1
X_4280_ _1983_ _1980_ _1982_ VPWR VGND sg13g2_xnor2_1
X_3231_ VGND VPWR _0850_ _0877_ _0962_ videogen.fancy_shader.video_y\[2\] sg13g2_a21oi_1
X_3162_ net601 net597 net570 _0911_ _0918_ VPWR VGND sg13g2_nor4_1
XFILLER_39_336 VPWR VGND sg13g2_decap_8
XFILLER_27_509 VPWR VGND sg13g2_decap_8
X_3093_ net451 net660 _0270_ VPWR VGND sg13g2_and2_1
XFILLER_22_203 VPWR VGND sg13g2_fill_2
X_3995_ VGND VPWR _1704_ _1705_ _1706_ _1691_ sg13g2_a21oi_1
XFILLER_22_258 VPWR VGND sg13g2_fill_1
X_2946_ videogen.test_lut_thingy.pixel_feeder_inst.row\[36\]\[3\] net762 _0813_ _0419_
+ VPWR VGND sg13g2_mux2_1
XFILLER_13_28 VPWR VGND sg13g2_decap_8
X_2877_ _0748_ _0773_ _0797_ VPWR VGND sg13g2_nor2_2
X_4616_ net705 net749 _0080_ VPWR VGND sg13g2_nor2_1
X_4547_ net695 net739 _0013_ VPWR VGND sg13g2_nor2_1
X_4478_ _2064_ _2151_ _2152_ VPWR VGND sg13g2_nor2_1
X_3429_ _1114_ _1125_ _1145_ _1147_ VPWR VGND sg13g2_or3_1
X_5181__95 VPWR VGND net95 sg13g2_tiehi
XFILLER_46_807 VPWR VGND sg13g2_decap_8
XFILLER_38_47 VPWR VGND sg13g2_decap_8
XFILLER_13_214 VPWR VGND sg13g2_decap_8
XFILLER_13_225 VPWR VGND sg13g2_fill_1
XFILLER_13_258 VPWR VGND sg13g2_fill_2
XFILLER_13_269 VPWR VGND sg13g2_decap_8
X_4802__176 VPWR VGND net176 sg13g2_tiehi
XFILLER_10_976 VPWR VGND sg13g2_decap_8
XFILLER_6_969 VPWR VGND sg13g2_decap_8
XFILLER_1_696 VPWR VGND sg13g2_fill_1
XFILLER_0_195 VPWR VGND sg13g2_decap_8
XFILLER_49_678 VPWR VGND sg13g2_decap_8
XFILLER_48_177 VPWR VGND sg13g2_fill_1
XFILLER_45_895 VPWR VGND sg13g2_decap_8
X_3780_ videogen.test_lut_thingy.pixel_feeder_inst.row\[12\]\[1\] net582 _1498_ VPWR
+ VGND sg13g2_nor2_1
X_2800_ videogen.test_lut_thingy.pixel_feeder_inst.row\[4\]\[1\] net792 _0781_ _0542_
+ VPWR VGND sg13g2_mux2_1
XFILLER_9_752 VPWR VGND sg13g2_decap_8
X_2731_ _0730_ _0762_ _0763_ VPWR VGND sg13g2_nor2_2
XFILLER_9_796 VPWR VGND sg13g2_decap_8
X_4401_ _2082_ tmds_blue.dc_balancing_reg\[2\] _2081_ VPWR VGND sg13g2_nand2_1
XFILLER_8_284 VPWR VGND sg13g2_fill_2
X_2662_ net633 _0711_ net629 _0730_ VPWR VGND sg13g2_nand3_1
XFILLER_5_980 VPWR VGND sg13g2_decap_8
X_4332_ _2022_ _2007_ _2021_ VPWR VGND sg13g2_nand2_1
XFILLER_5_95 VPWR VGND sg13g2_fill_2
XFILLER_5_84 VPWR VGND sg13g2_fill_2
X_4263_ _1965_ _1955_ _1967_ VPWR VGND sg13g2_xor2_1
X_3214_ videogen.fancy_shader.shader_counter_reg\[7\] _0951_ _0952_ VPWR VGND sg13g2_and2_1
X_4194_ _1881_ _1899_ _1900_ VPWR VGND sg13g2_nor2_1
XFILLER_39_166 VPWR VGND sg13g2_fill_2
X_3145_ VGND VPWR videogen.test_lut_thingy.pixel_feeder_inst.v_pix\[3\] _0904_ _0306_
+ _0906_ sg13g2_a21oi_1
XFILLER_27_306 VPWR VGND sg13g2_fill_1
X_3076_ VPWR clk_video _0005_ VGND sg13g2_inv_1
XFILLER_36_895 VPWR VGND sg13g2_decap_8
X_3978_ _1102_ _1688_ _1689_ VPWR VGND sg13g2_nor2_1
X_5192__384 VPWR VGND net384 sg13g2_tiehi
X_2929_ videogen.test_lut_thingy.pixel_feeder_inst.row\[31\]\[0\] net798 _0809_ _0432_
+ VPWR VGND sg13g2_mux2_1
X_5036__199 VPWR VGND net199 sg13g2_tiehi
XFILLER_49_35 VPWR VGND sg13g2_decap_8
XFILLER_49_79 VPWR VGND sg13g2_decap_8
Xfanout720 net723 net720 VPWR VGND sg13g2_buf_2
Xfanout742 net743 net742 VPWR VGND sg13g2_buf_8
Xfanout731 net732 net731 VPWR VGND sg13g2_buf_8
Xfanout764 net765 net764 VPWR VGND sg13g2_buf_1
Xfanout753 net755 net753 VPWR VGND sg13g2_buf_1
Xfanout775 net776 net775 VPWR VGND sg13g2_buf_8
X_4986__294 VPWR VGND net294 sg13g2_tiehi
XFILLER_19_829 VPWR VGND sg13g2_fill_1
Xfanout797 net805 net797 VPWR VGND sg13g2_buf_8
Xfanout786 net787 net786 VPWR VGND sg13g2_buf_8
X_5067__69 VPWR VGND net69 sg13g2_tiehi
XFILLER_26_372 VPWR VGND sg13g2_decap_8
XFILLER_27_884 VPWR VGND sg13g2_fill_1
XFILLER_41_331 VPWR VGND sg13g2_decap_8
XFILLER_6_744 VPWR VGND sg13g2_decap_8
XFILLER_10_784 VPWR VGND sg13g2_fill_2
XFILLER_39_7 VPWR VGND sg13g2_fill_1
XFILLER_49_453 VPWR VGND sg13g2_decap_8
XFILLER_39_90 VPWR VGND sg13g2_decap_8
X_4950_ net357 VGND VPWR _0407_ red_tmds_par\[2\] net653 sg13g2_dfrbpq_1
XFILLER_44_180 VPWR VGND sg13g2_decap_8
X_3901_ _1591_ _1614_ _1615_ VPWR VGND sg13g2_nor2_1
X_4881_ net42 VGND VPWR _0342_ tmds_red.dc_balancing_reg\[0\] net653 sg13g2_dfrbpq_1
XFILLER_33_865 VPWR VGND sg13g2_fill_2
X_3832_ _1528_ _1529_ _1530_ _1548_ _1549_ VPWR VGND sg13g2_or4_1
XFILLER_32_375 VPWR VGND sg13g2_decap_4
X_3763_ _1477_ _1478_ _1479_ _1480_ _1481_ VPWR VGND sg13g2_nor4_1
X_2714_ videogen.test_lut_thingy.pixel_feeder_inst.row\[38\]\[3\] net761 _0757_ _0604_
+ VPWR VGND sg13g2_mux2_1
X_3694_ videogen.test_lut_thingy.pixel_feeder_inst.row\[41\]\[2\] net558 _1412_ VPWR
+ VGND sg13g2_nor2_1
X_2645_ _0678_ _0716_ _0717_ VPWR VGND sg13g2_and2_1
X_4315_ _2003_ _2004_ _2005_ VPWR VGND sg13g2_nor2b_2
X_4246_ net555 _1950_ _0372_ VPWR VGND sg13g2_nor2_1
XFILLER_28_604 VPWR VGND sg13g2_decap_8
X_4177_ red\[4\] red\[6\] _1876_ _1883_ VPWR VGND sg13g2_mux2_1
X_3128_ net807 _0893_ _0302_ VPWR VGND sg13g2_and2_1
X_3059_ VGND VPWR videogen.test_lut_thingy.pixel_feeder_inst.v_pix\[1\] _0858_ _0863_
+ videogen.test_lut_thingy.pixel_feeder_inst.v_pix\[2\] sg13g2_a21oi_1
XFILLER_27_169 VPWR VGND sg13g2_decap_4
XFILLER_23_320 VPWR VGND sg13g2_decap_8
XFILLER_23_331 VPWR VGND sg13g2_fill_2
XFILLER_24_832 VPWR VGND sg13g2_decap_8
XFILLER_23_364 VPWR VGND sg13g2_fill_2
X_5118__241 VPWR VGND net241 sg13g2_tiehi
XFILLER_3_725 VPWR VGND sg13g2_fill_1
XFILLER_3_714 VPWR VGND sg13g2_decap_8
XFILLER_4_4 VPWR VGND sg13g2_fill_2
Xfanout550 _1117_ net550 VPWR VGND sg13g2_buf_8
Xfanout561 net564 net561 VPWR VGND sg13g2_buf_8
Xfanout583 net584 net583 VPWR VGND sg13g2_buf_8
Xfanout572 net574 net572 VPWR VGND sg13g2_buf_8
XFILLER_47_935 VPWR VGND sg13g2_decap_8
XFILLER_46_412 VPWR VGND sg13g2_fill_1
Xfanout594 net595 net594 VPWR VGND sg13g2_buf_8
XFILLER_18_103 VPWR VGND sg13g2_fill_2
XFILLER_18_125 VPWR VGND sg13g2_fill_2
XFILLER_46_478 VPWR VGND sg13g2_decap_8
XFILLER_33_106 VPWR VGND sg13g2_fill_1
XFILLER_33_139 VPWR VGND sg13g2_fill_2
XFILLER_15_865 VPWR VGND sg13g2_fill_1
X_5095__333 VPWR VGND net333 sg13g2_tiehi
XFILLER_25_92 VPWR VGND sg13g2_fill_1
X_5171__243 VPWR VGND net243 sg13g2_tiehi
XFILLER_29_1022 VPWR VGND sg13g2_decap_8
X_4877__50 VPWR VGND net50 sg13g2_tiehi
X_4100_ _1807_ _1810_ _1811_ VPWR VGND sg13g2_and2_1
X_5080_ net405 VGND VPWR _0537_ videogen.test_lut_thingy.pixel_feeder_inst.row\[50\]\[0\]
+ _0165_ sg13g2_dfrbpq_1
X_4031_ _1138_ _1675_ _1742_ VPWR VGND sg13g2_nor2_2
X_4933_ net383 VGND VPWR _0394_ videogen.test_lut_thingy.pixel_feeder_inst.row\[17\]\[3\]
+ _0040_ sg13g2_dfrbpq_1
X_4864_ net76 VGND VPWR _0325_ videogen.test_lut_thingy.pixel_feeder_inst.row\[37\]\[2\]
+ _0023_ sg13g2_dfrbpq_1
X_3815_ _1532_ _0691_ videogen.test_lut_thingy.pixel_feeder_inst.row\[54\]\[0\] VPWR
+ VGND sg13g2_nand2b_1
XFILLER_20_345 VPWR VGND sg13g2_decap_8
X_4795_ net698 net742 _0257_ VPWR VGND sg13g2_nor2_1
X_3746_ _1460_ _1461_ _1462_ _1463_ _1464_ VPWR VGND sg13g2_nor4_1
X_3677_ _1391_ _1392_ _1393_ _1394_ _1395_ VPWR VGND sg13g2_nor4_1
X_2628_ videogen.fancy_shader.video_x\[8\] videogen.fancy_shader.video_x\[9\] _0700_
+ VPWR VGND sg13g2_nor2b_2
XFILLER_43_1019 VPWR VGND sg13g2_decap_8
XFILLER_47_209 VPWR VGND sg13g2_decap_4
X_4229_ _1934_ net544 _1903_ VPWR VGND sg13g2_nand2_1
XFILLER_44_916 VPWR VGND sg13g2_decap_8
XFILLER_11_334 VPWR VGND sg13g2_decap_8
XFILLER_7_338 VPWR VGND sg13g2_decap_8
X_5060__97 VPWR VGND net97 sg13g2_tiehi
XFILLER_3_588 VPWR VGND sg13g2_fill_2
XFILLER_3_577 VPWR VGND sg13g2_decap_8
X_5049__154 VPWR VGND net154 sg13g2_tiehi
XFILLER_4_1013 VPWR VGND sg13g2_decap_8
XFILLER_19_467 VPWR VGND sg13g2_fill_1
XFILLER_34_448 VPWR VGND sg13g2_fill_2
XFILLER_30_621 VPWR VGND sg13g2_decap_4
XFILLER_42_492 VPWR VGND sg13g2_decap_8
X_3600_ videogen.test_lut_thingy.pixel_feeder_inst.row\[0\]\[3\] net583 _1318_ VPWR
+ VGND sg13g2_nor2_1
XFILLER_30_676 VPWR VGND sg13g2_decap_4
XFILLER_30_687 VPWR VGND sg13g2_fill_1
X_4580_ net702 net746 _0044_ VPWR VGND sg13g2_nor2_1
XFILLER_7_850 VPWR VGND sg13g2_fill_2
X_3531_ videogen.test_lut_thingy.pixel_feeder_inst.row\[59\]\[3\] net566 _1249_ VPWR
+ VGND sg13g2_nor2_1
X_3462_ _1180_ net546 _1178_ VPWR VGND sg13g2_nand2_1
X_5201_ net263 VGND VPWR _0658_ serialize.shift_reg_r\[3\] clknet_3_4__leaf_clk_regs
+ sg13g2_dfrbpq_1
X_3393_ net549 _1110_ _1100_ _1111_ VPWR VGND sg13g2_nand3_1
Xclkbuf_1_0__f_clk clknet_0_clk clknet_1_0__leaf_clk VPWR VGND sg13g2_buf_8
X_5132_ net152 VGND VPWR _0589_ videogen.test_lut_thingy.pixel_feeder_inst.row\[6\]\[0\]
+ _0217_ sg13g2_dfrbpq_1
X_5063_ net85 VGND VPWR _0520_ videogen.test_lut_thingy.pixel_feeder_inst.row\[55\]\[3\]
+ _0148_ sg13g2_dfrbpq_1
XFILLER_38_743 VPWR VGND sg13g2_fill_1
XFILLER_37_231 VPWR VGND sg13g2_fill_2
X_4014_ VGND VPWR _1725_ _1724_ _1719_ sg13g2_or2_1
XFILLER_26_905 VPWR VGND sg13g2_fill_1
XFILLER_37_264 VPWR VGND sg13g2_fill_2
XFILLER_26_927 VPWR VGND sg13g2_decap_8
XFILLER_41_919 VPWR VGND sg13g2_fill_2
XFILLER_40_407 VPWR VGND sg13g2_decap_4
X_4916_ net411 VGND VPWR _0377_ red_tmds_par\[3\] net653 sg13g2_dfrbpq_1
X_4847_ net110 VGND VPWR _0308_ videogen.test_lut_thingy.pixel_feeder_inst.v_pix\[5\]
+ net638 sg13g2_dfrbpq_1
XFILLER_20_131 VPWR VGND sg13g2_decap_8
XFILLER_21_632 VPWR VGND sg13g2_decap_4
XFILLER_20_142 VPWR VGND sg13g2_fill_2
XFILLER_21_676 VPWR VGND sg13g2_decap_8
X_4778_ _2144_ _2145_ _0617_ VPWR VGND sg13g2_nor2_1
XFILLER_10_1018 VPWR VGND sg13g2_decap_8
X_3729_ net600 _1441_ _1446_ _1447_ VPWR VGND sg13g2_nor3_1
XFILLER_0_514 VPWR VGND sg13g2_decap_8
XFILLER_48_507 VPWR VGND sg13g2_decap_8
XFILLER_29_721 VPWR VGND sg13g2_decap_8
XFILLER_29_754 VPWR VGND sg13g2_decap_8
XFILLER_16_415 VPWR VGND sg13g2_decap_8
XFILLER_17_949 VPWR VGND sg13g2_decap_8
XFILLER_12_621 VPWR VGND sg13g2_decap_4
XFILLER_25_982 VPWR VGND sg13g2_decap_8
XFILLER_31_418 VPWR VGND sg13g2_fill_1
XFILLER_31_429 VPWR VGND sg13g2_decap_4
XFILLER_8_614 VPWR VGND sg13g2_fill_1
XFILLER_11_142 VPWR VGND sg13g2_decap_8
XFILLER_11_197 VPWR VGND sg13g2_fill_2
XFILLER_4_864 VPWR VGND sg13g2_fill_1
XFILLER_3_374 VPWR VGND sg13g2_decap_8
XFILLER_26_1025 VPWR VGND sg13g2_decap_4
XFILLER_14_6 VPWR VGND sg13g2_fill_1
XFILLER_19_220 VPWR VGND sg13g2_fill_1
XFILLER_47_90 VPWR VGND sg13g2_fill_2
XFILLER_47_584 VPWR VGND sg13g2_decap_4
XFILLER_15_470 VPWR VGND sg13g2_fill_2
XFILLER_16_982 VPWR VGND sg13g2_decap_8
X_2962_ videogen.test_lut_thingy.pixel_feeder_inst.row\[16\]\[2\] net781 _0816_ _0397_
+ VPWR VGND sg13g2_mux2_1
XFILLER_31_930 VPWR VGND sg13g2_fill_1
XFILLER_33_1007 VPWR VGND sg13g2_decap_8
X_4701_ net683 net727 _0165_ VPWR VGND sg13g2_nor2_1
X_2893_ videogen.test_lut_thingy.pixel_feeder_inst.row\[62\]\[0\] net799 _0800_ _0460_
+ VPWR VGND sg13g2_mux2_1
XFILLER_30_473 VPWR VGND sg13g2_fill_1
X_4632_ net707 net751 _0096_ VPWR VGND sg13g2_nor2_1
X_4563_ VPWR VGND _1897_ _1989_ _1923_ _1877_ _0378_ _1922_ sg13g2_a221oi_1
X_4494_ VPWR _0641_ _2161_ VGND sg13g2_inv_1
X_3514_ videogen.test_lut_thingy.pixel_feeder_inst.row\[54\]\[3\] net590 _1232_ VPWR
+ VGND sg13g2_nor2_1
X_3445_ _1148_ VPWR _1163_ VGND _1144_ _1151_ sg13g2_o21ai_1
X_3376_ _1093_ _1092_ _1094_ VPWR VGND sg13g2_xor2_1
X_5115_ net253 VGND VPWR _0572_ videogen.test_lut_thingy.pixel_feeder_inst.row\[43\]\[3\]
+ _0200_ sg13g2_dfrbpq_1
X_5046_ net183 VGND VPWR _0503_ videogen.test_lut_thingy.pixel_feeder_inst.row\[28\]\[2\]
+ _0131_ sg13g2_dfrbpq_1
XFILLER_41_716 VPWR VGND sg13g2_decap_4
XFILLER_25_267 VPWR VGND sg13g2_fill_2
XFILLER_26_779 VPWR VGND sg13g2_fill_2
XFILLER_43_15 VPWR VGND sg13g2_fill_1
X_5195__360 VPWR VGND net360 sg13g2_tiehi
XFILLER_40_226 VPWR VGND sg13g2_decap_8
XFILLER_22_941 VPWR VGND sg13g2_decap_8
XFILLER_21_495 VPWR VGND sg13g2_fill_2
XFILLER_1_834 VPWR VGND sg13g2_decap_8
XFILLER_49_805 VPWR VGND sg13g2_decap_8
XFILLER_0_322 VPWR VGND sg13g2_decap_8
XFILLER_29_540 VPWR VGND sg13g2_fill_1
XFILLER_1_1016 VPWR VGND sg13g2_decap_8
XFILLER_17_713 VPWR VGND sg13g2_decap_4
XFILLER_1_1027 VPWR VGND sg13g2_fill_2
XFILLER_44_576 VPWR VGND sg13g2_decap_8
XFILLER_16_289 VPWR VGND sg13g2_decap_8
XFILLER_32_738 VPWR VGND sg13g2_decap_4
XFILLER_31_248 VPWR VGND sg13g2_fill_2
XFILLER_40_760 VPWR VGND sg13g2_fill_1
X_4996__274 VPWR VGND net274 sg13g2_tiehi
XFILLER_9_923 VPWR VGND sg13g2_decap_8
XFILLER_12_462 VPWR VGND sg13g2_decap_4
XFILLER_13_996 VPWR VGND sg13g2_decap_8
XFILLER_8_466 VPWR VGND sg13g2_decap_4
X_3230_ _0960_ _0961_ _0344_ VPWR VGND sg13g2_nor2_1
X_3161_ VGND VPWR net624 _0914_ _0917_ net620 sg13g2_a21oi_1
X_3092_ net450 net660 _0269_ VPWR VGND sg13g2_and2_1
XFILLER_35_510 VPWR VGND sg13g2_fill_1
X_3994_ _1094_ VPWR _1705_ VGND _1038_ _1696_ sg13g2_o21ai_1
X_2945_ _0755_ _0772_ _0813_ VPWR VGND sg13g2_nor2_2
X_2876_ videogen.test_lut_thingy.pixel_feeder_inst.row\[5\]\[0\] net800 _0796_ _0472_
+ VPWR VGND sg13g2_mux2_1
X_4615_ net705 net748 _0079_ VPWR VGND sg13g2_nor2_1
X_4546_ net707 net750 _0012_ VPWR VGND sg13g2_nor2_1
X_4477_ _2151_ _2066_ _2150_ VPWR VGND sg13g2_xnor2_1
X_3428_ _1114_ VPWR _1146_ VGND _1125_ _1145_ sg13g2_o21ai_1
X_3359_ videogen.fancy_shader.shader_counter_reg\[8\] videogen.fancy_shader.video_y\[8\]
+ _1077_ VPWR VGND sg13g2_xor2_1
X_5029_ net208 VGND VPWR _0486_ videogen.test_lut_thingy.pixel_feeder_inst.row\[58\]\[2\]
+ _0123_ sg13g2_dfrbpq_1
XFILLER_38_392 VPWR VGND sg13g2_decap_8
XFILLER_26_554 VPWR VGND sg13g2_fill_1
XFILLER_14_716 VPWR VGND sg13g2_decap_8
XFILLER_41_557 VPWR VGND sg13g2_decap_4
XFILLER_13_237 VPWR VGND sg13g2_fill_1
XFILLER_16_1024 VPWR VGND sg13g2_decap_4
XFILLER_10_955 VPWR VGND sg13g2_decap_8
XFILLER_6_948 VPWR VGND sg13g2_decap_8
XFILLER_5_425 VPWR VGND sg13g2_decap_4
XFILLER_49_657 VPWR VGND sg13g2_decap_8
XFILLER_0_174 VPWR VGND sg13g2_decap_8
XFILLER_23_1028 VPWR VGND sg13g2_fill_1
XFILLER_17_532 VPWR VGND sg13g2_fill_2
XFILLER_29_392 VPWR VGND sg13g2_decap_8
XFILLER_44_362 VPWR VGND sg13g2_fill_1
XFILLER_32_513 VPWR VGND sg13g2_decap_8
XFILLER_9_720 VPWR VGND sg13g2_decap_8
X_2730_ _0718_ _0722_ net603 _0762_ VPWR VGND _0725_ sg13g2_nand4_1
X_2661_ _0729_ net627 net632 VPWR VGND sg13g2_nand2_1
X_4400_ VGND VPWR _2069_ _2081_ _2080_ _2079_ sg13g2_a21oi_2
X_4331_ _2020_ VPWR _2021_ VGND tmds_green.dc_balancing_reg\[1\] _1991_ sg13g2_o21ai_1
X_4262_ _1966_ _1965_ _1955_ VPWR VGND sg13g2_nand2b_1
XFILLER_39_101 VPWR VGND sg13g2_fill_2
X_3213_ net551 _0950_ _0951_ _0337_ VPWR VGND sg13g2_nor3_1
XFILLER_39_134 VPWR VGND sg13g2_decap_8
X_4193_ _1897_ _1893_ _1899_ VPWR VGND sg13g2_xor2_1
XFILLER_39_156 VPWR VGND sg13g2_decap_4
X_3144_ _0895_ VPWR _0906_ VGND videogen.test_lut_thingy.pixel_feeder_inst.v_pix\[3\]
+ _0904_ sg13g2_o21ai_1
X_3075_ net698 net742 _0005_ VPWR VGND sg13g2_nor2_1
XFILLER_39_1024 VPWR VGND sg13g2_decap_4
XFILLER_23_535 VPWR VGND sg13g2_decap_4
XFILLER_11_719 VPWR VGND sg13g2_decap_8
X_3977_ _1116_ _1683_ _1002_ _1688_ VPWR VGND sg13g2_nand3_1
XFILLER_31_590 VPWR VGND sg13g2_fill_1
X_2928_ videogen.test_lut_thingy.pixel_feeder_inst.row\[31\]\[1\] net788 _0809_ _0433_
+ VPWR VGND sg13g2_mux2_1
X_5153__347 VPWR VGND net347 sg13g2_tiehi
X_2859_ net774 videogen.test_lut_thingy.pixel_feeder_inst.row\[58\]\[2\] _0793_ _0486_
+ VPWR VGND sg13g2_mux2_1
X_4529_ _2179_ net660 net456 net665 red_tmds_par\[4\] VPWR VGND sg13g2_a22oi_1
XFILLER_49_14 VPWR VGND sg13g2_decap_8
XFILLER_46_1028 VPWR VGND sg13g2_fill_1
XFILLER_46_1017 VPWR VGND sg13g2_decap_8
Xfanout710 net711 net710 VPWR VGND sg13g2_buf_8
Xfanout721 net723 net721 VPWR VGND sg13g2_buf_8
Xfanout732 net735 net732 VPWR VGND sg13g2_buf_8
Xfanout754 net755 net754 VPWR VGND sg13g2_buf_8
Xfanout743 net744 net743 VPWR VGND sg13g2_buf_8
Xfanout765 net766 net765 VPWR VGND sg13g2_buf_8
Xfanout776 net783 net776 VPWR VGND sg13g2_buf_8
X_5160__307 VPWR VGND net307 sg13g2_tiehi
Xfanout798 net805 net798 VPWR VGND sg13g2_buf_8
Xfanout787 net788 net787 VPWR VGND sg13g2_buf_8
XFILLER_46_638 VPWR VGND sg13g2_decap_8
XFILLER_45_159 VPWR VGND sg13g2_fill_1
XFILLER_14_502 VPWR VGND sg13g2_fill_1
XFILLER_42_844 VPWR VGND sg13g2_fill_1
XFILLER_26_395 VPWR VGND sg13g2_decap_4
XFILLER_41_398 VPWR VGND sg13g2_fill_1
XFILLER_6_701 VPWR VGND sg13g2_decap_8
XFILLER_6_756 VPWR VGND sg13g2_fill_2
XFILLER_2_984 VPWR VGND sg13g2_decap_8
XFILLER_49_432 VPWR VGND sg13g2_decap_8
XFILLER_7_1011 VPWR VGND sg13g2_decap_8
XFILLER_1_483 VPWR VGND sg13g2_decap_8
XFILLER_39_80 VPWR VGND sg13g2_decap_4
XFILLER_37_605 VPWR VGND sg13g2_fill_1
XFILLER_36_104 VPWR VGND sg13g2_fill_2
XFILLER_36_137 VPWR VGND sg13g2_fill_2
XFILLER_18_896 VPWR VGND sg13g2_fill_1
X_5059__101 VPWR VGND net101 sg13g2_tiehi
X_3900_ VGND VPWR _1613_ _1614_ _1612_ _1608_ sg13g2_a21oi_2
X_4880_ net44 VGND VPWR _0341_ tmds_green.dc_balancing_reg\[0\] net650 sg13g2_dfrbpq_1
X_3831_ net624 VPWR _1548_ VGND videogen.test_lut_thingy.pixel_feeder_inst.row\[21\]\[0\]
+ net561 sg13g2_o21ai_1
XFILLER_20_527 VPWR VGND sg13g2_decap_4
XFILLER_32_387 VPWR VGND sg13g2_decap_4
X_3762_ videogen.test_lut_thingy.pixel_feeder_inst.row\[17\]\[1\] net562 _1480_ VPWR
+ VGND sg13g2_nor2_1
XFILLER_9_594 VPWR VGND sg13g2_fill_1
X_2713_ _0730_ _0755_ _0757_ VPWR VGND sg13g2_nor2_2
X_3693_ videogen.test_lut_thingy.pixel_feeder_inst.row\[43\]\[2\] net567 _1411_ VPWR
+ VGND sg13g2_nor2_1
X_2644_ net617 net622 net576 _0716_ VPWR VGND sg13g2_nor3_1
X_4314_ green\[7\] green\[6\] net605 _2004_ VPWR VGND sg13g2_nand3_1
X_4245_ VGND VPWR _1923_ _1937_ _1950_ _1949_ sg13g2_a21oi_1
X_4176_ VGND VPWR red\[4\] _1876_ _1882_ _1875_ sg13g2_a21oi_1
X_3127_ _0696_ _0851_ _0695_ _0893_ VPWR VGND _0892_ sg13g2_nand4_1
XFILLER_27_104 VPWR VGND sg13g2_decap_8
XFILLER_27_137 VPWR VGND sg13g2_fill_1
X_3058_ _0862_ videogen.test_lut_thingy.pixel_feeder_inst.v_pix\[2\] videogen.test_lut_thingy.pixel_feeder_inst.v_pix\[1\]
+ _0858_ VPWR VGND sg13g2_and3_2
XFILLER_24_811 VPWR VGND sg13g2_decap_8
XFILLER_23_354 VPWR VGND sg13g2_fill_2
XFILLER_23_387 VPWR VGND sg13g2_decap_8
Xfanout551 _0940_ net551 VPWR VGND sg13g2_buf_8
XFILLER_47_914 VPWR VGND sg13g2_decap_8
X_5125__213 VPWR VGND net213 sg13g2_tiehi
XFILLER_19_605 VPWR VGND sg13g2_fill_1
Xfanout584 _0714_ net584 VPWR VGND sg13g2_buf_8
Xfanout562 net564 net562 VPWR VGND sg13g2_buf_8
Xfanout573 net574 net573 VPWR VGND sg13g2_buf_8
Xfanout595 _0682_ net595 VPWR VGND sg13g2_buf_8
XFILLER_33_118 VPWR VGND sg13g2_decap_8
XFILLER_34_619 VPWR VGND sg13g2_fill_2
X_4925__396 VPWR VGND net396 sg13g2_tiehi
XFILLER_26_170 VPWR VGND sg13g2_decap_8
XFILLER_42_674 VPWR VGND sg13g2_fill_1
XFILLER_6_575 VPWR VGND sg13g2_decap_8
XFILLER_29_1001 VPWR VGND sg13g2_decap_8
XFILLER_2_781 VPWR VGND sg13g2_decap_8
XFILLER_38_903 VPWR VGND sg13g2_decap_8
X_4030_ VPWR _1741_ _1740_ VGND sg13g2_inv_1
XFILLER_49_284 VPWR VGND sg13g2_decap_8
XFILLER_37_424 VPWR VGND sg13g2_decap_4
XFILLER_2_97 VPWR VGND sg13g2_decap_8
X_4932_ net385 VGND VPWR _0393_ videogen.test_lut_thingy.pixel_feeder_inst.row\[17\]\[2\]
+ _0039_ sg13g2_dfrbpq_1
XFILLER_33_663 VPWR VGND sg13g2_decap_4
XFILLER_33_674 VPWR VGND sg13g2_decap_8
X_4822__147 VPWR VGND net147 sg13g2_tiehi
X_4863_ net78 VGND VPWR _0324_ videogen.test_lut_thingy.pixel_feeder_inst.row\[37\]\[1\]
+ _0022_ sg13g2_dfrbpq_1
X_4794_ net697 net741 _0256_ VPWR VGND sg13g2_nor2_1
X_3814_ VGND VPWR _1531_ net566 videogen.test_lut_thingy.pixel_feeder_inst.row\[55\]\[0\]
+ sg13g2_or2_1
X_3745_ videogen.test_lut_thingy.pixel_feeder_inst.row\[57\]\[1\] net557 _1463_ VPWR
+ VGND sg13g2_nor2_1
XFILLER_9_380 VPWR VGND sg13g2_fill_2
X_3676_ videogen.test_lut_thingy.pixel_feeder_inst.row\[60\]\[2\] net580 _1394_ VPWR
+ VGND sg13g2_nor2_1
X_2627_ VPWR _0699_ _0698_ VGND sg13g2_inv_1
XFILLER_0_707 VPWR VGND sg13g2_decap_8
X_4228_ _1931_ _1903_ _1933_ VPWR VGND sg13g2_xor2_1
XFILLER_46_15 VPWR VGND sg13g2_decap_8
X_4159_ _1867_ VPWR _1870_ VGND _1577_ _1868_ sg13g2_o21ai_1
XFILLER_36_490 VPWR VGND sg13g2_fill_1
XFILLER_12_814 VPWR VGND sg13g2_decap_8
XFILLER_24_696 VPWR VGND sg13g2_fill_1
XFILLER_12_858 VPWR VGND sg13g2_decap_8
XFILLER_3_534 VPWR VGND sg13g2_fill_2
XFILLER_11_73 VPWR VGND sg13g2_fill_2
XFILLER_3_556 VPWR VGND sg13g2_decap_4
XFILLER_19_413 VPWR VGND sg13g2_fill_2
X_4845__114 VPWR VGND net114 sg13g2_tiehi
XFILLER_35_917 VPWR VGND sg13g2_decap_8
XFILLER_34_427 VPWR VGND sg13g2_fill_1
XFILLER_15_652 VPWR VGND sg13g2_decap_8
X_3530_ videogen.test_lut_thingy.pixel_feeder_inst.row\[58\]\[3\] net585 _1248_ VPWR
+ VGND sg13g2_nor2_1
X_3461_ VGND VPWR _1177_ _1178_ _1179_ net546 sg13g2_a21oi_1
X_5200_ net271 VGND VPWR _0657_ serialize.shift_reg_r\[2\] clknet_3_5__leaf_clk_regs
+ sg13g2_dfrbpq_1
X_3392_ _1108_ _1107_ _1109_ _1110_ VPWR VGND sg13g2_a21o_2
X_5131_ net160 VGND VPWR _0588_ videogen.test_lut_thingy.pixel_feeder_inst.row\[3\]\[3\]
+ _0216_ sg13g2_dfrbpq_1
XFILLER_35_2 VPWR VGND sg13g2_fill_1
X_5062_ net89 VGND VPWR _0519_ videogen.test_lut_thingy.pixel_feeder_inst.row\[55\]\[2\]
+ _0147_ sg13g2_dfrbpq_1
XFILLER_38_700 VPWR VGND sg13g2_fill_1
X_4013_ VGND VPWR _1721_ _1723_ _1724_ _1720_ sg13g2_a21oi_1
XFILLER_16_18 VPWR VGND sg13g2_fill_1
XFILLER_19_991 VPWR VGND sg13g2_decap_8
X_4915_ net412 VGND VPWR _0376_ red_tmds_par\[1\] net652 sg13g2_dfrbpq_1
X_4846_ net112 VGND VPWR _0307_ videogen.test_lut_thingy.pixel_feeder_inst.v_pix\[4\]
+ net638 sg13g2_dfrbpq_1
X_4777_ _2144_ _2145_ _0616_ VPWR VGND sg13g2_nor2_1
X_3728_ _1442_ _1443_ _1444_ _1445_ _1446_ VPWR VGND sg13g2_nor4_1
X_3659_ videogen.test_lut_thingy.pixel_feeder_inst.row\[57\]\[2\] net557 _1377_ VPWR
+ VGND sg13g2_nor2_1
XFILLER_17_928 VPWR VGND sg13g2_decap_8
XFILLER_25_961 VPWR VGND sg13g2_decap_8
XFILLER_31_408 VPWR VGND sg13g2_decap_4
XFILLER_7_114 VPWR VGND sg13g2_fill_2
XFILLER_22_83 VPWR VGND sg13g2_decap_8
XFILLER_4_887 VPWR VGND sg13g2_fill_2
XFILLER_3_353 VPWR VGND sg13g2_decap_8
XFILLER_26_1004 VPWR VGND sg13g2_decap_8
XFILLER_19_232 VPWR VGND sg13g2_decap_8
XFILLER_47_552 VPWR VGND sg13g2_decap_8
XFILLER_34_224 VPWR VGND sg13g2_fill_1
XFILLER_16_961 VPWR VGND sg13g2_decap_8
XFILLER_23_909 VPWR VGND sg13g2_decap_8
X_2961_ videogen.test_lut_thingy.pixel_feeder_inst.row\[16\]\[3\] net770 _0816_ _0398_
+ VPWR VGND sg13g2_mux2_1
X_4700_ net682 net726 _0164_ VPWR VGND sg13g2_nor2_1
X_2892_ _0801_ VPWR _0461_ VGND _0673_ _0800_ sg13g2_o21ai_1
X_4631_ net707 net751 _0095_ VPWR VGND sg13g2_nor2_1
XFILLER_31_986 VPWR VGND sg13g2_decap_8
X_4938__373 VPWR VGND net373 sg13g2_tiehi
XFILLER_8_63 VPWR VGND sg13g2_decap_8
X_4562_ net687 net731 _0028_ VPWR VGND sg13g2_nor2_1
X_4493_ _2161_ net658 net479 net665 blue_tmds_par\[2\] VPWR VGND sg13g2_a22oi_1
XFILLER_6_180 VPWR VGND sg13g2_decap_8
X_3513_ net601 VPWR _1231_ VGND videogen.test_lut_thingy.pixel_feeder_inst.row\[53\]\[3\]
+ net561 sg13g2_o21ai_1
XFILLER_6_191 VPWR VGND sg13g2_fill_1
X_3444_ _1162_ _1158_ _1160_ VPWR VGND sg13g2_nand2_1
XFILLER_40_0 VPWR VGND sg13g2_decap_4
X_3375_ _1093_ _1076_ _1077_ VPWR VGND sg13g2_xnor2_1
X_5114_ net257 VGND VPWR _0571_ videogen.test_lut_thingy.pixel_feeder_inst.row\[43\]\[2\]
+ _0199_ sg13g2_dfrbpq_1
X_5045_ net185 VGND VPWR _0502_ videogen.test_lut_thingy.pixel_feeder_inst.row\[28\]\[1\]
+ _0130_ sg13g2_dfrbpq_1
XFILLER_38_541 VPWR VGND sg13g2_decap_8
XFILLER_26_747 VPWR VGND sg13g2_decap_4
XFILLER_25_246 VPWR VGND sg13g2_fill_2
XFILLER_25_257 VPWR VGND sg13g2_decap_4
XFILLER_41_728 VPWR VGND sg13g2_fill_1
XFILLER_13_419 VPWR VGND sg13g2_decap_8
XFILLER_22_920 VPWR VGND sg13g2_decap_8
X_5156__323 VPWR VGND net323 sg13g2_tiehi
XFILLER_22_997 VPWR VGND sg13g2_decap_8
X_4829_ net135 VGND VPWR _0290_ videogen.test_lut_thingy.pixel_feeder_inst.row\[18\]\[2\]
+ _0019_ sg13g2_dfrbpq_1
XFILLER_4_106 VPWR VGND sg13g2_decap_8
XFILLER_49_1015 VPWR VGND sg13g2_decap_8
XFILLER_1_813 VPWR VGND sg13g2_decap_8
XFILLER_48_327 VPWR VGND sg13g2_fill_1
XFILLER_17_736 VPWR VGND sg13g2_decap_8
XFILLER_32_706 VPWR VGND sg13g2_fill_2
XFILLER_32_717 VPWR VGND sg13g2_decap_8
XFILLER_13_975 VPWR VGND sg13g2_decap_8
XFILLER_9_979 VPWR VGND sg13g2_decap_8
XFILLER_12_485 VPWR VGND sg13g2_decap_8
XFILLER_4_673 VPWR VGND sg13g2_decap_8
XFILLER_3_150 VPWR VGND sg13g2_decap_4
X_3160_ VGND VPWR net624 _0914_ _0311_ _0916_ sg13g2_a21oi_1
XFILLER_12_4 VPWR VGND sg13g2_decap_8
Xhold1 clockdiv.q2 VPWR VGND net447 sg13g2_dlygate4sd3_1
X_3091_ VGND VPWR net484 _0873_ _0874_ net760 sg13g2_a21oi_1
XFILLER_48_894 VPWR VGND sg13g2_decap_8
XFILLER_35_566 VPWR VGND sg13g2_decap_8
XFILLER_22_216 VPWR VGND sg13g2_fill_2
X_3993_ _1095_ _1695_ _1704_ VPWR VGND _1038_ sg13g2_nand3b_1
XFILLER_22_227 VPWR VGND sg13g2_decap_8
X_5001__264 VPWR VGND net264 sg13g2_tiehi
X_2944_ videogen.test_lut_thingy.pixel_feeder_inst.row\[33\]\[0\] net796 _0812_ _0420_
+ VPWR VGND sg13g2_mux2_1
X_2875_ videogen.test_lut_thingy.pixel_feeder_inst.row\[5\]\[1\] net793 _0796_ _0473_
+ VPWR VGND sg13g2_mux2_1
XFILLER_30_271 VPWR VGND sg13g2_fill_2
X_4614_ net703 net747 _0078_ VPWR VGND sg13g2_nor2_1
X_4545_ net708 net752 _0011_ VPWR VGND sg13g2_nor2_1
X_4476_ _2150_ blue\[6\] _2068_ VPWR VGND sg13g2_xnor2_1
X_3427_ VPWR VGND _1133_ _1127_ _1124_ _1013_ _1145_ _1014_ sg13g2_a221oi_1
X_3358_ _1075_ VPWR _1076_ VGND _1054_ _1074_ sg13g2_o21ai_1
X_3289_ videogen.fancy_shader.shader_counter_reg\[1\] videogen.fancy_shader.video_x\[1\]
+ _1007_ VPWR VGND sg13g2_xor2_1
X_5028_ net210 VGND VPWR _0485_ videogen.test_lut_thingy.pixel_feeder_inst.row\[58\]\[1\]
+ _0122_ sg13g2_dfrbpq_1
XFILLER_16_1003 VPWR VGND sg13g2_decap_8
XFILLER_10_934 VPWR VGND sg13g2_decap_8
XFILLER_21_282 VPWR VGND sg13g2_fill_2
XFILLER_22_794 VPWR VGND sg13g2_decap_8
XFILLER_6_927 VPWR VGND sg13g2_decap_8
XFILLER_5_415 VPWR VGND sg13g2_fill_2
XFILLER_49_614 VPWR VGND sg13g2_decap_4
XFILLER_0_153 VPWR VGND sg13g2_decap_8
XFILLER_49_636 VPWR VGND sg13g2_decap_8
XFILLER_23_1007 VPWR VGND sg13g2_decap_8
XFILLER_17_500 VPWR VGND sg13g2_decap_8
X_5098__321 VPWR VGND net321 sg13g2_tiehi
XFILLER_32_558 VPWR VGND sg13g2_decap_8
XFILLER_44_92 VPWR VGND sg13g2_fill_2
XFILLER_40_591 VPWR VGND sg13g2_decap_4
XFILLER_8_264 VPWR VGND sg13g2_fill_2
XFILLER_12_293 VPWR VGND sg13g2_decap_8
X_2660_ videogen.test_lut_thingy.pixel_feeder_inst.row\[21\]\[0\] net799 _0728_ _0664_
+ VPWR VGND sg13g2_mux2_1
X_4330_ _2020_ net605 green\[7\] VPWR VGND sg13g2_nand2b_1
XFILLER_5_86 VPWR VGND sg13g2_fill_1
X_4261_ _1912_ tmds_red.dc_balancing_reg\[2\] _1956_ _1965_ VPWR VGND sg13g2_a21o_1
X_3212_ videogen.fancy_shader.shader_counter_reg\[6\] _0949_ _0951_ VPWR VGND sg13g2_and2_1
X_4192_ _1892_ _1888_ _1898_ VPWR VGND _1897_ sg13g2_nand3b_1
X_3143_ _0904_ _0905_ _0305_ VPWR VGND sg13g2_nor2_1
XFILLER_48_680 VPWR VGND sg13g2_fill_1
X_3074_ serialize.shift_reg_r\[1\] serialize.shift_reg_r\[0\] clknet_1_1__leaf_clk
+ net6 VPWR VGND sg13g2_mux2_1
XFILLER_39_1003 VPWR VGND sg13g2_decap_8
XFILLER_36_853 VPWR VGND sg13g2_fill_1
XFILLER_36_875 VPWR VGND sg13g2_fill_1
XFILLER_23_547 VPWR VGND sg13g2_decap_8
X_3976_ _1687_ _1117_ _1686_ VPWR VGND sg13g2_xnor2_1
X_2927_ videogen.test_lut_thingy.pixel_feeder_inst.row\[31\]\[2\] net777 _0809_ _0434_
+ VPWR VGND sg13g2_mux2_1
X_2858_ net762 videogen.test_lut_thingy.pixel_feeder_inst.row\[58\]\[3\] _0793_ _0487_
+ VPWR VGND sg13g2_mux2_1
X_2789_ videogen.test_lut_thingy.pixel_feeder_inst.row\[39\]\[2\] net773 _0779_ _0551_
+ VPWR VGND sg13g2_mux2_1
X_5139__83 VPWR VGND net83 sg13g2_tiehi
X_4528_ VPWR _0658_ _2178_ VGND sg13g2_inv_1
XFILLER_2_429 VPWR VGND sg13g2_decap_8
X_4459_ VGND VPWR _2127_ _2130_ _2138_ _2137_ sg13g2_a21oi_1
Xfanout700 clockdiv.q2temp net700 VPWR VGND sg13g2_buf_8
Xfanout733 net735 net733 VPWR VGND sg13g2_buf_8
Xfanout722 net723 net722 VPWR VGND sg13g2_buf_1
Xfanout711 clockdiv.q2temp net711 VPWR VGND sg13g2_buf_8
Xfanout755 net756 net755 VPWR VGND sg13g2_buf_8
Xfanout766 ui_in[7] net766 VPWR VGND sg13g2_buf_8
Xfanout744 clockdiv.q1 net744 VPWR VGND sg13g2_buf_8
Xfanout788 ui_in[5] net788 VPWR VGND sg13g2_buf_8
Xfanout799 net804 net799 VPWR VGND sg13g2_buf_8
Xfanout777 net783 net777 VPWR VGND sg13g2_buf_1
XFILLER_39_691 VPWR VGND sg13g2_fill_1
XFILLER_27_897 VPWR VGND sg13g2_decap_8
XFILLER_41_322 VPWR VGND sg13g2_fill_2
XFILLER_41_300 VPWR VGND sg13g2_decap_4
XFILLER_14_536 VPWR VGND sg13g2_fill_2
XFILLER_10_764 VPWR VGND sg13g2_decap_8
XFILLER_6_779 VPWR VGND sg13g2_fill_1
XFILLER_30_83 VPWR VGND sg13g2_decap_8
XFILLER_30_94 VPWR VGND sg13g2_fill_2
XFILLER_2_963 VPWR VGND sg13g2_decap_8
XFILLER_1_462 VPWR VGND sg13g2_decap_8
XFILLER_49_411 VPWR VGND sg13g2_decap_8
X_4965__336 VPWR VGND net336 sg13g2_tiehi
XFILLER_49_488 VPWR VGND sg13g2_decap_8
XFILLER_37_639 VPWR VGND sg13g2_decap_8
XFILLER_18_886 VPWR VGND sg13g2_decap_4
XFILLER_33_812 VPWR VGND sg13g2_fill_2
XFILLER_32_300 VPWR VGND sg13g2_decap_8
X_3830_ _1544_ _1546_ _1547_ VPWR VGND sg13g2_nor2_2
XFILLER_13_580 VPWR VGND sg13g2_decap_8
X_3761_ videogen.test_lut_thingy.pixel_feeder_inst.row\[18\]\[1\] net591 _1479_ VPWR
+ VGND sg13g2_nor2_1
X_2712_ VGND VPWR _0756_ _0730_ net594 sg13g2_or2_1
X_3692_ videogen.test_lut_thingy.pixel_feeder_inst.row\[40\]\[2\] net577 _1410_ VPWR
+ VGND sg13g2_nor2_1
X_2643_ net622 net575 _0715_ VPWR VGND sg13g2_nor2_2
X_4313_ net605 green\[7\] green\[6\] _2003_ VPWR VGND sg13g2_nor3_1
X_4244_ _1948_ VPWR _1949_ VGND _1943_ _1945_ sg13g2_o21ai_1
X_4175_ _1881_ red\[6\] _1876_ VPWR VGND sg13g2_xnor2_1
X_3126_ _0676_ videogen.fancy_shader.video_y\[2\] _0892_ VPWR VGND sg13g2_nor2_1
X_3057_ VGND VPWR _0855_ _0861_ net17 _0857_ sg13g2_a21oi_1
X_3959_ VPWR VGND _1664_ net1 _1580_ _1326_ _1671_ _1521_ sg13g2_a221oi_1
XFILLER_13_1017 VPWR VGND sg13g2_decap_8
XFILLER_13_1028 VPWR VGND sg13g2_fill_1
XFILLER_2_204 VPWR VGND sg13g2_decap_8
XFILLER_2_215 VPWR VGND sg13g2_fill_1
XFILLER_2_237 VPWR VGND sg13g2_decap_4
Xfanout552 _0827_ net552 VPWR VGND sg13g2_buf_8
Xfanout563 net564 net563 VPWR VGND sg13g2_buf_8
Xfanout574 _0729_ net574 VPWR VGND sg13g2_buf_8
Xfanout596 net599 net596 VPWR VGND sg13g2_buf_8
Xfanout585 net589 net585 VPWR VGND sg13g2_buf_8
XFILLER_18_105 VPWR VGND sg13g2_fill_1
XFILLER_46_447 VPWR VGND sg13g2_decap_4
XFILLER_18_127 VPWR VGND sg13g2_fill_1
XFILLER_18_138 VPWR VGND sg13g2_decap_8
XFILLER_14_322 VPWR VGND sg13g2_fill_2
XFILLER_15_823 VPWR VGND sg13g2_fill_2
XFILLER_15_845 VPWR VGND sg13g2_decap_8
XFILLER_27_683 VPWR VGND sg13g2_decap_8
XFILLER_42_653 VPWR VGND sg13g2_fill_1
XFILLER_14_355 VPWR VGND sg13g2_decap_4
XFILLER_15_889 VPWR VGND sg13g2_decap_4
XFILLER_30_804 VPWR VGND sg13g2_fill_1
XFILLER_41_174 VPWR VGND sg13g2_fill_1
XFILLER_14_366 VPWR VGND sg13g2_fill_2
X_5063__85 VPWR VGND net85 sg13g2_tiehi
XFILLER_41_196 VPWR VGND sg13g2_decap_4
XFILLER_41_82 VPWR VGND sg13g2_decap_4
XFILLER_6_598 VPWR VGND sg13g2_decap_8
XFILLER_2_760 VPWR VGND sg13g2_decap_8
XFILLER_2_32 VPWR VGND sg13g2_decap_8
XFILLER_18_661 VPWR VGND sg13g2_decap_4
XFILLER_24_119 VPWR VGND sg13g2_fill_1
X_4931_ net387 VGND VPWR _0392_ videogen.test_lut_thingy.pixel_feeder_inst.row\[17\]\[1\]
+ _0038_ sg13g2_dfrbpq_1
X_4862_ net80 VGND VPWR _0323_ videogen.test_lut_thingy.pixel_feeder_inst.row\[37\]\[0\]
+ _0021_ sg13g2_dfrbpq_1
XFILLER_36_1017 VPWR VGND sg13g2_decap_8
X_3813_ videogen.test_lut_thingy.pixel_feeder_inst.row\[23\]\[0\] net570 _1530_ VPWR
+ VGND sg13g2_nor2_1
XFILLER_20_314 VPWR VGND sg13g2_decap_8
XFILLER_21_826 VPWR VGND sg13g2_decap_8
XFILLER_36_1028 VPWR VGND sg13g2_fill_1
X_4793_ net697 net741 _0255_ VPWR VGND sg13g2_nor2_1
XFILLER_20_336 VPWR VGND sg13g2_decap_4
X_3744_ videogen.test_lut_thingy.pixel_feeder_inst.row\[56\]\[1\] net576 _1462_ VPWR
+ VGND sg13g2_nor2_1
X_3675_ videogen.test_lut_thingy.pixel_feeder_inst.row\[61\]\[2\] net564 _1393_ VPWR
+ VGND sg13g2_nor2_1
X_2626_ _0695_ _0697_ _0698_ VPWR VGND sg13g2_and2_1
X_4227_ _1903_ _1931_ _1932_ VPWR VGND sg13g2_and2_1
X_4158_ VPWR _1869_ _1868_ VGND sg13g2_inv_1
XFILLER_28_436 VPWR VGND sg13g2_decap_8
XFILLER_29_959 VPWR VGND sg13g2_decap_8
X_3109_ net757 _0833_ _0882_ _0294_ VPWR VGND sg13g2_nor3_1
X_4089_ _1800_ _1597_ _1695_ VPWR VGND sg13g2_xnor2_1
XFILLER_24_653 VPWR VGND sg13g2_fill_1
XFILLER_23_152 VPWR VGND sg13g2_decap_4
XFILLER_11_325 VPWR VGND sg13g2_decap_4
XFILLER_11_358 VPWR VGND sg13g2_fill_2
XFILLER_20_870 VPWR VGND sg13g2_fill_1
XFILLER_11_41 VPWR VGND sg13g2_decap_4
XFILLER_43_984 VPWR VGND sg13g2_decap_8
XFILLER_42_450 VPWR VGND sg13g2_fill_1
XFILLER_11_892 VPWR VGND sg13g2_decap_4
X_3460_ _1082_ VPWR _1178_ VGND net548 _1095_ sg13g2_o21ai_1
XFILLER_42_4 VPWR VGND sg13g2_fill_2
X_3391_ _1109_ net547 _1091_ _1095_ VPWR VGND sg13g2_and3_1
X_5130_ net184 VGND VPWR _0587_ videogen.test_lut_thingy.pixel_feeder_inst.row\[3\]\[2\]
+ _0215_ sg13g2_dfrbpq_1
X_5061_ net93 VGND VPWR _0518_ videogen.test_lut_thingy.pixel_feeder_inst.row\[55\]\[1\]
+ _0146_ sg13g2_dfrbpq_1
X_4012_ _1714_ _1722_ _1713_ _1723_ VPWR VGND sg13g2_nand3_1
XFILLER_37_200 VPWR VGND sg13g2_decap_4
XFILLER_37_266 VPWR VGND sg13g2_fill_1
XFILLER_19_970 VPWR VGND sg13g2_decap_8
X_4914_ net413 VGND VPWR _0375_ red_tmds_par\[0\] net652 sg13g2_dfrbpq_1
XFILLER_33_472 VPWR VGND sg13g2_fill_1
XFILLER_34_984 VPWR VGND sg13g2_decap_8
X_4845_ net114 VGND VPWR _0306_ videogen.test_lut_thingy.pixel_feeder_inst.v_pix\[3\]
+ net638 sg13g2_dfrbpq_2
XFILLER_32_29 VPWR VGND sg13g2_decap_8
X_4776_ net675 net719 _0240_ VPWR VGND sg13g2_nor2_1
X_3727_ videogen.test_lut_thingy.pixel_feeder_inst.row\[42\]\[1\] net585 _1445_ VPWR
+ VGND sg13g2_nor2_1
X_3658_ videogen.test_lut_thingy.pixel_feeder_inst.row\[59\]\[2\] net566 _1376_ VPWR
+ VGND sg13g2_nor2_1
X_3589_ videogen.test_lut_thingy.pixel_feeder_inst.row\[14\]\[3\] net591 _1307_ VPWR
+ VGND sg13g2_nor2_1
X_2609_ VPWR _0682_ net603 VGND sg13g2_inv_1
X_5011__244 VPWR VGND net244 sg13g2_tiehi
XFILLER_0_549 VPWR VGND sg13g2_decap_8
XFILLER_28_288 VPWR VGND sg13g2_fill_2
XFILLER_25_940 VPWR VGND sg13g2_decap_8
XFILLER_19_1012 VPWR VGND sg13g2_decap_8
XFILLER_19_1023 VPWR VGND sg13g2_fill_2
XFILLER_24_472 VPWR VGND sg13g2_decap_4
XFILLER_40_932 VPWR VGND sg13g2_fill_1
XFILLER_40_998 VPWR VGND sg13g2_decap_8
XFILLER_12_678 VPWR VGND sg13g2_fill_2
XFILLER_3_310 VPWR VGND sg13g2_fill_2
XFILLER_0_0 VPWR VGND sg13g2_decap_8
XFILLER_47_531 VPWR VGND sg13g2_decap_8
XFILLER_35_748 VPWR VGND sg13g2_decap_8
XFILLER_16_940 VPWR VGND sg13g2_decap_8
XFILLER_15_472 VPWR VGND sg13g2_fill_1
X_2960_ _0727_ _0739_ _0816_ VPWR VGND sg13g2_nor2_2
XFILLER_34_269 VPWR VGND sg13g2_decap_8
X_2891_ _0801_ net789 _0800_ VPWR VGND sg13g2_nand2_1
XFILLER_31_943 VPWR VGND sg13g2_fill_1
X_4630_ net707 net751 _0094_ VPWR VGND sg13g2_nor2_1
XFILLER_30_442 VPWR VGND sg13g2_decap_4
X_4561_ net688 net732 _0027_ VPWR VGND sg13g2_nor2_1
X_4492_ VPWR _0640_ _2160_ VGND sg13g2_inv_1
X_3512_ net1 VPWR _1230_ VGND _1174_ _1229_ sg13g2_o21ai_1
X_3443_ VPWR _1161_ _1160_ VGND sg13g2_inv_1
X_3374_ _1092_ _1067_ _1068_ VPWR VGND sg13g2_xnor2_1
X_5113_ net261 VGND VPWR _0570_ videogen.test_lut_thingy.pixel_feeder_inst.row\[43\]\[1\]
+ _0198_ sg13g2_dfrbpq_1
XFILLER_33_0 VPWR VGND sg13g2_decap_8
X_5044_ net187 VGND VPWR _0501_ videogen.test_lut_thingy.pixel_feeder_inst.row\[28\]\[0\]
+ _0129_ sg13g2_dfrbpq_1
XFILLER_21_431 VPWR VGND sg13g2_fill_2
XFILLER_22_976 VPWR VGND sg13g2_decap_8
X_4828_ net137 VGND VPWR _0289_ videogen.test_lut_thingy.pixel_feeder_inst.row\[18\]\[1\]
+ _0018_ sg13g2_dfrbpq_1
X_4759_ net699 net743 _0223_ VPWR VGND sg13g2_nor2_1
XFILLER_1_869 VPWR VGND sg13g2_decap_8
XFILLER_0_357 VPWR VGND sg13g2_decap_8
XFILLER_16_214 VPWR VGND sg13g2_decap_8
XFILLER_29_575 VPWR VGND sg13g2_decap_8
XFILLER_44_556 VPWR VGND sg13g2_decap_8
XFILLER_16_247 VPWR VGND sg13g2_fill_2
XFILLER_17_759 VPWR VGND sg13g2_fill_2
XFILLER_13_954 VPWR VGND sg13g2_decap_8
XFILLER_40_751 VPWR VGND sg13g2_decap_8
XFILLER_8_413 VPWR VGND sg13g2_fill_1
XFILLER_12_442 VPWR VGND sg13g2_decap_4
XFILLER_9_958 VPWR VGND sg13g2_decap_8
XFILLER_33_94 VPWR VGND sg13g2_decap_8
XFILLER_4_663 VPWR VGND sg13g2_fill_2
XFILLER_3_195 VPWR VGND sg13g2_decap_4
X_3090_ serialize.tmds_parallel_b\[9\] net664 _0268_ VPWR VGND sg13g2_and2_1
Xhold2 _0663_ VPWR VGND net448 sg13g2_dlygate4sd3_1
XFILLER_48_873 VPWR VGND sg13g2_decap_8
XFILLER_35_545 VPWR VGND sg13g2_decap_8
XFILLER_35_556 VPWR VGND sg13g2_fill_1
X_3992_ _1701_ net546 _1703_ VPWR VGND sg13g2_xor2_1
X_4899__428 VPWR VGND net428 sg13g2_tiehi
XFILLER_16_781 VPWR VGND sg13g2_fill_1
X_2943_ videogen.test_lut_thingy.pixel_feeder_inst.row\[33\]\[1\] net787 _0812_ _0421_
+ VPWR VGND sg13g2_mux2_1
X_4975__316 VPWR VGND net316 sg13g2_tiehi
XFILLER_15_291 VPWR VGND sg13g2_decap_8
XFILLER_30_261 VPWR VGND sg13g2_decap_4
X_2874_ videogen.test_lut_thingy.pixel_feeder_inst.row\[5\]\[2\] net780 _0796_ _0474_
+ VPWR VGND sg13g2_mux2_1
X_4613_ net703 net747 _0077_ VPWR VGND sg13g2_nor2_1
X_4544_ net701 net745 _0010_ VPWR VGND sg13g2_nor2_1
X_4475_ VGND VPWR net609 _2149_ _0618_ _2146_ sg13g2_a21oi_1
X_3426_ _1127_ _1134_ _1135_ _1142_ _1144_ VPWR VGND sg13g2_nor4_1
X_3357_ VPWR VGND _1073_ _1039_ _1049_ _1040_ _1075_ _1042_ sg13g2_a221oi_1
XFILLER_45_309 VPWR VGND sg13g2_fill_1
XFILLER_39_840 VPWR VGND sg13g2_decap_8
X_5027_ net212 VGND VPWR _0484_ videogen.test_lut_thingy.pixel_feeder_inst.row\[58\]\[0\]
+ _0121_ sg13g2_dfrbpq_1
X_3288_ videogen.fancy_shader.video_x\[1\] videogen.fancy_shader.shader_counter_reg\[1\]
+ _1006_ VPWR VGND sg13g2_nor2_1
XFILLER_39_895 VPWR VGND sg13g2_fill_2
XFILLER_26_545 VPWR VGND sg13g2_fill_1
XFILLER_26_567 VPWR VGND sg13g2_fill_1
XFILLER_21_272 VPWR VGND sg13g2_fill_2
XFILLER_22_773 VPWR VGND sg13g2_decap_8
XFILLER_6_906 VPWR VGND sg13g2_decap_8
XFILLER_5_449 VPWR VGND sg13g2_decap_8
XFILLER_45_821 VPWR VGND sg13g2_decap_8
XFILLER_29_361 VPWR VGND sg13g2_decap_4
XFILLER_28_94 VPWR VGND sg13g2_decap_4
XFILLER_44_342 VPWR VGND sg13g2_fill_2
XFILLER_44_60 VPWR VGND sg13g2_fill_1
XFILLER_9_766 VPWR VGND sg13g2_fill_2
XFILLER_8_276 VPWR VGND sg13g2_decap_4
XFILLER_5_994 VPWR VGND sg13g2_decap_8
X_4260_ _1930_ _1932_ _1964_ VPWR VGND sg13g2_nor2_1
X_3211_ videogen.fancy_shader.shader_counter_reg\[6\] _0949_ _0950_ VPWR VGND sg13g2_nor2_1
X_4191_ _1897_ red\[2\] _1895_ VPWR VGND sg13g2_xnor2_1
X_3142_ _0895_ VPWR _0905_ VGND videogen.test_lut_thingy.pixel_feeder_inst.v_pix\[2\]
+ _0902_ sg13g2_o21ai_1
X_3073_ serialize.shift_reg_g\[1\] serialize.shift_reg_g\[0\] clknet_1_1__leaf_clk
+ net5 VPWR VGND sg13g2_mux2_1
XFILLER_36_810 VPWR VGND sg13g2_decap_8
XFILLER_36_821 VPWR VGND sg13g2_fill_1
XFILLER_48_692 VPWR VGND sg13g2_decap_8
XFILLER_36_865 VPWR VGND sg13g2_decap_4
X_3975_ _1685_ _1684_ _1686_ VPWR VGND sg13g2_xor2_1
X_2926_ videogen.test_lut_thingy.pixel_feeder_inst.row\[31\]\[3\] net765 _0809_ _0435_
+ VPWR VGND sg13g2_mux2_1
XFILLER_31_570 VPWR VGND sg13g2_decap_8
X_2857_ VGND VPWR _0793_ _0769_ _0748_ sg13g2_or2_1
XFILLER_3_909 VPWR VGND sg13g2_decap_8
X_2788_ videogen.test_lut_thingy.pixel_feeder_inst.row\[39\]\[3\] net762 _0779_ _0552_
+ VPWR VGND sg13g2_mux2_1
X_4527_ _2178_ net661 net470 net666 red_tmds_par\[3\] VPWR VGND sg13g2_a22oi_1
X_4458_ _2137_ _2116_ _2136_ VPWR VGND sg13g2_nand2_1
XFILLER_49_49 VPWR VGND sg13g2_decap_8
Xfanout712 net717 net712 VPWR VGND sg13g2_buf_8
X_3409_ VPWR _1127_ _1126_ VGND sg13g2_inv_1
Xfanout723 net736 net723 VPWR VGND sg13g2_buf_8
Xfanout701 net702 net701 VPWR VGND sg13g2_buf_8
Xfanout734 net735 net734 VPWR VGND sg13g2_buf_8
X_4389_ _2071_ tmds_blue.dc_balancing_reg\[1\] _2068_ VPWR VGND sg13g2_xnor2_1
Xfanout767 net772 net767 VPWR VGND sg13g2_buf_8
Xfanout745 net746 net745 VPWR VGND sg13g2_buf_8
Xfanout756 clockdiv.q1 net756 VPWR VGND sg13g2_buf_8
XFILLER_46_607 VPWR VGND sg13g2_fill_2
Xfanout789 net793 net789 VPWR VGND sg13g2_buf_8
Xfanout778 net782 net778 VPWR VGND sg13g2_buf_8
XFILLER_27_843 VPWR VGND sg13g2_decap_8
XFILLER_27_854 VPWR VGND sg13g2_fill_1
XFILLER_42_802 VPWR VGND sg13g2_fill_2
XFILLER_41_345 VPWR VGND sg13g2_decap_4
XFILLER_41_389 VPWR VGND sg13g2_decap_4
XFILLER_41_378 VPWR VGND sg13g2_fill_1
XFILLER_6_758 VPWR VGND sg13g2_fill_1
XFILLER_5_246 VPWR VGND sg13g2_decap_4
XFILLER_10_798 VPWR VGND sg13g2_fill_2
XFILLER_2_942 VPWR VGND sg13g2_decap_8
XFILLER_1_441 VPWR VGND sg13g2_decap_8
XFILLER_49_467 VPWR VGND sg13g2_decap_8
XFILLER_29_180 VPWR VGND sg13g2_fill_1
XFILLER_17_364 VPWR VGND sg13g2_decap_8
XFILLER_17_375 VPWR VGND sg13g2_fill_1
XFILLER_32_334 VPWR VGND sg13g2_fill_2
XFILLER_33_879 VPWR VGND sg13g2_decap_8
XFILLER_20_507 VPWR VGND sg13g2_decap_8
X_3760_ videogen.test_lut_thingy.pixel_feeder_inst.row\[16\]\[1\] net582 _1478_ VPWR
+ VGND sg13g2_nor2_1
X_2711_ net594 _0726_ _0754_ _0755_ VPWR VGND sg13g2_or3_1
X_3691_ net618 VPWR _1409_ VGND videogen.test_lut_thingy.pixel_feeder_inst.row\[42\]\[2\]
+ net587 sg13g2_o21ai_1
X_2642_ VGND VPWR _0714_ net632 net628 sg13g2_or2_1
X_4312_ VGND VPWR tmds_green.dc_balancing_reg\[4\] _2001_ _0412_ _2002_ sg13g2_a21oi_1
X_4243_ _1948_ _1947_ _1942_ _1946_ _1933_ VPWR VGND sg13g2_a22oi_1
X_4174_ _1880_ _1877_ red\[6\] VPWR VGND sg13g2_nand2b_1
X_3125_ VGND VPWR videogen.fancy_shader.video_x\[9\] _0889_ _0301_ _0891_ sg13g2_a21oi_1
XFILLER_28_618 VPWR VGND sg13g2_decap_8
X_3056_ _0861_ videogen.test_lut_thingy.pixel_feeder_inst.v_pix\[1\] _0858_ VPWR VGND
+ sg13g2_xnor2_1
XFILLER_24_846 VPWR VGND sg13g2_decap_4
XFILLER_24_879 VPWR VGND sg13g2_decap_8
X_3958_ _1667_ VPWR _0363_ VGND _1665_ _1670_ sg13g2_o21ai_1
X_3889_ VGND VPWR _1603_ _1602_ _1598_ sg13g2_or2_1
X_2909_ videogen.test_lut_thingy.pixel_feeder_inst.row\[0\]\[0\] net802 _0805_ _0448_
+ VPWR VGND sg13g2_mux2_1
Xfanout553 _0709_ net553 VPWR VGND sg13g2_buf_8
Xfanout575 net579 net575 VPWR VGND sg13g2_buf_8
Xfanout564 _0737_ net564 VPWR VGND sg13g2_buf_8
XFILLER_47_949 VPWR VGND sg13g2_decap_8
Xfanout597 net599 net597 VPWR VGND sg13g2_buf_8
Xfanout586 net589 net586 VPWR VGND sg13g2_buf_1
XFILLER_15_802 VPWR VGND sg13g2_decap_8
XFILLER_27_662 VPWR VGND sg13g2_fill_2
X_5021__224 VPWR VGND net224 sg13g2_tiehi
XFILLER_42_665 VPWR VGND sg13g2_decap_8
XFILLER_41_131 VPWR VGND sg13g2_fill_2
XFILLER_10_584 VPWR VGND sg13g2_decap_4
XFILLER_37_7 VPWR VGND sg13g2_decap_8
XFILLER_2_11 VPWR VGND sg13g2_decap_8
XFILLER_2_44 VPWR VGND sg13g2_decap_8
XFILLER_49_253 VPWR VGND sg13g2_fill_2
XFILLER_38_916 VPWR VGND sg13g2_decap_8
XFILLER_18_640 VPWR VGND sg13g2_fill_2
XFILLER_46_982 VPWR VGND sg13g2_decap_8
X_4930_ net389 VGND VPWR _0391_ videogen.test_lut_thingy.pixel_feeder_inst.row\[17\]\[0\]
+ _0037_ sg13g2_dfrbpq_1
X_4861_ net82 VGND VPWR _0322_ videogen.test_lut_thingy.pixel_feeder_inst.h_counter\[3\]
+ net639 sg13g2_dfrbpq_1
XFILLER_21_805 VPWR VGND sg13g2_decap_8
X_3812_ videogen.test_lut_thingy.pixel_feeder_inst.row\[22\]\[0\] net590 _1529_ VPWR
+ VGND sg13g2_nor2_1
XFILLER_14_890 VPWR VGND sg13g2_decap_8
X_4792_ net698 net742 _0254_ VPWR VGND sg13g2_nor2_1
XFILLER_21_849 VPWR VGND sg13g2_fill_2
XFILLER_32_197 VPWR VGND sg13g2_decap_4
X_3743_ videogen.test_lut_thingy.pixel_feeder_inst.row\[58\]\[1\] net586 _1461_ VPWR
+ VGND sg13g2_nor2_1
XFILLER_20_359 VPWR VGND sg13g2_fill_2
X_3674_ videogen.test_lut_thingy.pixel_feeder_inst.row\[63\]\[2\] net570 _1392_ VPWR
+ VGND sg13g2_nor2_1
X_2625_ videogen.fancy_shader.video_y\[3\] videogen.fancy_shader.video_y\[2\] _0696_
+ _0697_ VPWR VGND sg13g2_nor3_1
X_4226_ _1929_ _1928_ _1931_ VPWR VGND sg13g2_xor2_1
X_4157_ _1868_ _1327_ _1863_ VPWR VGND sg13g2_nand2_1
XFILLER_29_938 VPWR VGND sg13g2_decap_8
X_3108_ VGND VPWR videogen.fancy_shader.video_x\[1\] net637 _0882_ videogen.fancy_shader.video_x\[2\]
+ sg13g2_a21oi_1
X_4088_ _1799_ _1596_ _1695_ VPWR VGND sg13g2_xnor2_1
X_5159__311 VPWR VGND net311 sg13g2_tiehi
XFILLER_37_982 VPWR VGND sg13g2_decap_8
X_3039_ _0849_ net621 _0713_ VPWR VGND sg13g2_xnor2_1
XFILLER_24_621 VPWR VGND sg13g2_decap_8
XFILLER_24_643 VPWR VGND sg13g2_decap_4
XFILLER_11_348 VPWR VGND sg13g2_fill_2
XFILLER_3_514 VPWR VGND sg13g2_decap_8
XFILLER_2_4 VPWR VGND sg13g2_decap_8
XFILLER_11_86 VPWR VGND sg13g2_fill_2
X_4859__86 VPWR VGND net86 sg13g2_tiehi
X_4874__56 VPWR VGND net56 sg13g2_tiehi
XFILLER_4_1027 VPWR VGND sg13g2_fill_2
XFILLER_27_481 VPWR VGND sg13g2_fill_2
XFILLER_28_993 VPWR VGND sg13g2_decap_8
XFILLER_36_61 VPWR VGND sg13g2_decap_8
XFILLER_43_963 VPWR VGND sg13g2_decap_8
XFILLER_14_164 VPWR VGND sg13g2_decap_4
XFILLER_30_657 VPWR VGND sg13g2_decap_8
XFILLER_7_820 VPWR VGND sg13g2_decap_4
XFILLER_6_341 VPWR VGND sg13g2_decap_4
XFILLER_6_385 VPWR VGND sg13g2_decap_4
X_3390_ _1096_ _1097_ _1099_ _1106_ _1108_ VPWR VGND sg13g2_or4_1
X_5060_ net97 VGND VPWR _0517_ videogen.test_lut_thingy.pixel_feeder_inst.row\[55\]\[0\]
+ _0145_ sg13g2_dfrbpq_1
XFILLER_42_1011 VPWR VGND sg13g2_decap_8
X_4011_ _1710_ _1719_ _1722_ VPWR VGND sg13g2_nor2_1
XFILLER_37_278 VPWR VGND sg13g2_decap_4
XFILLER_25_429 VPWR VGND sg13g2_decap_8
X_4913_ net414 VGND VPWR _0374_ tmds_red.dc_balancing_reg\[4\] net653 sg13g2_dfrbpq_2
XFILLER_34_963 VPWR VGND sg13g2_decap_8
X_4844_ net116 VGND VPWR _0305_ videogen.test_lut_thingy.pixel_feeder_inst.v_pix\[2\]
+ net638 sg13g2_dfrbpq_1
XFILLER_21_646 VPWR VGND sg13g2_fill_2
X_4775_ net676 net720 _0239_ VPWR VGND sg13g2_nor2_1
X_3726_ videogen.test_lut_thingy.pixel_feeder_inst.row\[41\]\[1\] net556 _1444_ VPWR
+ VGND sg13g2_nor2_1
X_3657_ net617 VPWR _1375_ VGND videogen.test_lut_thingy.pixel_feeder_inst.row\[56\]\[2\]
+ net576 sg13g2_o21ai_1
X_3588_ net625 VPWR _1306_ VGND videogen.test_lut_thingy.pixel_feeder_inst.row\[15\]\[3\]
+ net572 sg13g2_o21ai_1
X_2608_ VPWR _0681_ net635 VGND sg13g2_inv_1
XFILLER_0_528 VPWR VGND sg13g2_decap_8
XFILLER_29_713 VPWR VGND sg13g2_decap_4
X_5189_ net438 VGND VPWR _0646_ serialize.shift_reg_b\[7\] clknet_3_1__leaf_clk_regs
+ sg13g2_dfrbpq_1
XFILLER_29_735 VPWR VGND sg13g2_decap_8
X_4209_ _1913_ _1914_ _1915_ VPWR VGND sg13g2_nor2b_1
XFILLER_29_768 VPWR VGND sg13g2_decap_8
XFILLER_16_429 VPWR VGND sg13g2_decap_8
XFILLER_43_226 VPWR VGND sg13g2_fill_2
XFILLER_25_996 VPWR VGND sg13g2_decap_8
XFILLER_40_977 VPWR VGND sg13g2_decap_8
XFILLER_7_127 VPWR VGND sg13g2_fill_2
XFILLER_22_41 VPWR VGND sg13g2_decap_8
XFILLER_3_333 VPWR VGND sg13g2_decap_8
XFILLER_3_388 VPWR VGND sg13g2_decap_8
XFILLER_47_510 VPWR VGND sg13g2_decap_8
XFILLER_35_705 VPWR VGND sg13g2_fill_1
XFILLER_16_996 VPWR VGND sg13g2_decap_8
XFILLER_42_281 VPWR VGND sg13g2_decap_4
X_2890_ videogen.test_lut_thingy.pixel_feeder_inst.row\[62\]\[2\] net779 _0800_ _0462_
+ VPWR VGND sg13g2_mux2_1
X_5034__201 VPWR VGND net201 sg13g2_tiehi
XFILLER_30_498 VPWR VGND sg13g2_decap_8
X_4560_ net688 net732 _0026_ VPWR VGND sg13g2_nor2_1
X_4491_ _2160_ net660 net472 net665 blue_tmds_par\[1\] VPWR VGND sg13g2_a22oi_1
X_3511_ _1227_ _1228_ _1176_ _1229_ VPWR VGND sg13g2_nand3_1
X_3442_ _1152_ _1159_ _1160_ VPWR VGND sg13g2_and2_1
X_3373_ _1082_ net546 _1091_ VPWR VGND sg13g2_and2_1
X_5112_ net265 VGND VPWR _0569_ videogen.test_lut_thingy.pixel_feeder_inst.row\[43\]\[0\]
+ _0197_ sg13g2_dfrbpq_1
X_5043_ net189 VGND VPWR _0500_ videogen.test_lut_thingy.pixel_feeder_inst.row\[2\]\[3\]
+ _0128_ sg13g2_dfrbpq_1
XFILLER_19_790 VPWR VGND sg13g2_fill_2
XFILLER_25_248 VPWR VGND sg13g2_fill_1
XFILLER_40_218 VPWR VGND sg13g2_decap_4
XFILLER_21_443 VPWR VGND sg13g2_fill_2
XFILLER_22_955 VPWR VGND sg13g2_decap_8
X_4827_ net139 VGND VPWR _0288_ videogen.test_lut_thingy.pixel_feeder_inst.row\[18\]\[0\]
+ _0017_ sg13g2_dfrbpq_1
X_4758_ net693 net737 _0222_ VPWR VGND sg13g2_nor2_1
X_5184__63 VPWR VGND net63 sg13g2_tiehi
XFILLER_4_119 VPWR VGND sg13g2_decap_8
X_4689_ net678 net722 _0153_ VPWR VGND sg13g2_nor2_1
X_3709_ videogen.test_lut_thingy.pixel_feeder_inst.row\[32\]\[1\] net578 _1427_ VPWR
+ VGND sg13g2_nor2_1
XFILLER_0_336 VPWR VGND sg13g2_decap_8
XFILLER_1_848 VPWR VGND sg13g2_decap_8
XFILLER_49_819 VPWR VGND sg13g2_decap_8
XFILLER_17_74 VPWR VGND sg13g2_fill_1
X_5100__313 VPWR VGND net313 sg13g2_tiehi
XFILLER_13_933 VPWR VGND sg13g2_decap_8
XFILLER_24_292 VPWR VGND sg13g2_decap_8
XFILLER_33_51 VPWR VGND sg13g2_decap_8
XFILLER_40_774 VPWR VGND sg13g2_fill_2
XFILLER_9_937 VPWR VGND sg13g2_decap_8
XFILLER_32_1010 VPWR VGND sg13g2_decap_8
X_5133__144 VPWR VGND net144 sg13g2_tiehi
XFILLER_4_642 VPWR VGND sg13g2_decap_4
XFILLER_4_620 VPWR VGND sg13g2_decap_4
Xhold3 serialize.shift_reg_c\[5\] VPWR VGND net449 sg13g2_dlygate4sd3_1
XFILLER_39_318 VPWR VGND sg13g2_decap_4
XFILLER_48_852 VPWR VGND sg13g2_decap_8
X_3991_ _1702_ net546 _1701_ VPWR VGND sg13g2_xnor2_1
XFILLER_16_760 VPWR VGND sg13g2_fill_1
X_2942_ videogen.test_lut_thingy.pixel_feeder_inst.row\[33\]\[2\] net776 _0812_ _0422_
+ VPWR VGND sg13g2_mux2_1
X_2873_ videogen.test_lut_thingy.pixel_feeder_inst.row\[5\]\[3\] net769 _0796_ _0475_
+ VPWR VGND sg13g2_mux2_1
X_4612_ net690 net734 _0076_ VPWR VGND sg13g2_nor2_1
XFILLER_8_992 VPWR VGND sg13g2_decap_8
X_4543_ net706 net750 _0009_ VPWR VGND sg13g2_nor2_1
X_4474_ _2149_ _2147_ _2148_ VPWR VGND sg13g2_xnor2_1
X_3425_ _1143_ _1140_ _1141_ VPWR VGND sg13g2_nand2_2
X_3356_ _1074_ _1057_ _1073_ VPWR VGND sg13g2_nand2_1
X_3287_ _1005_ videogen.fancy_shader.video_x\[1\] videogen.fancy_shader.shader_counter_reg\[1\]
+ VPWR VGND sg13g2_nand2_1
X_5026_ net214 VGND VPWR _0483_ videogen.test_lut_thingy.pixel_feeder_inst.row\[57\]\[3\]
+ _0120_ sg13g2_dfrbpq_1
XFILLER_13_207 VPWR VGND sg13g2_decap_8
XFILLER_41_538 VPWR VGND sg13g2_fill_2
XFILLER_41_527 VPWR VGND sg13g2_decap_8
XFILLER_22_752 VPWR VGND sg13g2_decap_8
XFILLER_10_969 VPWR VGND sg13g2_decap_8
XFILLER_21_295 VPWR VGND sg13g2_fill_2
X_5052__142 VPWR VGND net142 sg13g2_tiehi
XFILLER_0_133 VPWR VGND sg13g2_fill_1
XFILLER_0_188 VPWR VGND sg13g2_decap_8
XFILLER_45_800 VPWR VGND sg13g2_decap_8
XFILLER_44_321 VPWR VGND sg13g2_fill_2
XFILLER_45_866 VPWR VGND sg13g2_fill_1
XFILLER_44_398 VPWR VGND sg13g2_fill_2
XFILLER_32_549 VPWR VGND sg13g2_decap_4
XFILLER_25_590 VPWR VGND sg13g2_decap_4
XFILLER_9_734 VPWR VGND sg13g2_fill_2
XFILLER_13_763 VPWR VGND sg13g2_fill_1
XFILLER_13_785 VPWR VGND sg13g2_decap_8
XFILLER_13_796 VPWR VGND sg13g2_fill_1
X_5031__204 VPWR VGND net204 sg13g2_tiehi
XFILLER_5_962 VPWR VGND sg13g2_decap_4
XFILLER_5_77 VPWR VGND sg13g2_decap_8
X_3210_ net551 _0948_ _0949_ _0336_ VPWR VGND sg13g2_nor3_1
X_4190_ _1896_ red\[2\] _1895_ VPWR VGND sg13g2_nand2_1
X_3141_ videogen.test_lut_thingy.pixel_feeder_inst.v_pix\[2\] _0902_ _0904_ VPWR VGND
+ sg13g2_and2_1
XFILLER_48_671 VPWR VGND sg13g2_decap_8
X_3072_ serialize.shift_reg_b\[1\] serialize.shift_reg_b\[0\] clknet_1_0__leaf_clk
+ net3 VPWR VGND sg13g2_mux2_1
X_3974_ _1004_ _1009_ _1675_ _1685_ VPWR VGND sg13g2_nor3_2
X_2925_ _0735_ _0760_ _0809_ VPWR VGND sg13g2_nor2_2
X_2856_ videogen.test_lut_thingy.pixel_feeder_inst.row\[2\]\[0\] net802 _0792_ _0497_
+ VPWR VGND sg13g2_mux2_1
X_2787_ _0732_ _0755_ _0779_ VPWR VGND sg13g2_nor2_2
X_4526_ VPWR _0657_ _2177_ VGND sg13g2_inv_1
XFILLER_49_28 VPWR VGND sg13g2_decap_8
X_4457_ _2066_ _2135_ _2062_ _2136_ VPWR VGND sg13g2_nand3_1
Xfanout713 net717 net713 VPWR VGND sg13g2_buf_1
X_3408_ _1121_ net550 _1126_ VPWR VGND sg13g2_xor2_1
Xfanout724 net726 net724 VPWR VGND sg13g2_buf_8
Xfanout702 net711 net702 VPWR VGND sg13g2_buf_8
X_4388_ _2070_ tmds_blue.dc_balancing_reg\[1\] _2068_ VPWR VGND sg13g2_nand2_1
Xfanout757 _0677_ net757 VPWR VGND sg13g2_buf_8
Xfanout746 net756 net746 VPWR VGND sg13g2_buf_8
Xfanout735 net736 net735 VPWR VGND sg13g2_buf_8
X_3339_ _1045_ _1046_ _1056_ _1057_ VPWR VGND sg13g2_nor3_1
Xfanout768 net772 net768 VPWR VGND sg13g2_buf_2
Xfanout779 net782 net779 VPWR VGND sg13g2_buf_2
XFILLER_39_682 VPWR VGND sg13g2_decap_8
X_5009_ net248 VGND VPWR _0466_ videogen.test_lut_thingy.pixel_feeder_inst.row\[61\]\[2\]
+ _0103_ sg13g2_dfrbpq_1
XFILLER_26_365 VPWR VGND sg13g2_decap_8
XFILLER_42_836 VPWR VGND sg13g2_fill_1
XFILLER_41_324 VPWR VGND sg13g2_fill_1
XFILLER_14_53 VPWR VGND sg13g2_decap_4
XFILLER_6_715 VPWR VGND sg13g2_decap_8
XFILLER_6_737 VPWR VGND sg13g2_decap_8
XFILLER_30_52 VPWR VGND sg13g2_decap_4
XFILLER_2_921 VPWR VGND sg13g2_decap_8
XFILLER_7_1025 VPWR VGND sg13g2_decap_4
XFILLER_2_998 VPWR VGND sg13g2_decap_8
XFILLER_49_446 VPWR VGND sg13g2_decap_8
XFILLER_1_497 VPWR VGND sg13g2_decap_8
XFILLER_17_321 VPWR VGND sg13g2_decap_8
X_5066__73 VPWR VGND net73 sg13g2_tiehi
XFILLER_18_855 VPWR VGND sg13g2_fill_2
XFILLER_33_836 VPWR VGND sg13g2_fill_2
XFILLER_13_560 VPWR VGND sg13g2_decap_8
XFILLER_32_368 VPWR VGND sg13g2_decap_8
X_2710_ VGND VPWR _0754_ _0746_ _0720_ sg13g2_or2_1
X_3690_ net596 _1402_ _1407_ _1408_ VPWR VGND sg13g2_nor3_1
X_2641_ net627 net631 _0713_ VPWR VGND sg13g2_nor2_2
X_4311_ net554 VPWR _2002_ VGND tmds_green.dc_balancing_reg\[4\] _2001_ sg13g2_o21ai_1
X_4242_ net544 _1922_ _1947_ VPWR VGND sg13g2_and2_1
X_4173_ VPWR _1879_ _1878_ VGND sg13g2_inv_1
XFILLER_49_980 VPWR VGND sg13g2_decap_8
X_3124_ _0880_ VPWR _0891_ VGND videogen.fancy_shader.video_x\[9\] _0889_ sg13g2_o21ai_1
X_3055_ _0857_ _0860_ net16 VPWR VGND sg13g2_nor2b_1
XFILLER_27_118 VPWR VGND sg13g2_decap_4
XFILLER_23_313 VPWR VGND sg13g2_decap_8
XFILLER_24_825 VPWR VGND sg13g2_decap_8
XFILLER_35_162 VPWR VGND sg13g2_fill_2
X_3957_ _1670_ net810 _1668_ VPWR VGND sg13g2_nand2_1
Xclkbuf_0_clk_regs clk_regs clknet_0_clk_regs VPWR VGND sg13g2_buf_8
X_2908_ videogen.test_lut_thingy.pixel_feeder_inst.row\[0\]\[1\] net790 _0805_ _0449_
+ VPWR VGND sg13g2_mux2_1
X_3888_ _1602_ _1082_ _1599_ VPWR VGND sg13g2_xnor2_1
X_2839_ videogen.test_lut_thingy.pixel_feeder_inst.row\[35\]\[2\] net777 _0789_ _0511_
+ VPWR VGND sg13g2_mux2_1
X_4509_ _2169_ net660 net466 net665 green_tmds_par\[2\] VPWR VGND sg13g2_a22oi_1
X_4886__32 VPWR VGND net32 sg13g2_tiehi
Xfanout543 _1801_ net543 VPWR VGND sg13g2_buf_2
Xfanout565 net569 net565 VPWR VGND sg13g2_buf_8
Xfanout554 _0957_ net554 VPWR VGND sg13g2_buf_8
XFILLER_47_928 VPWR VGND sg13g2_decap_8
Xfanout598 net599 net598 VPWR VGND sg13g2_buf_8
Xfanout576 net579 net576 VPWR VGND sg13g2_buf_1
Xfanout587 net589 net587 VPWR VGND sg13g2_buf_8
XFILLER_15_825 VPWR VGND sg13g2_fill_1
XFILLER_25_30 VPWR VGND sg13g2_decap_4
XFILLER_26_195 VPWR VGND sg13g2_decap_8
XFILLER_14_379 VPWR VGND sg13g2_decap_8
X_4895__432 VPWR VGND net432 sg13g2_tiehi
XFILLER_29_1015 VPWR VGND sg13g2_decap_8
XFILLER_49_232 VPWR VGND sg13g2_decap_8
XFILLER_2_795 VPWR VGND sg13g2_decap_8
XFILLER_46_961 VPWR VGND sg13g2_decap_8
XFILLER_17_140 VPWR VGND sg13g2_fill_1
X_4860_ net84 VGND VPWR _0321_ videogen.test_lut_thingy.pixel_feeder_inst.h_counter\[2\]
+ net639 sg13g2_dfrbpq_1
X_3811_ videogen.test_lut_thingy.pixel_feeder_inst.row\[20\]\[0\] net581 _1528_ VPWR
+ VGND sg13g2_nor2_1
XFILLER_33_688 VPWR VGND sg13g2_decap_4
X_4791_ net698 net742 _0253_ VPWR VGND sg13g2_nor2_1
XFILLER_33_699 VPWR VGND sg13g2_fill_2
X_3742_ net596 VPWR _1460_ VGND videogen.test_lut_thingy.pixel_feeder_inst.row\[59\]\[1\]
+ net565 sg13g2_o21ai_1
XFILLER_13_390 VPWR VGND sg13g2_decap_8
X_3673_ net620 VPWR _1391_ VGND videogen.test_lut_thingy.pixel_feeder_inst.row\[62\]\[2\]
+ net593 sg13g2_o21ai_1
X_2624_ VGND VPWR _0696_ net613 videogen.fancy_shader.video_y\[1\] sg13g2_or2_1
X_4225_ _1928_ _1929_ _1930_ VPWR VGND sg13g2_nor2_1
X_4156_ VGND VPWR _1867_ _1865_ _1863_ sg13g2_or2_1
XFILLER_46_29 VPWR VGND sg13g2_decap_4
X_3107_ _0879_ _0881_ _0293_ VPWR VGND sg13g2_nor2_1
XFILLER_44_909 VPWR VGND sg13g2_decap_8
XFILLER_43_408 VPWR VGND sg13g2_decap_8
XFILLER_37_961 VPWR VGND sg13g2_decap_8
X_4087_ _1699_ _1599_ _1798_ VPWR VGND sg13g2_xor2_1
X_3038_ VGND VPWR net594 net9 _0848_ net553 sg13g2_a21oi_2
XFILLER_12_828 VPWR VGND sg13g2_fill_2
X_4989_ net288 VGND VPWR _0446_ videogen.test_lut_thingy.pixel_feeder_inst.row\[11\]\[2\]
+ _0083_ sg13g2_dfrbpq_1
X_4838__124 VPWR VGND net124 sg13g2_tiehi
XFILLER_4_1006 VPWR VGND sg13g2_decap_8
XFILLER_47_736 VPWR VGND sg13g2_fill_1
XFILLER_28_972 VPWR VGND sg13g2_decap_8
XFILLER_36_40 VPWR VGND sg13g2_decap_8
XFILLER_43_942 VPWR VGND sg13g2_decap_8
XFILLER_30_614 VPWR VGND sg13g2_decap_8
XFILLER_30_625 VPWR VGND sg13g2_fill_2
XFILLER_30_669 VPWR VGND sg13g2_decap_8
XFILLER_7_832 VPWR VGND sg13g2_fill_2
XFILLER_10_371 VPWR VGND sg13g2_decap_8
XFILLER_10_393 VPWR VGND sg13g2_decap_8
X_4010_ VGND VPWR _1700_ _1711_ _1721_ _1708_ sg13g2_a21oi_1
XFILLER_37_257 VPWR VGND sg13g2_decap_8
X_4912_ net415 VGND VPWR _0373_ tmds_red.dc_balancing_reg\[3\] net653 sg13g2_dfrbpq_2
XFILLER_34_942 VPWR VGND sg13g2_decap_8
XFILLER_33_441 VPWR VGND sg13g2_fill_1
X_4843_ net118 VGND VPWR _0304_ videogen.test_lut_thingy.pixel_feeder_inst.v_pix\[1\]
+ net638 sg13g2_dfrbpq_2
XFILLER_21_625 VPWR VGND sg13g2_decap_8
XFILLER_21_636 VPWR VGND sg13g2_fill_1
X_4774_ net693 net737 _0238_ VPWR VGND sg13g2_nor2_1
X_3725_ videogen.test_lut_thingy.pixel_feeder_inst.row\[40\]\[1\] net575 _1443_ VPWR
+ VGND sg13g2_nor2_1
XFILLER_20_168 VPWR VGND sg13g2_decap_4
X_3656_ videogen.test_lut_thingy.pixel_feeder_inst.h_pix\[5\] _1350_ _1373_ _1374_
+ VPWR VGND sg13g2_nor3_1
X_3587_ _1301_ _1302_ _1303_ _1304_ _1305_ VPWR VGND sg13g2_nor4_1
X_2607_ VPWR _0680_ net623 VGND sg13g2_inv_1
XFILLER_0_507 VPWR VGND sg13g2_decap_8
XFILLER_29_703 VPWR VGND sg13g2_decap_4
X_4208_ _1904_ VPWR _1914_ VGND _1906_ _1910_ sg13g2_o21ai_1
X_5188_ net31 VGND VPWR _0645_ serialize.shift_reg_b\[6\] clknet_3_2__leaf_clk_regs
+ sg13g2_dfrbpq_1
X_4139_ _1850_ _1846_ _1849_ VPWR VGND sg13g2_nand2b_1
XFILLER_37_791 VPWR VGND sg13g2_fill_2
XFILLER_25_975 VPWR VGND sg13g2_decap_8
XFILLER_12_614 VPWR VGND sg13g2_decap_8
XFILLER_12_625 VPWR VGND sg13g2_fill_1
XFILLER_8_607 VPWR VGND sg13g2_decap_8
XFILLER_11_135 VPWR VGND sg13g2_decap_8
X_4892__435 VPWR VGND net435 sg13g2_tiehi
XFILLER_22_97 VPWR VGND sg13g2_decap_8
XFILLER_4_857 VPWR VGND sg13g2_decap_8
XFILLER_3_367 VPWR VGND sg13g2_decap_8
XFILLER_26_1018 VPWR VGND sg13g2_decap_8
XFILLER_19_202 VPWR VGND sg13g2_fill_1
XFILLER_47_61 VPWR VGND sg13g2_fill_2
XFILLER_47_50 VPWR VGND sg13g2_decap_8
XFILLER_19_246 VPWR VGND sg13g2_decap_4
XFILLER_47_588 VPWR VGND sg13g2_fill_2
XFILLER_47_577 VPWR VGND sg13g2_decap_8
XFILLER_28_780 VPWR VGND sg13g2_decap_8
XFILLER_15_430 VPWR VGND sg13g2_fill_2
XFILLER_15_463 VPWR VGND sg13g2_decap_8
XFILLER_16_975 VPWR VGND sg13g2_decap_8
XFILLER_8_11 VPWR VGND sg13g2_fill_2
XFILLER_8_55 VPWR VGND sg13g2_decap_4
XFILLER_30_488 VPWR VGND sg13g2_fill_2
XFILLER_7_640 VPWR VGND sg13g2_decap_8
X_3510_ VGND VPWR _1171_ _1173_ _1228_ _1175_ sg13g2_a21oi_1
X_4490_ VPWR _0639_ _2159_ VGND sg13g2_inv_1
X_3441_ _1148_ _1151_ _1142_ _1159_ VPWR VGND sg13g2_nand3_1
X_3372_ _1090_ _1086_ _1087_ VPWR VGND sg13g2_nand2_1
X_5111_ net269 VGND VPWR _0568_ videogen.test_lut_thingy.pixel_feeder_inst.row\[44\]\[3\]
+ _0196_ sg13g2_dfrbpq_1
X_5149__388 VPWR VGND net388 sg13g2_tiehi
X_5042_ net191 VGND VPWR _0499_ videogen.test_lut_thingy.pixel_feeder_inst.row\[2\]\[2\]
+ _0127_ sg13g2_dfrbpq_1
XFILLER_38_555 VPWR VGND sg13g2_fill_2
XFILLER_26_728 VPWR VGND sg13g2_fill_1
XFILLER_26_739 VPWR VGND sg13g2_fill_2
X_4861__82 VPWR VGND net82 sg13g2_tiehi
XFILLER_41_709 VPWR VGND sg13g2_decap_8
XFILLER_34_750 VPWR VGND sg13g2_decap_8
XFILLER_22_934 VPWR VGND sg13g2_decap_8
X_4826_ net140 VGND VPWR _0287_ serialize.bit_cnt\[1\] clknet_3_0__leaf_clk_regs sg13g2_dfrbpq_1
XFILLER_21_466 VPWR VGND sg13g2_decap_4
X_4757_ net694 net738 _0221_ VPWR VGND sg13g2_nor2_1
X_4835__127 VPWR VGND net127 sg13g2_tiehi
X_4688_ net693 net737 _0152_ VPWR VGND sg13g2_nor2_1
X_3708_ net596 VPWR _1426_ VGND videogen.test_lut_thingy.pixel_feeder_inst.row\[33\]\[1\]
+ net559 sg13g2_o21ai_1
X_3639_ videogen.test_lut_thingy.pixel_feeder_inst.row\[18\]\[2\] net590 _1357_ VPWR
+ VGND sg13g2_nor2_1
XFILLER_1_827 VPWR VGND sg13g2_decap_8
XFILLER_0_315 VPWR VGND sg13g2_decap_8
XFILLER_44_514 VPWR VGND sg13g2_decap_4
XFILLER_1_1009 VPWR VGND sg13g2_decap_8
XFILLER_17_706 VPWR VGND sg13g2_decap_8
XFILLER_17_717 VPWR VGND sg13g2_fill_2
XFILLER_9_916 VPWR VGND sg13g2_decap_8
XFILLER_12_455 VPWR VGND sg13g2_decap_8
XFILLER_13_989 VPWR VGND sg13g2_decap_8
XFILLER_8_459 VPWR VGND sg13g2_decap_8
XFILLER_12_499 VPWR VGND sg13g2_decap_4
XFILLER_4_698 VPWR VGND sg13g2_fill_1
Xhold4 serialize.shift_reg_c\[2\] VPWR VGND net450 sg13g2_dlygate4sd3_1
XFILLER_0_882 VPWR VGND sg13g2_decap_8
XFILLER_48_831 VPWR VGND sg13g2_decap_8
XFILLER_47_330 VPWR VGND sg13g2_decap_8
XFILLER_47_341 VPWR VGND sg13g2_decap_8
X_3990_ _1701_ _1689_ _1693_ VPWR VGND sg13g2_xnor2_1
X_2941_ videogen.test_lut_thingy.pixel_feeder_inst.row\[33\]\[3\] net765 _0812_ _0423_
+ VPWR VGND sg13g2_mux2_1
X_4611_ net690 net734 _0075_ VPWR VGND sg13g2_nor2_1
X_2872_ _0712_ _0762_ _0796_ VPWR VGND sg13g2_nor2_2
XFILLER_8_971 VPWR VGND sg13g2_decap_8
X_4542_ net700 net744 _0008_ VPWR VGND sg13g2_nor2_1
XFILLER_7_492 VPWR VGND sg13g2_decap_8
X_4473_ _2142_ blue\[6\] _2148_ VPWR VGND sg13g2_xor2_1
X_3424_ _1140_ _1141_ _1142_ VPWR VGND sg13g2_and2_1
X_3355_ _1041_ _1044_ _1073_ VPWR VGND sg13g2_nor2_2
X_3286_ _1004_ videogen.fancy_shader.video_x\[3\] videogen.fancy_shader.shader_counter_reg\[3\]
+ VPWR VGND sg13g2_xnor2_1
X_5025_ net216 VGND VPWR _0482_ videogen.test_lut_thingy.pixel_feeder_inst.row\[57\]\[2\]
+ _0119_ sg13g2_dfrbpq_1
XFILLER_14_709 VPWR VGND sg13g2_decap_8
XFILLER_16_1017 VPWR VGND sg13g2_decap_8
XFILLER_16_1028 VPWR VGND sg13g2_fill_1
X_4809_ net169 VGND VPWR _0270_ serialize.shift_reg_c\[1\] clknet_3_6__leaf_clk_regs
+ sg13g2_dfrbpq_1
XFILLER_10_948 VPWR VGND sg13g2_decap_8
XFILLER_1_602 VPWR VGND sg13g2_decap_8
XFILLER_1_613 VPWR VGND sg13g2_fill_1
XFILLER_0_167 VPWR VGND sg13g2_decap_8
XFILLER_1_679 VPWR VGND sg13g2_fill_2
XFILLER_28_41 VPWR VGND sg13g2_decap_4
XFILLER_28_63 VPWR VGND sg13g2_fill_2
XFILLER_17_514 VPWR VGND sg13g2_decap_4
XFILLER_32_506 VPWR VGND sg13g2_fill_2
XFILLER_44_51 VPWR VGND sg13g2_decap_4
XFILLER_13_753 VPWR VGND sg13g2_decap_8
XFILLER_9_713 VPWR VGND sg13g2_fill_2
XFILLER_12_263 VPWR VGND sg13g2_decap_4
XFILLER_8_223 VPWR VGND sg13g2_decap_4
X_4818__155 VPWR VGND net155 sg13g2_tiehi
XFILLER_5_941 VPWR VGND sg13g2_decap_8
X_4935__379 VPWR VGND net379 sg13g2_tiehi
X_3140_ _0902_ _0903_ _0304_ VPWR VGND sg13g2_nor2_1
XFILLER_39_127 VPWR VGND sg13g2_decap_8
X_3071_ serialize.shift_reg_c\[1\] serialize.shift_reg_c\[0\] clknet_1_0__leaf_clk
+ net4 VPWR VGND sg13g2_mux2_1
XFILLER_10_4 VPWR VGND sg13g2_decap_4
XFILLER_39_1028 VPWR VGND sg13g2_fill_1
XFILLER_39_1017 VPWR VGND sg13g2_decap_8
XFILLER_35_333 VPWR VGND sg13g2_fill_2
X_3973_ _1684_ _1002_ _1683_ VPWR VGND sg13g2_nand2_1
X_2924_ videogen.test_lut_thingy.pixel_feeder_inst.row\[30\]\[0\] net798 _0808_ _0436_
+ VPWR VGND sg13g2_mux2_1
X_2855_ videogen.test_lut_thingy.pixel_feeder_inst.row\[2\]\[1\] net791 _0792_ _0498_
+ VPWR VGND sg13g2_mux2_1
XFILLER_31_583 VPWR VGND sg13g2_decap_8
X_4525_ _2177_ net660 net474 net665 red_tmds_par\[2\] VPWR VGND sg13g2_a22oi_1
X_2786_ videogen.test_lut_thingy.pixel_feeder_inst.row\[47\]\[0\] net794 _0778_ _0553_
+ VPWR VGND sg13g2_mux2_1
X_4456_ _2135_ _2118_ _2134_ VPWR VGND sg13g2_nand2_1
Xfanout703 net705 net703 VPWR VGND sg13g2_buf_8
X_4387_ blue\[7\] blue\[1\] _2069_ VPWR VGND sg13g2_xor2_1
X_3407_ net550 _1121_ _1125_ VPWR VGND sg13g2_and2_1
Xfanout714 net716 net714 VPWR VGND sg13g2_buf_8
Xfanout747 net749 net747 VPWR VGND sg13g2_buf_8
X_3338_ _1056_ videogen.fancy_shader.video_y\[4\] videogen.fancy_shader.shader_counter_reg\[4\]
+ VPWR VGND sg13g2_xnor2_1
Xfanout725 net726 net725 VPWR VGND sg13g2_buf_1
Xfanout758 _0677_ net758 VPWR VGND sg13g2_buf_1
Xfanout736 clockdiv.q1 net736 VPWR VGND sg13g2_buf_8
Xfanout769 net771 net769 VPWR VGND sg13g2_buf_8
XFILLER_46_609 VPWR VGND sg13g2_fill_1
XFILLER_39_661 VPWR VGND sg13g2_decap_8
X_3269_ _0987_ videogen.fancy_shader.shader_counter_reg\[0\] net637 VPWR VGND sg13g2_nand2_1
X_5008_ net250 VGND VPWR _0465_ videogen.test_lut_thingy.pixel_feeder_inst.row\[61\]\[1\]
+ _0102_ sg13g2_dfrbpq_1
XFILLER_26_333 VPWR VGND sg13g2_decap_4
XFILLER_38_193 VPWR VGND sg13g2_decap_8
XFILLER_26_388 VPWR VGND sg13g2_decap_8
XFILLER_2_900 VPWR VGND sg13g2_decap_8
XFILLER_7_1004 VPWR VGND sg13g2_decap_8
XFILLER_2_977 VPWR VGND sg13g2_decap_8
XFILLER_1_476 VPWR VGND sg13g2_decap_8
XFILLER_49_425 VPWR VGND sg13g2_decap_8
XFILLER_39_84 VPWR VGND sg13g2_fill_2
XFILLER_45_686 VPWR VGND sg13g2_decap_4
XFILLER_44_163 VPWR VGND sg13g2_decap_8
XFILLER_44_152 VPWR VGND sg13g2_fill_1
XFILLER_32_336 VPWR VGND sg13g2_fill_1
XFILLER_9_532 VPWR VGND sg13g2_decap_8
X_2640_ _0712_ _0691_ _0711_ VPWR VGND sg13g2_nand2_2
X_4310_ _1991_ tmds_green.dc_balancing_reg\[1\] _2001_ VPWR VGND sg13g2_xor2_1
XFILLER_4_281 VPWR VGND sg13g2_decap_4
X_4241_ net545 _1922_ _1946_ VPWR VGND sg13g2_nor2b_1
XFILLER_45_1021 VPWR VGND sg13g2_decap_4
X_4172_ _1878_ red\[4\] _1876_ VPWR VGND sg13g2_xnor2_1
X_3123_ _0889_ _0890_ _0300_ VPWR VGND sg13g2_nor2_1
X_3054_ _0855_ VPWR _0860_ VGND _0858_ _0859_ sg13g2_o21ai_1
XFILLER_24_804 VPWR VGND sg13g2_decap_8
XFILLER_23_347 VPWR VGND sg13g2_decap_8
X_3956_ VPWR _1669_ _1668_ VGND sg13g2_inv_1
X_2907_ videogen.test_lut_thingy.pixel_feeder_inst.row\[0\]\[2\] net780 _0805_ _0450_
+ VPWR VGND sg13g2_mux2_1
XFILLER_31_380 VPWR VGND sg13g2_decap_8
X_3887_ _1601_ _1081_ _1599_ VPWR VGND sg13g2_nand2_1
X_2838_ videogen.test_lut_thingy.pixel_feeder_inst.row\[35\]\[3\] net765 _0789_ _0512_
+ VPWR VGND sg13g2_mux2_1
X_2769_ videogen.test_lut_thingy.pixel_feeder_inst.row\[44\]\[2\] net773 _0774_ _0567_
+ VPWR VGND sg13g2_mux2_1
X_4508_ VPWR _0648_ _2168_ VGND sg13g2_inv_1
X_4439_ _2119_ _2114_ _2117_ VPWR VGND sg13g2_xnor2_1
X_5142__59 VPWR VGND net59 sg13g2_tiehi
Xfanout566 net569 net566 VPWR VGND sg13g2_buf_1
Xfanout544 net545 net544 VPWR VGND sg13g2_buf_8
Xfanout555 _0958_ net555 VPWR VGND sg13g2_buf_8
XFILLER_47_907 VPWR VGND sg13g2_decap_8
Xfanout599 _0680_ net599 VPWR VGND sg13g2_buf_8
Xfanout588 net589 net588 VPWR VGND sg13g2_buf_8
Xfanout577 net579 net577 VPWR VGND sg13g2_buf_8
XFILLER_39_491 VPWR VGND sg13g2_fill_1
XFILLER_27_664 VPWR VGND sg13g2_fill_1
XFILLER_14_336 VPWR VGND sg13g2_fill_1
XFILLER_14_347 VPWR VGND sg13g2_decap_4
XFILLER_23_881 VPWR VGND sg13g2_decap_8
XFILLER_41_41 VPWR VGND sg13g2_fill_1
XFILLER_41_30 VPWR VGND sg13g2_fill_1
XFILLER_41_74 VPWR VGND sg13g2_decap_4
XFILLER_41_96 VPWR VGND sg13g2_decap_8
XFILLER_6_568 VPWR VGND sg13g2_decap_8
XFILLER_2_774 VPWR VGND sg13g2_decap_8
XFILLER_49_255 VPWR VGND sg13g2_fill_1
XFILLER_49_277 VPWR VGND sg13g2_decap_8
XFILLER_37_428 VPWR VGND sg13g2_fill_1
XFILLER_46_940 VPWR VGND sg13g2_decap_8
XFILLER_18_642 VPWR VGND sg13g2_fill_1
XFILLER_33_656 VPWR VGND sg13g2_decap_8
X_4790_ net697 net741 _0252_ VPWR VGND sg13g2_nor2_1
XFILLER_20_306 VPWR VGND sg13g2_fill_2
X_3810_ videogen.test_lut_thingy.pixel_feeder_inst.row\[19\]\[0\] net571 _1527_ VPWR
+ VGND sg13g2_nor2_1
XFILLER_33_667 VPWR VGND sg13g2_fill_1
XFILLER_20_328 VPWR VGND sg13g2_decap_4
X_3741_ net617 _1453_ _1458_ _1459_ VPWR VGND sg13g2_nor3_1
X_3672_ _1386_ _1387_ _1388_ _1389_ _1390_ VPWR VGND sg13g2_nor4_1
X_2623_ videogen.fancy_shader.video_y\[9\] videogen.fancy_shader.video_y\[4\] _0694_
+ _0695_ VPWR VGND sg13g2_nor3_1
XFILLER_49_0 VPWR VGND sg13g2_decap_8
X_4224_ _1929_ tmds_red.dc_balancing_reg\[2\] _1912_ VPWR VGND sg13g2_xnor2_1
X_4155_ VPWR _1866_ _1865_ VGND sg13g2_inv_1
X_3106_ _0881_ videogen.fancy_shader.video_x\[1\] net637 VPWR VGND sg13g2_xnor2_1
X_4086_ _1797_ _1599_ _1699_ VPWR VGND sg13g2_xnor2_1
X_3037_ _0848_ net585 net556 VPWR VGND sg13g2_nand2_1
XFILLER_36_472 VPWR VGND sg13g2_fill_1
XFILLER_36_483 VPWR VGND sg13g2_decap_8
X_4988_ net290 VGND VPWR _0445_ videogen.test_lut_thingy.pixel_feeder_inst.row\[11\]\[1\]
+ _0082_ sg13g2_dfrbpq_1
X_3939_ VGND VPWR _1653_ _1652_ _1650_ sg13g2_or2_1
XFILLER_20_884 VPWR VGND sg13g2_fill_2
XFILLER_11_66 VPWR VGND sg13g2_decap_8
XFILLER_3_549 VPWR VGND sg13g2_decap_8
XFILLER_11_88 VPWR VGND sg13g2_fill_1
X_5103__301 VPWR VGND net301 sg13g2_tiehi
XFILLER_43_921 VPWR VGND sg13g2_decap_8
XFILLER_15_645 VPWR VGND sg13g2_decap_8
XFILLER_42_464 VPWR VGND sg13g2_fill_2
XFILLER_42_442 VPWR VGND sg13g2_fill_2
XFILLER_43_998 VPWR VGND sg13g2_decap_8
XFILLER_11_851 VPWR VGND sg13g2_decap_8
XFILLER_6_310 VPWR VGND sg13g2_decap_4
XFILLER_10_361 VPWR VGND sg13g2_fill_2
XFILLER_7_899 VPWR VGND sg13g2_decap_8
XFILLER_19_984 VPWR VGND sg13g2_decap_8
X_4911_ net416 VGND VPWR _0372_ tmds_red.dc_balancing_reg\[2\] net655 sg13g2_dfrbpq_2
X_4842_ net120 VGND VPWR _0303_ videogen.test_lut_thingy.pixel_feeder_inst.v_pix\[0\]
+ net638 sg13g2_dfrbpq_1
XFILLER_34_998 VPWR VGND sg13g2_decap_8
X_4773_ net676 net719 _0237_ VPWR VGND sg13g2_nor2_1
X_3724_ net596 VPWR _1442_ VGND videogen.test_lut_thingy.pixel_feeder_inst.row\[43\]\[1\]
+ net565 sg13g2_o21ai_1
XFILLER_9_181 VPWR VGND sg13g2_decap_8
X_3655_ _0678_ _1361_ _1372_ _1373_ VPWR VGND sg13g2_nor3_1
X_2606_ VPWR _0679_ net618 VGND sg13g2_inv_1
X_3586_ videogen.test_lut_thingy.pixel_feeder_inst.row\[11\]\[3\] net572 _1304_ VPWR
+ VGND sg13g2_nor2_1
X_4207_ _1904_ _1906_ _1910_ _1913_ VPWR VGND sg13g2_nor3_2
X_5187_ net39 VGND VPWR _0644_ serialize.shift_reg_b\[5\] clknet_3_1__leaf_clk_regs
+ sg13g2_dfrbpq_1
X_4138_ _1843_ _1848_ _1849_ VPWR VGND sg13g2_nor2_1
X_5202__255 VPWR VGND net255 sg13g2_tiehi
X_4069_ VGND VPWR _1777_ _1779_ _1780_ _1678_ sg13g2_a21oi_1
XFILLER_24_431 VPWR VGND sg13g2_decap_8
XFILLER_25_954 VPWR VGND sg13g2_decap_8
XFILLER_12_637 VPWR VGND sg13g2_fill_2
XFILLER_8_619 VPWR VGND sg13g2_decap_4
XFILLER_22_32 VPWR VGND sg13g2_decap_4
XFILLER_20_692 VPWR VGND sg13g2_decap_8
XFILLER_47_545 VPWR VGND sg13g2_decap_8
XFILLER_47_84 VPWR VGND sg13g2_fill_2
XFILLER_15_420 VPWR VGND sg13g2_decap_4
XFILLER_16_954 VPWR VGND sg13g2_decap_8
XFILLER_31_979 VPWR VGND sg13g2_decap_8
XFILLER_8_89 VPWR VGND sg13g2_decap_8
XFILLER_11_670 VPWR VGND sg13g2_decap_8
XFILLER_6_151 VPWR VGND sg13g2_decap_4
XFILLER_6_173 VPWR VGND sg13g2_decap_8
X_3440_ _1158_ _1155_ _1156_ VPWR VGND sg13g2_xnor2_1
X_3371_ _1089_ _1083_ _1085_ VPWR VGND sg13g2_nand2_1
X_5110_ net273 VGND VPWR _0567_ videogen.test_lut_thingy.pixel_feeder_inst.row\[44\]\[2\]
+ _0195_ sg13g2_dfrbpq_1
X_5041_ net193 VGND VPWR _0498_ videogen.test_lut_thingy.pixel_feeder_inst.row\[2\]\[1\]
+ _0126_ sg13g2_dfrbpq_1
XFILLER_19_792 VPWR VGND sg13g2_fill_1
XFILLER_34_740 VPWR VGND sg13g2_fill_2
XFILLER_21_401 VPWR VGND sg13g2_decap_8
XFILLER_21_412 VPWR VGND sg13g2_fill_1
XFILLER_22_913 VPWR VGND sg13g2_decap_8
XFILLER_21_445 VPWR VGND sg13g2_fill_1
XFILLER_33_294 VPWR VGND sg13g2_decap_8
X_4825_ net141 VGND VPWR _0286_ serialize.bit_cnt\[0\] clknet_3_0__leaf_clk_regs sg13g2_dfrbpq_1
X_4756_ net697 net741 _0220_ VPWR VGND sg13g2_nor2_1
X_4687_ net693 net737 _0151_ VPWR VGND sg13g2_nor2_1
X_3707_ VPWR _1425_ _1424_ VGND sg13g2_inv_1
XFILLER_49_1008 VPWR VGND sg13g2_decap_8
X_3638_ net597 VPWR _1356_ VGND videogen.test_lut_thingy.pixel_feeder_inst.row\[17\]\[2\]
+ net562 sg13g2_o21ai_1
XFILLER_1_806 VPWR VGND sg13g2_decap_8
X_3569_ _1283_ _1284_ _1285_ _1286_ _1287_ VPWR VGND sg13g2_nor4_1
XFILLER_29_512 VPWR VGND sg13g2_fill_1
XFILLER_17_32 VPWR VGND sg13g2_fill_1
XFILLER_29_589 VPWR VGND sg13g2_decap_4
XFILLER_24_250 VPWR VGND sg13g2_fill_1
XFILLER_13_968 VPWR VGND sg13g2_decap_8
XFILLER_33_31 VPWR VGND sg13g2_fill_2
XFILLER_8_427 VPWR VGND sg13g2_fill_1
XFILLER_3_154 VPWR VGND sg13g2_fill_1
XFILLER_3_143 VPWR VGND sg13g2_decap_8
XFILLER_3_176 VPWR VGND sg13g2_decap_4
XFILLER_48_810 VPWR VGND sg13g2_decap_8
XFILLER_0_861 VPWR VGND sg13g2_decap_8
Xhold5 serialize.shift_reg_c\[3\] VPWR VGND net451 sg13g2_dlygate4sd3_1
XFILLER_48_887 VPWR VGND sg13g2_decap_8
XFILLER_47_386 VPWR VGND sg13g2_decap_8
XFILLER_22_209 VPWR VGND sg13g2_decap_8
X_2940_ _0742_ _0755_ _0812_ VPWR VGND sg13g2_nor2_2
X_2871_ net801 videogen.test_lut_thingy.pixel_feeder_inst.row\[56\]\[0\] _0795_ _0476_
+ VPWR VGND sg13g2_mux2_1
X_4610_ net690 net734 _0074_ VPWR VGND sg13g2_nor2_1
XFILLER_8_950 VPWR VGND sg13g2_decap_8
X_4541_ net697 net741 _0007_ VPWR VGND sg13g2_nor2_1
X_4472_ _2147_ _2064_ _2066_ VPWR VGND sg13g2_nand2_1
XFILLER_7_471 VPWR VGND sg13g2_decap_8
X_3423_ VGND VPWR _1141_ _1139_ _1138_ sg13g2_or2_1
X_3354_ videogen.fancy_shader.video_y\[8\] videogen.fancy_shader.shader_counter_reg\[8\]
+ _1072_ VPWR VGND sg13g2_and2_1
XFILLER_31_0 VPWR VGND sg13g2_decap_8
X_3285_ VGND VPWR _1003_ videogen.fancy_shader.shader_counter_reg\[3\] videogen.fancy_shader.video_x\[3\]
+ sg13g2_or2_1
X_5024_ net218 VGND VPWR _0481_ videogen.test_lut_thingy.pixel_feeder_inst.row\[57\]\[1\]
+ _0118_ sg13g2_dfrbpq_1
XFILLER_38_386 VPWR VGND sg13g2_fill_1
X_4841__121 VPWR VGND net121 sg13g2_tiehi
XFILLER_10_927 VPWR VGND sg13g2_decap_8
XFILLER_22_787 VPWR VGND sg13g2_decap_8
X_4808_ net170 VGND VPWR _0269_ serialize.shift_reg_c\[0\] clknet_3_6__leaf_clk_regs
+ sg13g2_dfrbpq_1
XFILLER_21_297 VPWR VGND sg13g2_fill_1
X_4739_ net680 net724 _0203_ VPWR VGND sg13g2_nor2_1
XFILLER_49_607 VPWR VGND sg13g2_decap_8
X_5167__275 VPWR VGND net275 sg13g2_tiehi
XFILLER_0_113 VPWR VGND sg13g2_fill_2
XFILLER_49_629 VPWR VGND sg13g2_decap_8
XFILLER_0_146 VPWR VGND sg13g2_decap_8
XFILLER_45_846 VPWR VGND sg13g2_fill_1
XFILLER_45_835 VPWR VGND sg13g2_fill_1
XFILLER_44_323 VPWR VGND sg13g2_fill_1
XFILLER_44_389 VPWR VGND sg13g2_decap_4
XFILLER_13_710 VPWR VGND sg13g2_fill_2
XFILLER_40_562 VPWR VGND sg13g2_fill_2
XFILLER_40_595 VPWR VGND sg13g2_fill_1
XFILLER_5_920 VPWR VGND sg13g2_decap_8
X_3070_ _0857_ _0870_ net7 VPWR VGND sg13g2_nor2_1
X_5069__61 VPWR VGND net61 sg13g2_tiehi
XFILLER_47_172 VPWR VGND sg13g2_decap_8
XFILLER_47_194 VPWR VGND sg13g2_decap_4
XFILLER_16_581 VPWR VGND sg13g2_decap_8
X_3972_ _1139_ _1156_ _1683_ VPWR VGND sg13g2_nor2b_2
XFILLER_31_540 VPWR VGND sg13g2_fill_2
X_2923_ videogen.test_lut_thingy.pixel_feeder_inst.row\[30\]\[1\] net788 _0808_ _0437_
+ VPWR VGND sg13g2_mux2_1
X_2854_ videogen.test_lut_thingy.pixel_feeder_inst.row\[2\]\[2\] net780 _0792_ _0499_
+ VPWR VGND sg13g2_mux2_1
X_2785_ videogen.test_lut_thingy.pixel_feeder_inst.row\[47\]\[1\] net784 _0778_ _0554_
+ VPWR VGND sg13g2_mux2_1
X_4524_ VPWR _0656_ _2176_ VGND sg13g2_inv_1
X_4455_ _2134_ _2131_ _2133_ VPWR VGND sg13g2_xnor2_1
Xfanout704 net705 net704 VPWR VGND sg13g2_buf_8
X_3406_ VPWR _1124_ _1123_ VGND sg13g2_inv_1
Xfanout715 net716 net715 VPWR VGND sg13g2_buf_1
X_4386_ _2068_ blue\[1\] blue\[7\] VPWR VGND sg13g2_xnor2_1
Xfanout748 net749 net748 VPWR VGND sg13g2_buf_8
X_3337_ _1045_ _1046_ _1055_ VPWR VGND sg13g2_nor2_1
Xfanout737 net740 net737 VPWR VGND sg13g2_buf_8
Xfanout726 net736 net726 VPWR VGND sg13g2_buf_8
Xfanout759 net760 net759 VPWR VGND sg13g2_buf_8
X_3268_ VGND VPWR _0985_ _0986_ _0357_ net757 sg13g2_a21oi_1
XFILLER_22_1011 VPWR VGND sg13g2_decap_8
XFILLER_45_109 VPWR VGND sg13g2_decap_4
X_5007_ net252 VGND VPWR _0464_ videogen.test_lut_thingy.pixel_feeder_inst.row\[61\]\[0\]
+ _0101_ sg13g2_dfrbpq_1
X_3199_ videogen.fancy_shader.shader_counter_reg\[2\] _0939_ _0942_ VPWR VGND sg13g2_nor2_1
XFILLER_26_356 VPWR VGND sg13g2_fill_2
XFILLER_41_315 VPWR VGND sg13g2_decap_8
XFILLER_14_529 VPWR VGND sg13g2_decap_8
XFILLER_22_584 VPWR VGND sg13g2_fill_1
XFILLER_10_757 VPWR VGND sg13g2_decap_8
XFILLER_14_99 VPWR VGND sg13g2_fill_2
XFILLER_30_10 VPWR VGND sg13g2_decap_8
XFILLER_30_43 VPWR VGND sg13g2_fill_1
X_5145__35 VPWR VGND net35 sg13g2_tiehi
XFILLER_2_956 VPWR VGND sg13g2_decap_8
XFILLER_49_404 VPWR VGND sg13g2_decap_8
XFILLER_39_30 VPWR VGND sg13g2_decap_4
XFILLER_1_455 VPWR VGND sg13g2_decap_8
XFILLER_17_334 VPWR VGND sg13g2_fill_1
XFILLER_18_857 VPWR VGND sg13g2_fill_1
XFILLER_18_879 VPWR VGND sg13g2_decap_8
XFILLER_33_838 VPWR VGND sg13g2_fill_1
XFILLER_40_381 VPWR VGND sg13g2_decap_8
XFILLER_5_750 VPWR VGND sg13g2_decap_8
XFILLER_4_260 VPWR VGND sg13g2_decap_8
XFILLER_45_1000 VPWR VGND sg13g2_decap_8
XFILLER_4_271 VPWR VGND sg13g2_decap_4
X_4831__131 VPWR VGND net131 sg13g2_tiehi
X_4240_ _1945_ _1920_ _1944_ VPWR VGND sg13g2_nand2_1
X_4171_ _1877_ red\[0\] red\[2\] VPWR VGND sg13g2_xnor2_1
X_3122_ _0880_ VPWR _0890_ VGND videogen.fancy_shader.video_x\[8\] _0887_ sg13g2_o21ai_1
X_3053_ VGND VPWR net553 _0719_ _0859_ videogen.test_lut_thingy.pixel_feeder_inst.v_pix\[0\]
+ sg13g2_a21oi_1
X_5007__252 VPWR VGND net252 sg13g2_tiehi
XFILLER_23_337 VPWR VGND sg13g2_decap_4
XFILLER_35_175 VPWR VGND sg13g2_decap_8
X_3955_ _1520_ _1577_ _1668_ VPWR VGND sg13g2_nor2_1
X_2906_ videogen.test_lut_thingy.pixel_feeder_inst.row\[0\]\[3\] net769 _0805_ _0451_
+ VPWR VGND sg13g2_mux2_1
X_3886_ VGND VPWR _1600_ _1599_ _1081_ sg13g2_or2_1
X_4992__282 VPWR VGND net282 sg13g2_tiehi
X_2837_ _0749_ _0755_ _0789_ VPWR VGND sg13g2_nor2_2
X_2768_ _0775_ VPWR _0568_ VGND _0671_ _0774_ sg13g2_o21ai_1
X_4507_ _2168_ net661 net458 net666 green_tmds_par\[1\] VPWR VGND sg13g2_a22oi_1
X_2699_ _0748_ _0750_ _0751_ VPWR VGND sg13g2_nor2_2
X_4438_ _2072_ _2087_ net606 _2118_ VPWR VGND _2111_ sg13g2_nand4_1
Xfanout556 net560 net556 VPWR VGND sg13g2_buf_8
X_4369_ _2056_ VPWR _2057_ VGND _2016_ _2045_ sg13g2_o21ai_1
Xfanout545 _1891_ net545 VPWR VGND sg13g2_buf_1
X_5205__231 VPWR VGND net231 sg13g2_tiehi
Xfanout589 _0692_ net589 VPWR VGND sg13g2_buf_8
Xfanout578 net579 net578 VPWR VGND sg13g2_buf_2
Xfanout567 net569 net567 VPWR VGND sg13g2_buf_8
XFILLER_39_481 VPWR VGND sg13g2_fill_2
XFILLER_27_676 VPWR VGND sg13g2_decap_8
XFILLER_42_624 VPWR VGND sg13g2_decap_4
XFILLER_15_838 VPWR VGND sg13g2_decap_8
XFILLER_42_679 VPWR VGND sg13g2_fill_2
XFILLER_14_359 VPWR VGND sg13g2_fill_1
XFILLER_23_860 VPWR VGND sg13g2_decap_8
XFILLER_41_53 VPWR VGND sg13g2_decap_4
XFILLER_41_86 VPWR VGND sg13g2_fill_2
XFILLER_2_753 VPWR VGND sg13g2_decap_8
XFILLER_49_212 VPWR VGND sg13g2_fill_2
XFILLER_49_201 VPWR VGND sg13g2_decap_8
XFILLER_2_25 VPWR VGND sg13g2_decap_8
XFILLER_2_58 VPWR VGND sg13g2_decap_4
XFILLER_49_267 VPWR VGND sg13g2_decap_4
XFILLER_46_996 VPWR VGND sg13g2_decap_8
XFILLER_18_665 VPWR VGND sg13g2_fill_2
XFILLER_33_613 VPWR VGND sg13g2_decap_4
XFILLER_21_819 VPWR VGND sg13g2_decap_8
X_3740_ _1454_ _1455_ _1456_ _1457_ _1458_ VPWR VGND sg13g2_nor4_1
XFILLER_9_330 VPWR VGND sg13g2_fill_2
XFILLER_9_341 VPWR VGND sg13g2_decap_8
XFILLER_12_1021 VPWR VGND sg13g2_decap_8
X_3671_ videogen.test_lut_thingy.pixel_feeder_inst.row\[54\]\[2\] net590 _1389_ VPWR
+ VGND sg13g2_nor2_1
XFILLER_9_396 VPWR VGND sg13g2_decap_8
X_2622_ videogen.fancy_shader.video_y\[7\] net611 videogen.fancy_shader.video_y\[8\]
+ _0694_ VPWR VGND videogen.fancy_shader.video_y\[5\] sg13g2_nand4_1
XFILLER_5_591 VPWR VGND sg13g2_fill_2
X_4223_ _1927_ VPWR _1928_ VGND tmds_red.dc_balancing_reg\[1\] _1902_ sg13g2_o21ai_1
X_4154_ _1864_ VPWR _1865_ VGND _1424_ _1580_ sg13g2_o21ai_1
XFILLER_29_908 VPWR VGND sg13g2_fill_2
X_4085_ _1794_ _1795_ _1796_ VPWR VGND sg13g2_and2_1
X_3105_ net637 _0879_ _0292_ VPWR VGND sg13g2_nor2_1
X_3036_ VGND VPWR net594 net8 net553 net631 sg13g2_a21oi_2
XFILLER_37_996 VPWR VGND sg13g2_decap_8
XFILLER_36_451 VPWR VGND sg13g2_decap_8
XFILLER_23_101 VPWR VGND sg13g2_decap_4
XFILLER_24_635 VPWR VGND sg13g2_fill_2
XFILLER_36_495 VPWR VGND sg13g2_decap_8
XFILLER_23_156 VPWR VGND sg13g2_fill_2
X_4987_ net292 VGND VPWR _0444_ videogen.test_lut_thingy.pixel_feeder_inst.row\[11\]\[0\]
+ _0081_ sg13g2_dfrbpq_1
XFILLER_11_329 VPWR VGND sg13g2_fill_1
X_3938_ _1652_ _1648_ _1651_ VPWR VGND sg13g2_xnor2_1
X_3869_ _1582_ VPWR _1583_ VGND _0990_ _1156_ sg13g2_o21ai_1
XFILLER_3_528 VPWR VGND sg13g2_fill_2
XFILLER_27_451 VPWR VGND sg13g2_decap_8
XFILLER_27_462 VPWR VGND sg13g2_fill_1
XFILLER_36_86 VPWR VGND sg13g2_decap_4
XFILLER_43_977 VPWR VGND sg13g2_decap_8
XFILLER_7_801 VPWR VGND sg13g2_decap_8
XFILLER_11_885 VPWR VGND sg13g2_decap_8
XFILLER_6_322 VPWR VGND sg13g2_fill_1
XFILLER_42_1025 VPWR VGND sg13g2_decap_4
X_5080__405 VPWR VGND net405 sg13g2_tiehi
XFILLER_37_204 VPWR VGND sg13g2_fill_1
XFILLER_19_963 VPWR VGND sg13g2_decap_8
XFILLER_46_793 VPWR VGND sg13g2_decap_8
X_4910_ net417 VGND VPWR _0371_ tmds_red.dc_balancing_reg\[1\] net653 sg13g2_dfrbpq_2
X_4841_ net121 VGND VPWR _0302_ tmds_blue.vsync net647 sg13g2_dfrbpq_1
XFILLER_33_432 VPWR VGND sg13g2_decap_8
XFILLER_34_977 VPWR VGND sg13g2_decap_8
X_4772_ net682 net726 _0236_ VPWR VGND sg13g2_nor2_1
X_3723_ _1437_ _1438_ _1439_ _1440_ _1441_ VPWR VGND sg13g2_nor4_1
X_3654_ net600 _1366_ _1371_ _1372_ VPWR VGND sg13g2_nor3_2
X_2605_ net615 _0678_ VPWR VGND sg13g2_inv_4
X_3585_ videogen.test_lut_thingy.pixel_feeder_inst.row\[8\]\[3\] net582 _1303_ VPWR
+ VGND sg13g2_nor2_1
X_4206_ _1902_ _1911_ _1912_ VPWR VGND sg13g2_nor2b_2
X_5186_ net47 VGND VPWR _0643_ serialize.shift_reg_b\[4\] clknet_3_3__leaf_clk_regs
+ sg13g2_dfrbpq_1
X_4137_ _1848_ _1847_ _1839_ VPWR VGND sg13g2_nand2b_1
XFILLER_28_237 VPWR VGND sg13g2_fill_2
XFILLER_29_749 VPWR VGND sg13g2_fill_1
X_4068_ _1761_ _1758_ _1778_ _1779_ VPWR VGND sg13g2_a21o_2
X_3019_ _0835_ net636 _0834_ VPWR VGND sg13g2_nand2_1
XFILLER_25_933 VPWR VGND sg13g2_decap_8
XFILLER_19_1005 VPWR VGND sg13g2_decap_8
XFILLER_24_476 VPWR VGND sg13g2_fill_1
XFILLER_22_11 VPWR VGND sg13g2_decap_8
XFILLER_20_671 VPWR VGND sg13g2_decap_8
XFILLER_3_303 VPWR VGND sg13g2_decap_8
XFILLER_3_347 VPWR VGND sg13g2_fill_2
XFILLER_47_524 VPWR VGND sg13g2_decap_8
XFILLER_16_933 VPWR VGND sg13g2_decap_8
XFILLER_28_793 VPWR VGND sg13g2_decap_8
XFILLER_42_295 VPWR VGND sg13g2_fill_2
XFILLER_8_13 VPWR VGND sg13g2_fill_1
XFILLER_30_435 VPWR VGND sg13g2_decap_8
XFILLER_6_130 VPWR VGND sg13g2_decap_8
XFILLER_7_697 VPWR VGND sg13g2_decap_8
X_3370_ _1088_ _1084_ _1083_ VPWR VGND sg13g2_nand2b_1
XFILLER_3_881 VPWR VGND sg13g2_decap_8
X_5040_ net195 VGND VPWR _0497_ videogen.test_lut_thingy.pixel_feeder_inst.row\[2\]\[0\]
+ _0125_ sg13g2_dfrbpq_1
XFILLER_46_590 VPWR VGND sg13g2_fill_1
XFILLER_18_292 VPWR VGND sg13g2_decap_8
XFILLER_21_424 VPWR VGND sg13g2_decap_8
XFILLER_22_969 VPWR VGND sg13g2_decap_8
X_4824_ net143 VGND VPWR _0285_ videogen.test_lut_thingy.pixel_feeder_inst.row\[19\]\[3\]
+ _0016_ sg13g2_dfrbpq_1
X_4755_ net697 net741 _0219_ VPWR VGND sg13g2_nor2_1
X_3706_ _1423_ VPWR _1424_ VGND _1374_ _1422_ sg13g2_o21ai_1
X_4686_ net678 net722 _0150_ VPWR VGND sg13g2_nor2_1
X_3637_ _1351_ _1352_ _1353_ _1354_ _1355_ VPWR VGND sg13g2_nor4_1
X_3568_ videogen.test_lut_thingy.pixel_feeder_inst.row\[18\]\[3\] net591 _1286_ VPWR
+ VGND sg13g2_nor2_1
X_3499_ _1213_ _1199_ _1217_ VPWR VGND sg13g2_xor2_1
X_5169_ net259 VGND VPWR _0626_ videogen.test_lut_thingy.pixel_feeder_inst.row\[25\]\[3\]
+ _0244_ sg13g2_dfrbpq_1
XFILLER_44_505 VPWR VGND sg13g2_decap_4
XFILLER_29_568 VPWR VGND sg13g2_decap_8
XFILLER_44_549 VPWR VGND sg13g2_decap_8
XFILLER_25_774 VPWR VGND sg13g2_fill_2
XFILLER_40_744 VPWR VGND sg13g2_decap_8
XFILLER_12_435 VPWR VGND sg13g2_decap_8
XFILLER_13_947 VPWR VGND sg13g2_decap_8
XFILLER_32_1024 VPWR VGND sg13g2_fill_1
XFILLER_33_87 VPWR VGND sg13g2_decap_8
XFILLER_3_111 VPWR VGND sg13g2_decap_8
XFILLER_0_840 VPWR VGND sg13g2_decap_8
Xhold6 serialize.bit_cnt\[0\] VPWR VGND net452 sg13g2_dlygate4sd3_1
XFILLER_48_866 VPWR VGND sg13g2_decap_8
XFILLER_35_538 VPWR VGND sg13g2_decap_8
XFILLER_16_774 VPWR VGND sg13g2_decap_8
XFILLER_43_582 VPWR VGND sg13g2_decap_8
X_2870_ net785 videogen.test_lut_thingy.pixel_feeder_inst.row\[56\]\[1\] _0795_ _0477_
+ VPWR VGND sg13g2_mux2_1
XFILLER_15_284 VPWR VGND sg13g2_decap_8
XFILLER_16_796 VPWR VGND sg13g2_decap_8
XFILLER_31_722 VPWR VGND sg13g2_decap_8
XFILLER_31_733 VPWR VGND sg13g2_fill_1
XFILLER_30_232 VPWR VGND sg13g2_decap_8
XFILLER_30_254 VPWR VGND sg13g2_decap_8
XFILLER_30_265 VPWR VGND sg13g2_fill_2
X_4540_ net695 net740 _0006_ VPWR VGND sg13g2_nor2_1
X_4471_ _2144_ _2146_ _0615_ VPWR VGND sg13g2_nor2_1
XFILLER_48_1020 VPWR VGND sg13g2_decap_8
X_3422_ _1140_ _1138_ _1139_ VPWR VGND sg13g2_nand2_1
X_3353_ _1071_ _1069_ _1070_ VPWR VGND sg13g2_xnor2_1
X_3284_ _1002_ _0994_ _1001_ VPWR VGND sg13g2_xnor2_1
XFILLER_39_833 VPWR VGND sg13g2_decap_8
X_5023_ net220 VGND VPWR _0480_ videogen.test_lut_thingy.pixel_feeder_inst.row\[57\]\[0\]
+ _0117_ sg13g2_dfrbpq_1
XFILLER_26_505 VPWR VGND sg13g2_fill_2
X_4945__179 VPWR VGND net179 sg13g2_tiehi
X_4923__400 VPWR VGND net400 sg13g2_tiehi
X_5045__185 VPWR VGND net185 sg13g2_tiehi
XFILLER_0_1022 VPWR VGND sg13g2_decap_8
X_4807_ net171 VGND VPWR _0268_ serialize.shift_reg_b\[9\] clknet_3_0__leaf_clk_regs
+ sg13g2_dfrbpq_1
XFILLER_22_766 VPWR VGND sg13g2_decap_8
XFILLER_21_265 VPWR VGND sg13g2_decap_8
X_2999_ videogen.test_lut_thingy.pixel_feeder_inst.row\[19\]\[0\] net800 _0823_ _0282_
+ VPWR VGND sg13g2_mux2_1
X_4738_ net670 net714 _0202_ VPWR VGND sg13g2_nor2_1
X_5017__232 VPWR VGND net232 sg13g2_tiehi
X_4669_ net684 net728 _0133_ VPWR VGND sg13g2_nor2_1
Xclkbuf_1_1__f_clk clknet_0_clk clknet_1_1__leaf_clk VPWR VGND sg13g2_buf_8
XFILLER_29_321 VPWR VGND sg13g2_decap_4
XFILLER_29_343 VPWR VGND sg13g2_fill_2
XFILLER_29_354 VPWR VGND sg13g2_decap_8
XFILLER_45_814 VPWR VGND sg13g2_decap_8
XFILLER_28_87 VPWR VGND sg13g2_decap_8
XFILLER_28_98 VPWR VGND sg13g2_fill_1
XFILLER_29_365 VPWR VGND sg13g2_fill_1
XFILLER_44_335 VPWR VGND sg13g2_decap_8
XFILLER_32_508 VPWR VGND sg13g2_fill_1
XFILLER_40_530 VPWR VGND sg13g2_fill_1
XFILLER_9_715 VPWR VGND sg13g2_fill_1
XFILLER_9_759 VPWR VGND sg13g2_decap_8
XFILLER_5_987 VPWR VGND sg13g2_decap_8
XFILLER_39_107 VPWR VGND sg13g2_fill_2
XFILLER_39_118 VPWR VGND sg13g2_fill_2
XFILLER_0_670 VPWR VGND sg13g2_decap_8
XFILLER_48_641 VPWR VGND sg13g2_decap_8
XFILLER_47_140 VPWR VGND sg13g2_fill_1
XFILLER_36_803 VPWR VGND sg13g2_decap_8
XFILLER_48_685 VPWR VGND sg13g2_decap_8
XFILLER_36_858 VPWR VGND sg13g2_decap_8
XFILLER_36_869 VPWR VGND sg13g2_fill_2
X_3971_ VPWR _1682_ _1681_ VGND sg13g2_inv_1
X_2922_ videogen.test_lut_thingy.pixel_feeder_inst.row\[30\]\[2\] net777 _0808_ _0438_
+ VPWR VGND sg13g2_mux2_1
X_2853_ videogen.test_lut_thingy.pixel_feeder_inst.row\[2\]\[3\] net769 _0792_ _0500_
+ VPWR VGND sg13g2_mux2_1
X_2784_ videogen.test_lut_thingy.pixel_feeder_inst.row\[47\]\[2\] net773 _0778_ _0555_
+ VPWR VGND sg13g2_mux2_1
X_4523_ _2176_ net661 net475 net666 red_tmds_par\[1\] VPWR VGND sg13g2_a22oi_1
X_4454_ _2132_ tmds_blue.dc_balancing_reg\[4\] _2133_ VPWR VGND sg13g2_xor2_1
Xfanout705 net711 net705 VPWR VGND sg13g2_buf_8
X_4385_ _2066_ net608 _2067_ VPWR VGND sg13g2_xor2_1
X_3405_ _1118_ _1122_ _1112_ _1123_ VPWR VGND sg13g2_mux2_1
Xfanout749 net756 net749 VPWR VGND sg13g2_buf_8
Xfanout727 net730 net727 VPWR VGND sg13g2_buf_8
Xfanout738 net740 net738 VPWR VGND sg13g2_buf_1
X_3336_ VPWR VGND _1051_ _1053_ _0999_ videogen.fancy_shader.video_y\[3\] _1054_ videogen.fancy_shader.shader_counter_reg\[3\]
+ sg13g2_a221oi_1
Xfanout716 net717 net716 VPWR VGND sg13g2_buf_8
X_3267_ VGND VPWR _0836_ _0884_ _0986_ _0701_ sg13g2_a21oi_1
X_5006_ net254 VGND VPWR _0463_ videogen.test_lut_thingy.pixel_feeder_inst.row\[62\]\[3\]
+ _0100_ sg13g2_dfrbpq_1
X_3198_ _0939_ net551 _0941_ _0332_ VPWR VGND sg13g2_nor3_1
XFILLER_26_324 VPWR VGND sg13g2_decap_4
XFILLER_26_379 VPWR VGND sg13g2_fill_2
XFILLER_41_338 VPWR VGND sg13g2_decap_8
XFILLER_35_880 VPWR VGND sg13g2_decap_4
XFILLER_14_34 VPWR VGND sg13g2_fill_2
XFILLER_22_530 VPWR VGND sg13g2_decap_8
XFILLER_14_78 VPWR VGND sg13g2_fill_1
X_4934__381 VPWR VGND net381 sg13g2_tiehi
XFILLER_2_935 VPWR VGND sg13g2_decap_8
XFILLER_45_600 VPWR VGND sg13g2_fill_1
XFILLER_29_140 VPWR VGND sg13g2_decap_8
XFILLER_44_143 VPWR VGND sg13g2_fill_1
XFILLER_17_357 VPWR VGND sg13g2_decap_8
XFILLER_44_187 VPWR VGND sg13g2_fill_2
XFILLER_13_541 VPWR VGND sg13g2_decap_4
XFILLER_40_360 VPWR VGND sg13g2_fill_2
XFILLER_9_512 VPWR VGND sg13g2_fill_2
XFILLER_40_393 VPWR VGND sg13g2_decap_8
X_5152__364 VPWR VGND net364 sg13g2_tiehi
X_4170_ red\[2\] red\[0\] _1876_ VPWR VGND sg13g2_xor2_1
X_3121_ videogen.fancy_shader.video_x\[8\] _0887_ _0889_ VPWR VGND sg13g2_and2_1
XFILLER_49_994 VPWR VGND sg13g2_decap_8
X_3052_ _0858_ videogen.test_lut_thingy.pixel_feeder_inst.v_pix\[0\] net553 _0719_
+ VPWR VGND sg13g2_and3_2
XFILLER_48_493 VPWR VGND sg13g2_decap_8
XFILLER_35_121 VPWR VGND sg13g2_decap_8
XFILLER_23_327 VPWR VGND sg13g2_decap_4
XFILLER_24_839 VPWR VGND sg13g2_decap_8
XFILLER_35_198 VPWR VGND sg13g2_fill_2
X_3954_ VPWR _0364_ _1667_ VGND sg13g2_inv_1
X_3885_ _1093_ _1593_ _1599_ VPWR VGND sg13g2_nor2_2
X_2905_ _0739_ _0762_ _0805_ VPWR VGND sg13g2_nor2_2
XFILLER_31_360 VPWR VGND sg13g2_fill_2
X_2836_ videogen.test_lut_thingy.pixel_feeder_inst.row\[26\]\[0\] net797 _0788_ _0513_
+ VPWR VGND sg13g2_mux2_1
X_2767_ _0775_ net761 _0774_ VPWR VGND sg13g2_nand2_1
X_4506_ VPWR _0647_ _2167_ VGND sg13g2_inv_1
X_2698_ _0713_ _0732_ net603 _0750_ VPWR VGND sg13g2_nand3_1
X_4437_ _2072_ _2087_ net606 _2117_ VPWR VGND sg13g2_nand3_1
Xfanout546 _1090_ net546 VPWR VGND sg13g2_buf_8
Xfanout557 net560 net557 VPWR VGND sg13g2_buf_2
X_4368_ _2056_ _2053_ _2055_ VPWR VGND sg13g2_xnor2_1
X_3319_ VGND VPWR _1021_ _1036_ _1037_ _1020_ sg13g2_a21oi_1
Xfanout579 _0714_ net579 VPWR VGND sg13g2_buf_8
Xfanout568 net569 net568 VPWR VGND sg13g2_buf_2
X_4299_ net555 _1995_ _0390_ VPWR VGND sg13g2_nor2_1
XFILLER_42_658 VPWR VGND sg13g2_decap_8
XFILLER_6_526 VPWR VGND sg13g2_fill_2
XFILLER_10_555 VPWR VGND sg13g2_fill_2
XFILLER_10_577 VPWR VGND sg13g2_decap_8
XFILLER_2_732 VPWR VGND sg13g2_decap_8
XFILLER_49_246 VPWR VGND sg13g2_decap_8
XFILLER_46_975 VPWR VGND sg13g2_decap_8
XFILLER_32_168 VPWR VGND sg13g2_fill_1
XFILLER_12_1000 VPWR VGND sg13g2_decap_8
X_3670_ videogen.test_lut_thingy.pixel_feeder_inst.row\[53\]\[2\] net561 _1388_ VPWR
+ VGND sg13g2_nor2_1
X_2621_ videogen.fancy_shader.video_y\[8\] videogen.fancy_shader.video_y\[7\] _0674_
+ _0693_ VPWR VGND net611 sg13g2_nand4_1
XFILLER_5_581 VPWR VGND sg13g2_decap_4
X_4222_ _1927_ _1902_ _1911_ VPWR VGND sg13g2_nand2_1
X_4868__68 VPWR VGND net68 sg13g2_tiehi
X_4883__38 VPWR VGND net38 sg13g2_tiehi
X_4153_ net1 _1326_ _1864_ VPWR VGND sg13g2_nor2b_1
X_4084_ _1795_ _1693_ _1598_ VPWR VGND sg13g2_nand2b_1
X_3104_ VPWR _0880_ _0879_ VGND sg13g2_inv_1
XFILLER_49_791 VPWR VGND sg13g2_decap_8
X_3035_ _0830_ net552 net604 videogen.mem_row VPWR VGND sg13g2_a21o_2
XFILLER_37_975 VPWR VGND sg13g2_decap_8
XFILLER_24_614 VPWR VGND sg13g2_decap_8
X_4986_ net294 VGND VPWR _0443_ videogen.test_lut_thingy.pixel_feeder_inst.row\[10\]\[3\]
+ _0080_ sg13g2_dfrbpq_1
XFILLER_24_647 VPWR VGND sg13g2_fill_1
X_3937_ _1651_ _1629_ _1637_ VPWR VGND sg13g2_xnor2_1
XFILLER_32_691 VPWR VGND sg13g2_fill_2
X_3868_ _1582_ _0990_ _0998_ VPWR VGND sg13g2_nand2_2
XFILLER_20_853 VPWR VGND sg13g2_fill_1
XFILLER_20_886 VPWR VGND sg13g2_fill_1
X_2819_ videogen.test_lut_thingy.pixel_feeder_inst.row\[53\]\[2\] net778 _0785_ _0527_
+ VPWR VGND sg13g2_mux2_1
X_3799_ net616 _1505_ _1516_ _1517_ VPWR VGND sg13g2_nor3_1
XFILLER_3_507 VPWR VGND sg13g2_decap_8
XFILLER_11_79 VPWR VGND sg13g2_decap_8
XFILLER_19_419 VPWR VGND sg13g2_fill_1
XFILLER_28_986 VPWR VGND sg13g2_decap_8
XFILLER_36_54 VPWR VGND sg13g2_fill_2
XFILLER_43_956 VPWR VGND sg13g2_decap_8
XFILLER_14_157 VPWR VGND sg13g2_decap_8
XFILLER_14_168 VPWR VGND sg13g2_fill_2
XFILLER_42_499 VPWR VGND sg13g2_decap_8
XFILLER_7_813 VPWR VGND sg13g2_decap_8
XFILLER_22_190 VPWR VGND sg13g2_fill_1
XFILLER_7_846 VPWR VGND sg13g2_decap_4
XFILLER_6_334 VPWR VGND sg13g2_decap_8
XFILLER_10_363 VPWR VGND sg13g2_fill_1
XFILLER_6_378 VPWR VGND sg13g2_decap_8
XFILLER_6_345 VPWR VGND sg13g2_fill_2
XFILLER_42_1004 VPWR VGND sg13g2_decap_8
XFILLER_37_227 VPWR VGND sg13g2_decap_4
XFILLER_19_942 VPWR VGND sg13g2_decap_8
XFILLER_33_411 VPWR VGND sg13g2_fill_2
X_4840_ net122 VGND VPWR _0301_ videogen.fancy_shader.video_x\[9\] net640 sg13g2_dfrbpq_2
XFILLER_34_956 VPWR VGND sg13g2_decap_8
XFILLER_21_606 VPWR VGND sg13g2_fill_1
XFILLER_14_680 VPWR VGND sg13g2_fill_1
XFILLER_20_138 VPWR VGND sg13g2_decap_4
X_4771_ net680 net724 _0235_ VPWR VGND sg13g2_nor2_1
XFILLER_9_161 VPWR VGND sg13g2_decap_8
X_3722_ videogen.test_lut_thingy.pixel_feeder_inst.row\[47\]\[1\] net565 _1440_ VPWR
+ VGND sg13g2_nor2_1
X_3653_ _1367_ _1368_ _1369_ _1370_ _1371_ VPWR VGND sg13g2_nor4_1
XFILLER_9_172 VPWR VGND sg13g2_decap_4
X_2604_ _0677_ net809 VPWR VGND sg13g2_inv_2
X_3584_ videogen.test_lut_thingy.pixel_feeder_inst.row\[10\]\[3\] net591 _1302_ VPWR
+ VGND sg13g2_nor2_1
X_5185_ net55 VGND VPWR _0642_ serialize.shift_reg_b\[3\] clknet_3_3__leaf_clk_regs
+ sg13g2_dfrbpq_1
X_4205_ _1911_ _1908_ _1909_ VPWR VGND sg13g2_xnor2_1
X_4136_ _1847_ _0991_ _1157_ VPWR VGND sg13g2_xnor2_1
XFILLER_28_205 VPWR VGND sg13g2_decap_4
XFILLER_29_728 VPWR VGND sg13g2_decap_8
X_4961__344 VPWR VGND net344 sg13g2_tiehi
X_4067_ VGND VPWR _1758_ _1764_ _1778_ _1761_ sg13g2_a21oi_1
X_3018_ videogen.fancy_shader.video_x\[3\] _0833_ _0834_ VPWR VGND sg13g2_and2_1
XFILLER_36_260 VPWR VGND sg13g2_fill_1
XFILLER_25_989 VPWR VGND sg13g2_decap_8
X_4969_ net328 VGND VPWR _0426_ videogen.test_lut_thingy.pixel_feeder_inst.row\[32\]\[2\]
+ _0063_ sg13g2_dfrbpq_1
XFILLER_11_149 VPWR VGND sg13g2_decap_8
X_4851__102 VPWR VGND net102 sg13g2_tiehi
XFILLER_47_503 VPWR VGND sg13g2_decap_8
X_5027__212 VPWR VGND net212 sg13g2_tiehi
XFILLER_27_271 VPWR VGND sg13g2_decap_4
XFILLER_42_252 VPWR VGND sg13g2_fill_2
XFILLER_16_989 VPWR VGND sg13g2_decap_8
XFILLER_30_414 VPWR VGND sg13g2_fill_1
XFILLER_3_860 VPWR VGND sg13g2_decap_8
XFILLER_26_4 VPWR VGND sg13g2_decap_8
XFILLER_38_536 VPWR VGND sg13g2_fill_1
X_4828__137 VPWR VGND net137 sg13g2_tiehi
XFILLER_19_783 VPWR VGND sg13g2_decap_8
XFILLER_22_948 VPWR VGND sg13g2_decap_8
X_4823_ net145 VGND VPWR _0284_ videogen.test_lut_thingy.pixel_feeder_inst.row\[19\]\[2\]
+ _0015_ sg13g2_dfrbpq_1
X_4754_ net697 net741 _0218_ VPWR VGND sg13g2_nor2_1
X_3705_ _1423_ _0689_ videogen.test_lut_thingy.gol_counter_reg\[2\] VPWR VGND sg13g2_nand2_1
X_4685_ net695 net739 _0149_ VPWR VGND sg13g2_nor2_1
X_3636_ videogen.test_lut_thingy.pixel_feeder_inst.row\[22\]\[2\] net590 _1354_ VPWR
+ VGND sg13g2_nor2_1
X_3567_ videogen.test_lut_thingy.pixel_feeder_inst.row\[17\]\[3\] net562 _1285_ VPWR
+ VGND sg13g2_nor2_1
X_4989__288 VPWR VGND net288 sg13g2_tiehi
XFILLER_0_329 VPWR VGND sg13g2_decap_8
X_3498_ _1157_ _1205_ _1216_ VPWR VGND sg13g2_and2_1
XFILLER_25_1010 VPWR VGND sg13g2_decap_8
X_5168_ net267 VGND VPWR _0625_ videogen.test_lut_thingy.pixel_feeder_inst.row\[25\]\[2\]
+ _0243_ sg13g2_dfrbpq_1
X_5099_ net317 VGND VPWR _0556_ videogen.test_lut_thingy.pixel_feeder_inst.row\[47\]\[3\]
+ _0184_ sg13g2_dfrbpq_1
X_4119_ _1823_ _1824_ _1822_ _1830_ VPWR VGND _1829_ sg13g2_nand4_1
XFILLER_40_701 VPWR VGND sg13g2_decap_4
XFILLER_12_403 VPWR VGND sg13g2_fill_1
XFILLER_13_926 VPWR VGND sg13g2_decap_8
XFILLER_24_241 VPWR VGND sg13g2_decap_8
XFILLER_33_11 VPWR VGND sg13g2_fill_2
XFILLER_33_33 VPWR VGND sg13g2_fill_1
XFILLER_32_1003 VPWR VGND sg13g2_decap_8
XFILLER_33_44 VPWR VGND sg13g2_decap_8
XFILLER_4_635 VPWR VGND sg13g2_decap_8
XFILLER_4_602 VPWR VGND sg13g2_fill_1
XFILLER_4_646 VPWR VGND sg13g2_fill_1
XFILLER_48_845 VPWR VGND sg13g2_decap_8
Xhold7 serialize.shift_reg_c\[4\] VPWR VGND net453 sg13g2_dlygate4sd3_1
XFILLER_0_896 VPWR VGND sg13g2_decap_8
X_4944__361 VPWR VGND net361 sg13g2_tiehi
XFILLER_28_591 VPWR VGND sg13g2_fill_2
XFILLER_15_241 VPWR VGND sg13g2_fill_2
XFILLER_15_252 VPWR VGND sg13g2_fill_1
XFILLER_31_745 VPWR VGND sg13g2_fill_1
X_4470_ _2146_ net810 _2139_ VPWR VGND sg13g2_nand2_1
XFILLER_8_985 VPWR VGND sg13g2_decap_8
X_3421_ _1139_ _0999_ _1000_ VPWR VGND sg13g2_xnor2_1
X_3352_ _1070_ videogen.fancy_shader.video_x\[9\] videogen.fancy_shader.shader_counter_reg\[9\]
+ VPWR VGND sg13g2_xnor2_1
X_3283_ VGND VPWR _0999_ _1000_ _1001_ _0995_ sg13g2_a21oi_1
X_5022_ net222 VGND VPWR _0479_ videogen.test_lut_thingy.pixel_feeder_inst.row\[56\]\[3\]
+ _0116_ sg13g2_dfrbpq_1
XFILLER_17_0 VPWR VGND sg13g2_decap_4
XFILLER_0_1001 VPWR VGND sg13g2_decap_8
XFILLER_38_399 VPWR VGND sg13g2_fill_1
XFILLER_19_591 VPWR VGND sg13g2_decap_8
XFILLER_0_92 VPWR VGND sg13g2_decap_8
XFILLER_21_211 VPWR VGND sg13g2_decap_8
X_4806_ net172 VGND VPWR _0267_ serialize.shift_reg_b\[8\] clknet_3_1__leaf_clk_regs
+ sg13g2_dfrbpq_1
XFILLER_21_288 VPWR VGND sg13g2_decap_8
X_2998_ videogen.test_lut_thingy.pixel_feeder_inst.row\[19\]\[1\] net790 _0823_ _0283_
+ VPWR VGND sg13g2_mux2_1
X_4737_ net670 net714 _0201_ VPWR VGND sg13g2_nor2_1
X_4668_ net690 net734 _0132_ VPWR VGND sg13g2_nor2_1
X_3619_ _1333_ _1334_ _1335_ _1336_ _1337_ VPWR VGND sg13g2_nor4_1
X_4599_ net688 net732 _0063_ VPWR VGND sg13g2_nor2_1
XFILLER_0_126 VPWR VGND sg13g2_decap_8
XFILLER_17_528 VPWR VGND sg13g2_decap_4
XFILLER_29_399 VPWR VGND sg13g2_decap_8
XFILLER_9_705 VPWR VGND sg13g2_decap_4
XFILLER_9_727 VPWR VGND sg13g2_decap_8
XFILLER_12_222 VPWR VGND sg13g2_decap_8
XFILLER_12_233 VPWR VGND sg13g2_fill_1
XFILLER_5_966 VPWR VGND sg13g2_fill_1
XFILLER_5_955 VPWR VGND sg13g2_decap_8
XFILLER_4_487 VPWR VGND sg13g2_fill_1
XFILLER_48_664 VPWR VGND sg13g2_decap_8
X_3970_ _1679_ _1680_ _1681_ VPWR VGND sg13g2_and2_1
X_2921_ videogen.test_lut_thingy.pixel_feeder_inst.row\[30\]\[3\] net765 _0808_ _0439_
+ VPWR VGND sg13g2_mux2_1
XFILLER_44_881 VPWR VGND sg13g2_fill_1
XFILLER_31_531 VPWR VGND sg13g2_decap_4
XFILLER_31_542 VPWR VGND sg13g2_fill_1
X_5640_ net603 net12 VPWR VGND sg13g2_buf_8
X_2852_ _0762_ _0768_ _0792_ VPWR VGND sg13g2_nor2_2
X_2783_ videogen.test_lut_thingy.pixel_feeder_inst.row\[47\]\[3\] net761 _0778_ _0556_
+ VPWR VGND sg13g2_mux2_1
X_4522_ VPWR _0655_ _2175_ VGND sg13g2_inv_1
XFILLER_8_782 VPWR VGND sg13g2_fill_2
X_4453_ tmds_blue.dc_balancing_reg\[3\] net607 _2081_ _2132_ VPWR VGND sg13g2_mux2_1
X_3404_ VGND VPWR _1112_ _1120_ _1122_ _1118_ sg13g2_a21oi_1
X_4384_ VGND VPWR _2066_ _2065_ _2061_ sg13g2_or2_1
Xfanout706 net710 net706 VPWR VGND sg13g2_buf_8
Xfanout728 net730 net728 VPWR VGND sg13g2_buf_1
X_3335_ _0993_ _0995_ _1053_ VPWR VGND sg13g2_nor2b_1
Xfanout739 net740 net739 VPWR VGND sg13g2_buf_8
Xfanout717 net736 net717 VPWR VGND sg13g2_buf_8
X_3266_ VGND VPWR _0985_ _0884_ _0702_ sg13g2_or2_1
X_5005_ net256 VGND VPWR _0462_ videogen.test_lut_thingy.pixel_feeder_inst.row\[62\]\[2\]
+ _0099_ sg13g2_dfrbpq_1
XFILLER_39_675 VPWR VGND sg13g2_decap_8
X_3197_ VGND VPWR videogen.fancy_shader.shader_counter_reg\[0\] _0937_ _0941_ videogen.fancy_shader.shader_counter_reg\[1\]
+ sg13g2_a21oi_1
XFILLER_26_358 VPWR VGND sg13g2_fill_1
XFILLER_22_553 VPWR VGND sg13g2_decap_4
XFILLER_14_46 VPWR VGND sg13g2_decap_8
X_4958__349 VPWR VGND net349 sg13g2_tiehi
XFILLER_6_708 VPWR VGND sg13g2_decap_8
XFILLER_30_34 VPWR VGND sg13g2_fill_1
XFILLER_30_56 VPWR VGND sg13g2_fill_1
XFILLER_2_914 VPWR VGND sg13g2_decap_8
XFILLER_49_439 VPWR VGND sg13g2_decap_8
XFILLER_7_1018 VPWR VGND sg13g2_decap_8
XFILLER_18_815 VPWR VGND sg13g2_decap_4
XFILLER_29_196 VPWR VGND sg13g2_fill_1
XFILLER_33_829 VPWR VGND sg13g2_decap_8
XFILLER_26_870 VPWR VGND sg13g2_fill_2
XFILLER_41_895 VPWR VGND sg13g2_fill_2
X_3120_ _0879_ _0887_ _0888_ _0299_ VPWR VGND sg13g2_nor3_1
XFILLER_49_973 VPWR VGND sg13g2_decap_8
XFILLER_48_472 VPWR VGND sg13g2_decap_8
X_3051_ net603 VPWR _0857_ VGND _0855_ _0856_ sg13g2_o21ai_1
XFILLER_24_818 VPWR VGND sg13g2_decap_8
X_3953_ net807 VPWR _1667_ VGND _1663_ _1666_ sg13g2_o21ai_1
X_2904_ videogen.test_lut_thingy.pixel_feeder_inst.row\[8\]\[0\] net803 _0804_ _0452_
+ VPWR VGND sg13g2_mux2_1
X_3884_ _1598_ net546 _1592_ VPWR VGND sg13g2_xnor2_1
X_2835_ videogen.test_lut_thingy.pixel_feeder_inst.row\[26\]\[1\] net786 _0788_ _0514_
+ VPWR VGND sg13g2_mux2_1
X_2766_ _0765_ _0773_ _0774_ VPWR VGND sg13g2_nor2_2
X_4505_ _2167_ net661 net455 net666 green_tmds_par\[0\] VPWR VGND sg13g2_a22oi_1
X_2697_ _0749_ _0713_ _0732_ VPWR VGND sg13g2_nand2_2
X_4436_ _2116_ _2114_ _2115_ _2108_ _2063_ VPWR VGND sg13g2_a22oi_1
X_4367_ _2055_ tmds_green.dc_balancing_reg\[4\] _2054_ VPWR VGND sg13g2_xnor2_1
X_3318_ _1028_ VPWR _1036_ VGND _1031_ _1035_ sg13g2_o21ai_1
Xfanout547 _1062_ net547 VPWR VGND sg13g2_buf_8
X_4888__443 VPWR VGND net443 sg13g2_tiehi
Xfanout558 net560 net558 VPWR VGND sg13g2_buf_8
Xfanout569 net574 net569 VPWR VGND sg13g2_buf_8
X_4298_ _1995_ _1991_ _1994_ VPWR VGND sg13g2_xnor2_1
X_3249_ _0975_ _0974_ videogen.fancy_shader.video_y\[7\] VPWR VGND sg13g2_nand2b_1
XFILLER_26_100 VPWR VGND sg13g2_fill_1
XFILLER_41_103 VPWR VGND sg13g2_fill_1
XFILLER_25_23 VPWR VGND sg13g2_decap_8
XFILLER_25_34 VPWR VGND sg13g2_fill_2
XFILLER_26_177 VPWR VGND sg13g2_decap_8
XFILLER_26_188 VPWR VGND sg13g2_decap_8
XFILLER_23_895 VPWR VGND sg13g2_decap_8
XFILLER_10_567 VPWR VGND sg13g2_fill_1
X_4971__324 VPWR VGND net324 sg13g2_tiehi
XFILLER_2_711 VPWR VGND sg13g2_decap_8
XFILLER_29_1008 VPWR VGND sg13g2_decap_8
XFILLER_2_788 VPWR VGND sg13g2_decap_8
XFILLER_49_225 VPWR VGND sg13g2_decap_8
XFILLER_18_601 VPWR VGND sg13g2_fill_1
XFILLER_46_954 VPWR VGND sg13g2_decap_8
XFILLER_32_136 VPWR VGND sg13g2_fill_1
XFILLER_9_332 VPWR VGND sg13g2_fill_1
XFILLER_9_376 VPWR VGND sg13g2_decap_4
X_2620_ _0692_ net628 VPWR VGND net632 sg13g2_nand2b_2
X_4221_ VGND VPWR _1903_ _1925_ _0371_ _1926_ sg13g2_a21oi_1
X_4152_ _1425_ _1520_ _1863_ VPWR VGND sg13g2_nor2_1
X_3103_ _0879_ net807 _0878_ VPWR VGND sg13g2_nand2_2
X_4083_ _1794_ _1598_ _1694_ VPWR VGND sg13g2_nand2_1
X_3034_ VGND VPWR _0842_ _0847_ _0002_ _0358_ sg13g2_a21oi_1
XFILLER_37_954 VPWR VGND sg13g2_decap_8
XFILLER_24_637 VPWR VGND sg13g2_fill_1
X_4985_ net296 VGND VPWR _0442_ videogen.test_lut_thingy.pixel_feeder_inst.row\[10\]\[2\]
+ _0079_ sg13g2_dfrbpq_1
X_3936_ _0992_ _1649_ _1650_ VPWR VGND sg13g2_and2_1
XFILLER_20_821 VPWR VGND sg13g2_fill_2
X_3867_ VGND VPWR _1230_ _1581_ _0362_ net758 sg13g2_a21oi_1
XFILLER_31_180 VPWR VGND sg13g2_fill_1
X_5170__251 VPWR VGND net251 sg13g2_tiehi
X_3798_ net625 _1510_ _1515_ _1516_ VPWR VGND sg13g2_nor3_1
X_2818_ videogen.test_lut_thingy.pixel_feeder_inst.row\[53\]\[3\] net767 _0785_ _0528_
+ VPWR VGND sg13g2_mux2_1
X_2749_ videogen.test_lut_thingy.pixel_feeder_inst.row\[41\]\[2\] net775 _0767_ _0579_
+ VPWR VGND sg13g2_mux2_1
X_4419_ _2100_ _2098_ _2099_ _2089_ _2065_ VPWR VGND sg13g2_a22oi_1
XFILLER_19_409 VPWR VGND sg13g2_decap_4
XFILLER_27_431 VPWR VGND sg13g2_fill_1
XFILLER_28_965 VPWR VGND sg13g2_decap_8
XFILLER_43_935 VPWR VGND sg13g2_decap_8
XFILLER_15_659 VPWR VGND sg13g2_fill_2
X_4999__268 VPWR VGND net268 sg13g2_tiehi
XFILLER_30_607 VPWR VGND sg13g2_decap_8
XFILLER_35_1023 VPWR VGND sg13g2_decap_4
XFILLER_11_865 VPWR VGND sg13g2_fill_2
XFILLER_2_552 VPWR VGND sg13g2_fill_2
XFILLER_19_921 VPWR VGND sg13g2_decap_8
XFILLER_18_464 VPWR VGND sg13g2_decap_4
XFILLER_19_998 VPWR VGND sg13g2_decap_8
XFILLER_34_935 VPWR VGND sg13g2_decap_8
XFILLER_42_990 VPWR VGND sg13g2_decap_8
X_4770_ net683 net727 _0234_ VPWR VGND sg13g2_nor2_1
X_3721_ videogen.test_lut_thingy.pixel_feeder_inst.row\[45\]\[1\] net556 _1439_ VPWR
+ VGND sg13g2_nor2_1
X_3652_ videogen.test_lut_thingy.pixel_feeder_inst.row\[28\]\[2\] net578 _1370_ VPWR
+ VGND sg13g2_nor2_1
X_3583_ net598 VPWR _1301_ VGND videogen.test_lut_thingy.pixel_feeder_inst.row\[9\]\[3\]
+ net562 sg13g2_o21ai_1
XFILLER_9_195 VPWR VGND sg13g2_decap_8
X_2603_ VPWR _0676_ videogen.fancy_shader.video_y\[3\] VGND sg13g2_inv_1
XFILLER_47_0 VPWR VGND sg13g2_decap_8
X_5184_ net63 VGND VPWR _0641_ serialize.shift_reg_b\[2\] clknet_3_3__leaf_clk_regs
+ sg13g2_dfrbpq_1
X_4204_ _1908_ _1909_ _1910_ VPWR VGND sg13g2_nor2_1
X_4135_ _1846_ _1844_ _1845_ VPWR VGND sg13g2_xnor2_1
XFILLER_29_707 VPWR VGND sg13g2_fill_2
XFILLER_3_1021 VPWR VGND sg13g2_decap_8
XFILLER_28_239 VPWR VGND sg13g2_fill_1
X_4066_ _1774_ _1775_ _1772_ _1777_ VPWR VGND sg13g2_nand3_1
XFILLER_25_902 VPWR VGND sg13g2_decap_8
XFILLER_43_209 VPWR VGND sg13g2_decap_8
XFILLER_37_784 VPWR VGND sg13g2_decap_8
X_3017_ _0833_ videogen.fancy_shader.video_x\[2\] videogen.fancy_shader.video_x\[1\]
+ net637 VPWR VGND sg13g2_and3_1
XFILLER_25_968 VPWR VGND sg13g2_decap_8
XFILLER_11_128 VPWR VGND sg13g2_decap_8
X_4968_ net330 VGND VPWR _0425_ videogen.test_lut_thingy.pixel_feeder_inst.row\[32\]\[1\]
+ _0062_ sg13g2_dfrbpq_1
X_3919_ _1632_ _1610_ _1633_ VPWR VGND sg13g2_xor2_1
X_4899_ net428 VGND VPWR _0360_ blue\[0\] net646 sg13g2_dfrbpq_1
XFILLER_4_806 VPWR VGND sg13g2_decap_8
XFILLER_22_68 VPWR VGND sg13g2_fill_1
XFILLER_47_21 VPWR VGND sg13g2_decap_8
XFILLER_47_43 VPWR VGND sg13g2_decap_8
XFILLER_47_559 VPWR VGND sg13g2_fill_1
X_4855__94 VPWR VGND net94 sg13g2_tiehi
XFILLER_19_239 VPWR VGND sg13g2_decap_8
X_4870__64 VPWR VGND net64 sg13g2_tiehi
XFILLER_28_773 VPWR VGND sg13g2_decap_8
XFILLER_16_968 VPWR VGND sg13g2_decap_8
XFILLER_7_600 VPWR VGND sg13g2_fill_2
XFILLER_7_633 VPWR VGND sg13g2_decap_8
XFILLER_10_183 VPWR VGND sg13g2_fill_1
XFILLER_6_165 VPWR VGND sg13g2_decap_4
XFILLER_6_187 VPWR VGND sg13g2_decap_4
XFILLER_38_548 VPWR VGND sg13g2_decap_8
XFILLER_19_740 VPWR VGND sg13g2_decap_4
XFILLER_18_250 VPWR VGND sg13g2_fill_1
XFILLER_22_927 VPWR VGND sg13g2_decap_8
X_4822_ net147 VGND VPWR _0283_ videogen.test_lut_thingy.pixel_feeder_inst.row\[19\]\[1\]
+ _0014_ sg13g2_dfrbpq_1
X_4753_ net698 net742 _0217_ VPWR VGND sg13g2_nor2_1
X_3704_ net2 VPWR _1422_ VGND _1397_ _1421_ sg13g2_o21ai_1
XFILLER_30_982 VPWR VGND sg13g2_decap_8
X_4684_ net696 net740 _0148_ VPWR VGND sg13g2_nor2_1
X_3635_ videogen.test_lut_thingy.pixel_feeder_inst.row\[21\]\[2\] net561 _1353_ VPWR
+ VGND sg13g2_nor2_1
X_3566_ videogen.test_lut_thingy.pixel_feeder_inst.row\[19\]\[3\] net572 _1284_ VPWR
+ VGND sg13g2_nor2_1
XFILLER_0_308 VPWR VGND sg13g2_fill_2
X_3497_ _1215_ _1157_ _1214_ VPWR VGND sg13g2_nand2_1
X_5167_ net275 VGND VPWR _0624_ videogen.test_lut_thingy.pixel_feeder_inst.row\[25\]\[1\]
+ _0242_ sg13g2_dfrbpq_1
X_5098_ net321 VGND VPWR _0555_ videogen.test_lut_thingy.pixel_feeder_inst.row\[47\]\[2\]
+ _0183_ sg13g2_dfrbpq_1
X_4118_ _1820_ _1828_ _1829_ VPWR VGND sg13g2_and2_1
X_4049_ _1760_ _1733_ _1759_ VPWR VGND sg13g2_xnor2_1
XFILLER_25_721 VPWR VGND sg13g2_decap_8
XFILLER_21_982 VPWR VGND sg13g2_decap_8
XFILLER_0_875 VPWR VGND sg13g2_decap_8
XFILLER_48_824 VPWR VGND sg13g2_decap_8
Xhold8 serialize.shift_reg_c\[6\] VPWR VGND net454 sg13g2_dlygate4sd3_1
XFILLER_16_732 VPWR VGND sg13g2_fill_1
XFILLER_28_570 VPWR VGND sg13g2_decap_8
XFILLER_15_231 VPWR VGND sg13g2_fill_1
XFILLER_8_964 VPWR VGND sg13g2_decap_8
XFILLER_7_441 VPWR VGND sg13g2_fill_2
XFILLER_12_993 VPWR VGND sg13g2_decap_8
X_3420_ _1009_ _1008_ _1138_ VPWR VGND sg13g2_xor2_1
X_3351_ VGND VPWR _1067_ _1068_ _1069_ _1063_ sg13g2_a21oi_1
X_3282_ videogen.fancy_shader.shader_counter_reg\[2\] videogen.fancy_shader.video_y\[2\]
+ _1000_ VPWR VGND sg13g2_xor2_1
XFILLER_38_312 VPWR VGND sg13g2_fill_2
X_5021_ net224 VGND VPWR _0478_ videogen.test_lut_thingy.pixel_feeder_inst.row\[56\]\[2\]
+ _0115_ sg13g2_dfrbpq_1
XFILLER_26_507 VPWR VGND sg13g2_fill_1
XFILLER_19_570 VPWR VGND sg13g2_fill_2
XFILLER_22_702 VPWR VGND sg13g2_fill_2
XFILLER_22_724 VPWR VGND sg13g2_decap_4
X_4805_ net173 VGND VPWR _0266_ serialize.shift_reg_g\[9\] clknet_3_3__leaf_clk_regs
+ sg13g2_dfrbpq_1
XFILLER_21_223 VPWR VGND sg13g2_decap_4
XFILLER_21_278 VPWR VGND sg13g2_decap_4
X_2997_ videogen.test_lut_thingy.pixel_feeder_inst.row\[19\]\[2\] net778 _0823_ _0284_
+ VPWR VGND sg13g2_mux2_1
XFILLER_9_91 VPWR VGND sg13g2_decap_4
X_4736_ net682 net726 _0200_ VPWR VGND sg13g2_nor2_1
X_4667_ net689 net733 _0131_ VPWR VGND sg13g2_nor2_1
X_3618_ videogen.test_lut_thingy.pixel_feeder_inst.row\[3\]\[2\] net573 _1336_ VPWR
+ VGND sg13g2_nor2_1
X_4598_ net688 net732 _0062_ VPWR VGND sg13g2_nor2_1
X_3549_ videogen.test_lut_thingy.pixel_feeder_inst.row\[38\]\[3\] net586 _1267_ VPWR
+ VGND sg13g2_nor2_1
XFILLER_28_56 VPWR VGND sg13g2_fill_1
XFILLER_17_507 VPWR VGND sg13g2_fill_2
XFILLER_25_551 VPWR VGND sg13g2_decap_8
XFILLER_44_55 VPWR VGND sg13g2_fill_1
XFILLER_40_521 VPWR VGND sg13g2_decap_8
XFILLER_40_576 VPWR VGND sg13g2_fill_2
XFILLER_12_267 VPWR VGND sg13g2_fill_2
XFILLER_21_790 VPWR VGND sg13g2_decap_8
XFILLER_5_934 VPWR VGND sg13g2_decap_8
X_4981__304 VPWR VGND net304 sg13g2_tiehi
XFILLER_10_8 VPWR VGND sg13g2_fill_1
X_5179__138 VPWR VGND net138 sg13g2_tiehi
XFILLER_36_849 VPWR VGND sg13g2_decap_4
X_2920_ _0735_ _0756_ _0808_ VPWR VGND sg13g2_nor2_2
XFILLER_16_562 VPWR VGND sg13g2_decap_8
XFILLER_16_595 VPWR VGND sg13g2_fill_2
X_2851_ videogen.test_lut_thingy.pixel_feeder_inst.row\[28\]\[0\] net798 _0791_ _0501_
+ VPWR VGND sg13g2_mux2_1
X_2782_ _0760_ _0765_ _0778_ VPWR VGND sg13g2_nor2_2
X_4521_ _2175_ net661 net463 net666 red_tmds_par\[0\] VPWR VGND sg13g2_a22oi_1
XFILLER_8_761 VPWR VGND sg13g2_fill_2
X_4452_ VGND VPWR _2111_ _2113_ _2131_ _2110_ sg13g2_a21oi_1
X_3403_ _1120_ VPWR _1121_ VGND _1112_ _1118_ sg13g2_o21ai_1
X_4383_ _2065_ tmds_blue.dc_balancing_reg\[4\] blue\[1\] VPWR VGND sg13g2_xnor2_1
Xfanout729 net730 net729 VPWR VGND sg13g2_buf_8
Xfanout718 net723 net718 VPWR VGND sg13g2_buf_8
X_3334_ VPWR _1052_ _1051_ VGND sg13g2_inv_1
Xfanout707 net710 net707 VPWR VGND sg13g2_buf_8
XFILLER_39_610 VPWR VGND sg13g2_decap_8
X_3265_ VGND VPWR videogen.test_lut_thingy.gol_counter_reg\[3\] _0983_ _0356_ _0984_
+ sg13g2_a21oi_1
XFILLER_39_654 VPWR VGND sg13g2_decap_8
X_5004_ net258 VGND VPWR _0461_ videogen.test_lut_thingy.pixel_feeder_inst.row\[62\]\[1\]
+ _0098_ sg13g2_dfrbpq_1
XFILLER_22_1025 VPWR VGND sg13g2_decap_4
X_3196_ net806 _0827_ _0940_ VPWR VGND sg13g2_nor2_1
XFILLER_27_816 VPWR VGND sg13g2_decap_4
XFILLER_26_337 VPWR VGND sg13g2_fill_2
XFILLER_38_186 VPWR VGND sg13g2_decap_8
XFILLER_10_705 VPWR VGND sg13g2_decap_4
X_4719_ net669 net713 _0183_ VPWR VGND sg13g2_nor2_1
XFILLER_49_418 VPWR VGND sg13g2_decap_8
XFILLER_39_44 VPWR VGND sg13g2_decap_8
XFILLER_1_469 VPWR VGND sg13g2_decap_8
X_4848__108 VPWR VGND net108 sg13g2_tiehi
XFILLER_17_304 VPWR VGND sg13g2_fill_2
XFILLER_44_189 VPWR VGND sg13g2_fill_1
XFILLER_41_830 VPWR VGND sg13g2_fill_2
XFILLER_40_362 VPWR VGND sg13g2_fill_1
XFILLER_9_514 VPWR VGND sg13g2_fill_1
XFILLER_13_587 VPWR VGND sg13g2_fill_2
XFILLER_4_285 VPWR VGND sg13g2_fill_2
XFILLER_45_1014 VPWR VGND sg13g2_decap_8
XFILLER_1_981 VPWR VGND sg13g2_decap_8
XFILLER_49_952 VPWR VGND sg13g2_decap_8
X_3050_ _0719_ _0705_ _0856_ VPWR VGND sg13g2_nor2b_1
XFILLER_48_451 VPWR VGND sg13g2_decap_8
XFILLER_36_646 VPWR VGND sg13g2_fill_1
XFILLER_17_882 VPWR VGND sg13g2_decap_8
X_3952_ VGND VPWR _1326_ _1425_ _1666_ _1665_ sg13g2_a21oi_1
X_2903_ videogen.test_lut_thingy.pixel_feeder_inst.row\[8\]\[1\] net790 _0804_ _0453_
+ VPWR VGND sg13g2_mux2_1
X_3883_ _1595_ net547 _1597_ VPWR VGND sg13g2_xor2_1
X_2834_ videogen.test_lut_thingy.pixel_feeder_inst.row\[26\]\[2\] net776 _0788_ _0515_
+ VPWR VGND sg13g2_mux2_1
X_4957__350 VPWR VGND net350 sg13g2_tiehi
XFILLER_31_373 VPWR VGND sg13g2_decap_8
X_4504_ VPWR _0646_ _2166_ VGND sg13g2_inv_1
X_2765_ _0711_ _0736_ net604 _0773_ VPWR VGND sg13g2_nand3_1
XFILLER_6_70 VPWR VGND sg13g2_decap_4
X_2696_ _0747_ _0748_ VPWR VGND sg13g2_inv_4
X_4435_ net607 _2062_ _2115_ VPWR VGND sg13g2_nor2_1
X_4366_ VGND VPWR _0684_ _2004_ _2054_ _2003_ sg13g2_a21oi_1
X_3317_ VPWR _1035_ _1034_ VGND sg13g2_inv_1
Xfanout548 _1062_ net548 VPWR VGND sg13g2_buf_1
Xfanout559 net560 net559 VPWR VGND sg13g2_buf_8
X_4297_ _1994_ green\[6\] _1993_ VPWR VGND sg13g2_xnor2_1
XFILLER_39_440 VPWR VGND sg13g2_decap_8
X_3248_ _0349_ net807 _0973_ _0974_ VPWR VGND sg13g2_and3_1
X_3179_ _0922_ _0929_ _0317_ VPWR VGND sg13g2_nor2_1
XFILLER_23_830 VPWR VGND sg13g2_fill_2
XFILLER_35_690 VPWR VGND sg13g2_fill_1
XFILLER_23_874 VPWR VGND sg13g2_decap_8
XFILLER_41_23 VPWR VGND sg13g2_decap_8
XFILLER_41_67 VPWR VGND sg13g2_decap_8
XFILLER_6_528 VPWR VGND sg13g2_fill_1
XFILLER_2_767 VPWR VGND sg13g2_decap_8
XFILLER_2_39 VPWR VGND sg13g2_fill_1
XFILLER_46_933 VPWR VGND sg13g2_decap_8
XFILLER_17_112 VPWR VGND sg13g2_fill_1
XFILLER_13_340 VPWR VGND sg13g2_decap_4
XFILLER_13_373 VPWR VGND sg13g2_decap_8
X_4220_ net554 VPWR _1926_ VGND _1903_ _1925_ sg13g2_o21ai_1
X_4151_ _1860_ _1861_ _1862_ VPWR VGND _1789_ sg13g2_nand3b_1
X_3102_ net635 _0702_ _0826_ _0835_ _0878_ VPWR VGND sg13g2_or4_1
X_4082_ _1791_ _1792_ _1793_ VPWR VGND sg13g2_and2_1
X_3033_ _0840_ _0844_ net811 _0847_ VPWR VGND _0845_ sg13g2_nand4_1
XFILLER_36_421 VPWR VGND sg13g2_fill_1
XFILLER_36_465 VPWR VGND sg13g2_decap_8
X_4984_ net298 VGND VPWR _0441_ videogen.test_lut_thingy.pixel_feeder_inst.row\[10\]\[1\]
+ _0078_ sg13g2_dfrbpq_1
X_3935_ _1649_ _1638_ _1647_ VPWR VGND sg13g2_xnor2_1
XFILLER_20_866 VPWR VGND sg13g2_decap_4
X_3866_ _1327_ VPWR _1581_ VGND _1424_ _1580_ sg13g2_o21ai_1
X_3797_ _1511_ _1512_ _1513_ _1514_ _1515_ VPWR VGND sg13g2_nor4_1
X_2817_ _0752_ _0758_ _0785_ VPWR VGND sg13g2_nor2_2
X_2748_ videogen.test_lut_thingy.pixel_feeder_inst.row\[41\]\[3\] net763 _0767_ _0580_
+ VPWR VGND sg13g2_mux2_1
XFILLER_11_59 VPWR VGND sg13g2_decap_8
X_4418_ VGND VPWR _2096_ _2097_ _2099_ _2066_ sg13g2_a21oi_1
X_2679_ _0739_ _0736_ _0738_ VPWR VGND sg13g2_nand2_2
X_4349_ _2038_ _2036_ _2037_ VPWR VGND sg13g2_xnor2_1
X_4867__70 VPWR VGND net70 sg13g2_tiehi
X_4882__40 VPWR VGND net40 sg13g2_tiehi
XFILLER_36_12 VPWR VGND sg13g2_fill_2
XFILLER_36_56 VPWR VGND sg13g2_fill_1
XFILLER_42_435 VPWR VGND sg13g2_decap_8
XFILLER_35_1002 VPWR VGND sg13g2_decap_8
XFILLER_23_671 VPWR VGND sg13g2_decap_4
XFILLER_23_693 VPWR VGND sg13g2_decap_4
XFILLER_6_303 VPWR VGND sg13g2_decap_8
XFILLER_2_586 VPWR VGND sg13g2_decap_8
XFILLER_28_9 VPWR VGND sg13g2_decap_8
XFILLER_18_410 VPWR VGND sg13g2_decap_8
XFILLER_19_977 VPWR VGND sg13g2_decap_8
X_5004__258 VPWR VGND net258 sg13g2_tiehi
XFILLER_33_413 VPWR VGND sg13g2_fill_1
XFILLER_33_468 VPWR VGND sg13g2_decap_4
X_3720_ videogen.test_lut_thingy.pixel_feeder_inst.row\[46\]\[1\] net585 _1438_ VPWR
+ VGND sg13g2_nor2_1
XFILLER_20_107 VPWR VGND sg13g2_fill_1
XFILLER_13_170 VPWR VGND sg13g2_decap_8
X_3651_ videogen.test_lut_thingy.pixel_feeder_inst.row\[29\]\[2\] net559 _1369_ VPWR
+ VGND sg13g2_nor2_1
X_4954__353 VPWR VGND net353 sg13g2_tiehi
X_2602_ VPWR _0675_ videogen.fancy_shader.video_y\[8\] VGND sg13g2_inv_1
X_3582_ _0678_ _1288_ _1299_ _1300_ VPWR VGND sg13g2_nor3_1
XFILLER_6_870 VPWR VGND sg13g2_decap_4
X_5183_ net71 VGND VPWR _0640_ serialize.shift_reg_b\[1\] clknet_3_6__leaf_clk_regs
+ sg13g2_dfrbpq_1
X_4203_ VGND VPWR _1879_ _1901_ _1909_ _1900_ sg13g2_a21oi_1
X_4134_ _1836_ _1825_ _1845_ VPWR VGND sg13g2_xor2_1
XFILLER_3_1000 VPWR VGND sg13g2_decap_8
X_4065_ _1776_ _1774_ _1775_ VPWR VGND sg13g2_nand2_1
X_3016_ _0832_ videogen.test_lut_thingy.pixel_feeder_inst.h_counter\[3\] _0830_ _0831_
+ VPWR VGND sg13g2_and3_1
XFILLER_25_947 VPWR VGND sg13g2_decap_8
XFILLER_19_1019 VPWR VGND sg13g2_decap_4
X_4967_ net332 VGND VPWR _0424_ videogen.test_lut_thingy.pixel_feeder_inst.row\[32\]\[0\]
+ _0061_ sg13g2_dfrbpq_1
X_3918_ VGND VPWR _1616_ _1628_ _1632_ _1615_ sg13g2_a21oi_1
XFILLER_20_652 VPWR VGND sg13g2_fill_1
X_4898_ net429 VGND VPWR _0359_ blue\[1\] net649 sg13g2_dfrbpq_2
X_3849_ net615 VPWR _1566_ VGND _1563_ _1565_ sg13g2_o21ai_1
XFILLER_20_685 VPWR VGND sg13g2_decap_8
XFILLER_22_36 VPWR VGND sg13g2_fill_1
XFILLER_0_7 VPWR VGND sg13g2_decap_8
XFILLER_47_538 VPWR VGND sg13g2_decap_8
XFILLER_47_77 VPWR VGND sg13g2_decap_8
XFILLER_15_424 VPWR VGND sg13g2_fill_2
XFILLER_16_947 VPWR VGND sg13g2_decap_8
XFILLER_31_928 VPWR VGND sg13g2_fill_2
X_5190__403 VPWR VGND net403 sg13g2_tiehi
XFILLER_24_991 VPWR VGND sg13g2_decap_8
XFILLER_31_939 VPWR VGND sg13g2_decap_4
XFILLER_11_663 VPWR VGND sg13g2_decap_8
XFILLER_6_144 VPWR VGND sg13g2_decap_8
XFILLER_6_155 VPWR VGND sg13g2_fill_2
XFILLER_3_895 VPWR VGND sg13g2_decap_8
XFILLER_33_7 VPWR VGND sg13g2_decap_4
XFILLER_2_394 VPWR VGND sg13g2_fill_1
XFILLER_38_505 VPWR VGND sg13g2_decap_4
XFILLER_22_906 VPWR VGND sg13g2_decap_8
X_4821_ net149 VGND VPWR _0282_ videogen.test_lut_thingy.pixel_feeder_inst.row\[19\]\[0\]
+ _0013_ sg13g2_dfrbpq_1
XFILLER_15_980 VPWR VGND sg13g2_decap_8
X_4752_ net708 net752 _0216_ VPWR VGND sg13g2_nor2_1
X_4683_ net695 net739 _0147_ VPWR VGND sg13g2_nor2_1
X_3703_ _1421_ net614 VPWR VGND _1420_ sg13g2_nand2b_2
XFILLER_30_961 VPWR VGND sg13g2_decap_8
X_3634_ videogen.test_lut_thingy.pixel_feeder_inst.row\[20\]\[2\] net581 _1352_ VPWR
+ VGND sg13g2_nor2_1
X_3565_ net598 VPWR _1283_ VGND videogen.test_lut_thingy.pixel_feeder_inst.row\[16\]\[3\]
+ net582 sg13g2_o21ai_1
X_3496_ _1214_ _1143_ _1210_ VPWR VGND sg13g2_xnor2_1
X_5166_ net283 VGND VPWR _0623_ videogen.test_lut_thingy.pixel_feeder_inst.row\[25\]\[0\]
+ _0241_ sg13g2_dfrbpq_1
X_5097_ net325 VGND VPWR _0554_ videogen.test_lut_thingy.pixel_feeder_inst.row\[47\]\[1\]
+ _0182_ sg13g2_dfrbpq_1
X_4117_ _1828_ _1826_ _1827_ VPWR VGND sg13g2_nand2_1
X_4048_ _1739_ VPWR _1759_ VGND _1741_ _1755_ sg13g2_o21ai_1
XFILLER_25_744 VPWR VGND sg13g2_fill_2
XFILLER_24_276 VPWR VGND sg13g2_fill_2
XFILLER_40_758 VPWR VGND sg13g2_fill_2
XFILLER_21_961 VPWR VGND sg13g2_decap_8
XFILLER_20_471 VPWR VGND sg13g2_fill_1
XFILLER_3_125 VPWR VGND sg13g2_fill_2
XFILLER_3_169 VPWR VGND sg13g2_decap_8
XFILLER_48_803 VPWR VGND sg13g2_decap_8
XFILLER_0_854 VPWR VGND sg13g2_decap_8
XFILLER_47_302 VPWR VGND sg13g2_decap_4
Xhold9 serialize.shift_reg_g\[2\] VPWR VGND net455 sg13g2_dlygate4sd3_1
XFILLER_35_508 VPWR VGND sg13g2_fill_2
XFILLER_28_593 VPWR VGND sg13g2_fill_1
XFILLER_43_541 VPWR VGND sg13g2_decap_8
XFILLER_15_221 VPWR VGND sg13g2_decap_4
XFILLER_15_265 VPWR VGND sg13g2_fill_2
XFILLER_30_202 VPWR VGND sg13g2_fill_2
X_5155__331 VPWR VGND net331 sg13g2_tiehi
XFILLER_15_298 VPWR VGND sg13g2_fill_2
XFILLER_12_972 VPWR VGND sg13g2_decap_8
XFILLER_8_943 VPWR VGND sg13g2_decap_8
X_4951__356 VPWR VGND net356 sg13g2_tiehi
X_3350_ videogen.fancy_shader.shader_counter_reg\[8\] videogen.fancy_shader.video_x\[8\]
+ _1068_ VPWR VGND sg13g2_xor2_1
X_5020_ net226 VGND VPWR _0477_ videogen.test_lut_thingy.pixel_feeder_inst.row\[56\]\[1\]
+ _0114_ sg13g2_dfrbpq_1
X_3281_ _0996_ VPWR _0999_ VGND _0989_ _0997_ sg13g2_o21ai_1
X_4988__290 VPWR VGND net290 sg13g2_tiehi
XFILLER_39_847 VPWR VGND sg13g2_fill_2
X_4804_ net174 VGND VPWR _0265_ serialize.shift_reg_g\[8\] clknet_3_1__leaf_clk_regs
+ sg13g2_dfrbpq_1
X_4735_ net682 net726 _0199_ VPWR VGND sg13g2_nor2_1
X_2996_ videogen.test_lut_thingy.pixel_feeder_inst.row\[19\]\[3\] net770 _0823_ _0285_
+ VPWR VGND sg13g2_mux2_1
X_4666_ net689 net733 _0130_ VPWR VGND sg13g2_nor2_1
X_4597_ net687 net726 _0061_ VPWR VGND sg13g2_nor2_1
X_3617_ videogen.test_lut_thingy.pixel_feeder_inst.row\[0\]\[2\] net583 _1335_ VPWR
+ VGND sg13g2_nor2_1
X_3548_ videogen.test_lut_thingy.pixel_feeder_inst.row\[36\]\[3\] net575 _1266_ VPWR
+ VGND sg13g2_nor2_1
XFILLER_0_106 VPWR VGND sg13g2_decap_8
XFILLER_0_139 VPWR VGND sg13g2_decap_8
X_3479_ _1195_ _1192_ net550 _1197_ VPWR VGND sg13g2_a21o_2
X_5149_ net388 VGND VPWR _0606_ videogen.test_lut_thingy.pixel_feeder_inst.row\[49\]\[1\]
+ _0234_ sg13g2_dfrbpq_1
XFILLER_45_828 VPWR VGND sg13g2_decap_8
XFILLER_44_305 VPWR VGND sg13g2_decap_4
XFILLER_45_839 VPWR VGND sg13g2_fill_1
XFILLER_25_530 VPWR VGND sg13g2_decap_8
XFILLER_25_563 VPWR VGND sg13g2_decap_4
XFILLER_25_574 VPWR VGND sg13g2_fill_1
XFILLER_5_913 VPWR VGND sg13g2_decap_8
XFILLER_4_467 VPWR VGND sg13g2_decap_4
XFILLER_0_640 VPWR VGND sg13g2_fill_1
XFILLER_0_684 VPWR VGND sg13g2_decap_4
XFILLER_48_655 VPWR VGND sg13g2_decap_4
XFILLER_36_817 VPWR VGND sg13g2_decap_4
XFILLER_47_198 VPWR VGND sg13g2_fill_1
XFILLER_16_541 VPWR VGND sg13g2_decap_8
X_2850_ videogen.test_lut_thingy.pixel_feeder_inst.row\[28\]\[1\] net787 _0791_ _0502_
+ VPWR VGND sg13g2_mux2_1
XFILLER_15_1022 VPWR VGND sg13g2_decap_8
XFILLER_31_577 VPWR VGND sg13g2_fill_2
X_2781_ videogen.test_lut_thingy.pixel_feeder_inst.row\[46\]\[0\] net794 _0777_ _0557_
+ VPWR VGND sg13g2_mux2_1
X_4520_ VPWR _0654_ _2174_ VGND sg13g2_inv_1
X_4451_ _2130_ _2122_ _2126_ VPWR VGND sg13g2_nand2_1
XFILLER_7_283 VPWR VGND sg13g2_fill_1
X_3402_ _1108_ _1107_ _1119_ _1120_ VPWR VGND sg13g2_a21o_1
X_4382_ _2064_ net608 _2061_ VPWR VGND sg13g2_nand2_2
Xfanout708 net709 net708 VPWR VGND sg13g2_buf_8
Xfanout719 net720 net719 VPWR VGND sg13g2_buf_8
X_3333_ _0994_ _1000_ _1051_ VPWR VGND sg13g2_and2_1
X_3264_ net808 VPWR _0984_ VGND videogen.test_lut_thingy.gol_counter_reg\[3\] _0983_
+ sg13g2_o21ai_1
X_5003_ net260 VGND VPWR _0460_ videogen.test_lut_thingy.pixel_feeder_inst.row\[62\]\[0\]
+ _0097_ sg13g2_dfrbpq_1
XFILLER_22_1004 VPWR VGND sg13g2_decap_8
X_3195_ _0939_ videogen.fancy_shader.shader_counter_reg\[0\] videogen.fancy_shader.shader_counter_reg\[1\]
+ _0937_ VPWR VGND sg13g2_and3_1
XFILLER_41_308 VPWR VGND sg13g2_decap_8
XFILLER_34_393 VPWR VGND sg13g2_fill_1
X_2979_ videogen.test_lut_thingy.pixel_feeder_inst.row\[13\]\[0\] net803 _0819_ _0380_
+ VPWR VGND sg13g2_mux2_1
XFILLER_10_728 VPWR VGND sg13g2_fill_1
X_4718_ net668 net712 _0182_ VPWR VGND sg13g2_nor2_1
X_4649_ net675 net720 _0113_ VPWR VGND sg13g2_nor2_1
XFILLER_2_949 VPWR VGND sg13g2_decap_8
X_5138__91 VPWR VGND net91 sg13g2_tiehi
XFILLER_39_23 VPWR VGND sg13g2_decap_8
XFILLER_39_12 VPWR VGND sg13g2_fill_2
XFILLER_1_448 VPWR VGND sg13g2_decap_8
XFILLER_29_110 VPWR VGND sg13g2_fill_1
XFILLER_26_872 VPWR VGND sg13g2_fill_1
XFILLER_25_371 VPWR VGND sg13g2_decap_8
XFILLER_40_374 VPWR VGND sg13g2_decap_8
XFILLER_9_559 VPWR VGND sg13g2_decap_8
XFILLER_5_743 VPWR VGND sg13g2_decap_8
XFILLER_4_275 VPWR VGND sg13g2_fill_2
XFILLER_4_253 VPWR VGND sg13g2_decap_8
XFILLER_1_960 VPWR VGND sg13g2_decap_8
XFILLER_49_931 VPWR VGND sg13g2_decap_8
XFILLER_48_430 VPWR VGND sg13g2_decap_8
X_4920__406 VPWR VGND net406 sg13g2_tiehi
X_3951_ VGND VPWR _1665_ _1664_ net1 sg13g2_or2_1
XFILLER_35_168 VPWR VGND sg13g2_decap_8
X_2902_ videogen.test_lut_thingy.pixel_feeder_inst.row\[8\]\[2\] net781 _0804_ _0454_
+ VPWR VGND sg13g2_mux2_1
XFILLER_16_382 VPWR VGND sg13g2_fill_1
X_5072__49 VPWR VGND net49 sg13g2_tiehi
X_3882_ _1596_ net547 _1595_ VPWR VGND sg13g2_xnor2_1
X_2833_ videogen.test_lut_thingy.pixel_feeder_inst.row\[26\]\[3\] net764 _0788_ _0516_
+ VPWR VGND sg13g2_mux2_1
X_2764_ _0772_ _0711_ _0736_ VPWR VGND sg13g2_nand2_2
X_4503_ _2166_ net658 net462 net664 serialize.tmds_parallel_b\[7\] VPWR VGND sg13g2_a22oi_1
X_5014__238 VPWR VGND net238 sg13g2_tiehi
X_2695_ _0747_ _0721_ _0726_ _0746_ VPWR VGND sg13g2_and3_2
X_4434_ _2113_ _2111_ _2114_ VPWR VGND sg13g2_xor2_1
X_4365_ _2044_ VPWR _2053_ VGND _2017_ _2045_ sg13g2_o21ai_1
X_3316_ _1026_ _1033_ _1034_ VPWR VGND sg13g2_and2_1
Xfanout549 _1105_ net549 VPWR VGND sg13g2_buf_8
X_4296_ _1993_ net605 tmds_green.dc_balancing_reg\[4\] VPWR VGND sg13g2_xnor2_1
XFILLER_39_430 VPWR VGND sg13g2_decap_4
X_3247_ net612 _0971_ net611 _0974_ VPWR VGND sg13g2_nand3_1
XFILLER_39_496 VPWR VGND sg13g2_decap_8
X_3178_ _0929_ videogen.test_lut_thingy.pixel_feeder_inst.v_counter\[2\] _0928_ VPWR
+ VGND sg13g2_xnor2_1
XFILLER_15_809 VPWR VGND sg13g2_fill_1
XFILLER_27_669 VPWR VGND sg13g2_decap_8
XFILLER_42_628 VPWR VGND sg13g2_fill_1
XFILLER_41_127 VPWR VGND sg13g2_decap_4
XFILLER_41_46 VPWR VGND sg13g2_decap_8
XFILLER_9_4 VPWR VGND sg13g2_fill_1
XFILLER_2_746 VPWR VGND sg13g2_decap_8
XFILLER_2_18 VPWR VGND sg13g2_decap_8
XFILLER_46_912 VPWR VGND sg13g2_decap_8
XFILLER_45_422 VPWR VGND sg13g2_decap_8
XFILLER_18_647 VPWR VGND sg13g2_fill_1
XFILLER_46_989 VPWR VGND sg13g2_decap_8
XFILLER_41_661 VPWR VGND sg13g2_fill_2
XFILLER_41_650 VPWR VGND sg13g2_fill_2
XFILLER_40_160 VPWR VGND sg13g2_decap_8
XFILLER_9_323 VPWR VGND sg13g2_decap_8
XFILLER_12_1014 VPWR VGND sg13g2_decap_8
XFILLER_5_551 VPWR VGND sg13g2_decap_4
X_4150_ _1782_ _1788_ _0992_ _1861_ VPWR VGND sg13g2_nand3_1
X_3101_ net635 _0702_ _0826_ _0877_ VGND VPWR _0835_ sg13g2_nor4_2
X_4081_ _1792_ _1588_ _1685_ VPWR VGND sg13g2_nand2b_1
X_3032_ _0846_ net811 _0845_ VPWR VGND sg13g2_nand2_1
XFILLER_36_433 VPWR VGND sg13g2_decap_4
XFILLER_37_989 VPWR VGND sg13g2_decap_8
XFILLER_24_628 VPWR VGND sg13g2_decap_8
X_4983_ net300 VGND VPWR _0440_ videogen.test_lut_thingy.pixel_feeder_inst.row\[10\]\[0\]
+ _0077_ sg13g2_dfrbpq_1
X_3934_ _1638_ _1647_ _1648_ VPWR VGND sg13g2_nor2_1
XFILLER_20_801 VPWR VGND sg13g2_fill_1
XFILLER_20_823 VPWR VGND sg13g2_fill_1
X_3865_ _1580_ _1520_ _1577_ VPWR VGND sg13g2_nand2_2
XFILLER_32_672 VPWR VGND sg13g2_fill_2
X_2816_ videogen.test_lut_thingy.pixel_feeder_inst.row\[52\]\[0\] net801 _0784_ _0529_
+ VPWR VGND sg13g2_mux2_1
X_3796_ videogen.test_lut_thingy.pixel_feeder_inst.row\[0\]\[1\] net582 _1514_ VPWR
+ VGND sg13g2_nor2_1
X_2747_ _0744_ _0765_ _0767_ VPWR VGND sg13g2_nor2_2
X_2678_ net624 _0707_ _0738_ VPWR VGND sg13g2_nor2_2
X_4417_ VGND VPWR _2098_ _2097_ _2096_ sg13g2_or2_1
X_4814__163 VPWR VGND net163 sg13g2_tiehi
XFILLER_28_1021 VPWR VGND sg13g2_decap_8
X_4931__387 VPWR VGND net387 sg13g2_tiehi
X_4348_ _2037_ _2022_ _2030_ VPWR VGND sg13g2_nand2_1
X_5129__188 VPWR VGND net188 sg13g2_tiehi
X_4279_ _1982_ tmds_red.dc_balancing_reg\[4\] _1981_ VPWR VGND sg13g2_xnor2_1
XFILLER_36_68 VPWR VGND sg13g2_fill_1
XFILLER_36_79 VPWR VGND sg13g2_decap_8
XFILLER_23_650 VPWR VGND sg13g2_decap_8
XFILLER_10_300 VPWR VGND sg13g2_fill_2
XFILLER_11_823 VPWR VGND sg13g2_decap_4
XFILLER_2_554 VPWR VGND sg13g2_fill_1
XFILLER_42_1018 VPWR VGND sg13g2_decap_8
XFILLER_46_720 VPWR VGND sg13g2_fill_1
XFILLER_18_422 VPWR VGND sg13g2_decap_4
XFILLER_19_956 VPWR VGND sg13g2_decap_8
XFILLER_45_241 VPWR VGND sg13g2_fill_1
XFILLER_33_425 VPWR VGND sg13g2_decap_8
XFILLER_9_142 VPWR VGND sg13g2_decap_8
X_3650_ videogen.test_lut_thingy.pixel_feeder_inst.row\[31\]\[2\] net568 _1368_ VPWR
+ VGND sg13g2_nor2_1
X_3581_ net600 _1293_ _1298_ _1299_ VPWR VGND sg13g2_nor3_2
X_2601_ _0674_ videogen.fancy_shader.video_y\[9\] VPWR VGND sg13g2_inv_2
X_4202_ _1908_ _1907_ _1906_ VPWR VGND sg13g2_nand2b_1
X_5182_ net79 VGND VPWR _0639_ serialize.shift_reg_b\[0\] clknet_3_6__leaf_clk_regs
+ sg13g2_dfrbpq_1
XFILLER_3_83 VPWR VGND sg13g2_fill_1
XFILLER_3_72 VPWR VGND sg13g2_decap_8
X_4133_ _1839_ _1842_ _1844_ VPWR VGND sg13g2_nor2_1
X_4064_ _1757_ _1765_ _1773_ _1775_ VPWR VGND sg13g2_or3_1
X_3015_ videogen.test_lut_thingy.pixel_feeder_inst.h_counter\[2\] videogen.test_lut_thingy.pixel_feeder_inst.h_counter\[1\]
+ _0831_ VPWR VGND sg13g2_nor2_1
XFILLER_25_926 VPWR VGND sg13g2_decap_8
X_4998__270 VPWR VGND net270 sg13g2_tiehi
X_4966_ net334 VGND VPWR _0423_ videogen.test_lut_thingy.pixel_feeder_inst.row\[33\]\[3\]
+ _0060_ sg13g2_dfrbpq_1
X_3917_ _1586_ _1617_ _1629_ _1631_ VPWR VGND sg13g2_nor3_1
X_4897_ net430 VGND VPWR _0358_ display_enable net646 sg13g2_dfrbpq_2
X_3848_ net620 VPWR _1565_ VGND net621 _1564_ sg13g2_o21ai_1
XFILLER_20_664 VPWR VGND sg13g2_decap_8
XFILLER_22_48 VPWR VGND sg13g2_decap_8
X_3779_ videogen.test_lut_thingy.pixel_feeder_inst.row\[13\]\[1\] net563 _1497_ VPWR
+ VGND sg13g2_nor2_1
XFILLER_47_517 VPWR VGND sg13g2_decap_8
XFILLER_16_926 VPWR VGND sg13g2_decap_8
XFILLER_43_756 VPWR VGND sg13g2_fill_2
XFILLER_24_970 VPWR VGND sg13g2_decap_8
XFILLER_30_428 VPWR VGND sg13g2_decap_8
XFILLER_11_620 VPWR VGND sg13g2_fill_1
XFILLER_23_491 VPWR VGND sg13g2_fill_1
XFILLER_10_130 VPWR VGND sg13g2_decap_8
XFILLER_7_613 VPWR VGND sg13g2_fill_1
XFILLER_7_602 VPWR VGND sg13g2_fill_1
XFILLER_6_123 VPWR VGND sg13g2_decap_8
XFILLER_7_679 VPWR VGND sg13g2_fill_2
XFILLER_3_874 VPWR VGND sg13g2_decap_8
X_5084__386 VPWR VGND net386 sg13g2_tiehi
XFILLER_19_775 VPWR VGND sg13g2_fill_2
XFILLER_18_285 VPWR VGND sg13g2_decap_8
X_4820_ net151 VGND VPWR _0281_ videogen.test_lut_thingy.pixel_feeder_inst.row\[1\]\[3\]
+ _0012_ sg13g2_dfrbpq_1
XFILLER_21_417 VPWR VGND sg13g2_decap_8
XFILLER_30_940 VPWR VGND sg13g2_decap_8
X_4751_ net708 net752 _0215_ VPWR VGND sg13g2_nor2_1
X_4682_ net677 net721 _0146_ VPWR VGND sg13g2_nor2_1
X_3702_ net615 _1408_ _1419_ _1420_ VPWR VGND sg13g2_nor3_1
X_3633_ net624 VPWR _1351_ VGND videogen.test_lut_thingy.pixel_feeder_inst.row\[23\]\[2\]
+ net570 sg13g2_o21ai_1
X_3564_ _1278_ _1279_ _1280_ _1281_ _1282_ VPWR VGND sg13g2_nor4_1
X_3495_ _1204_ _1212_ _1213_ VPWR VGND sg13g2_nor2_1
XFILLER_25_1024 VPWR VGND sg13g2_decap_4
X_5165_ net287 VGND VPWR net482 serialize.bit_cnt\[2\] clknet_3_1__leaf_clk_regs sg13g2_dfrbpq_1
X_4116_ _1827_ _1586_ _1742_ VPWR VGND sg13g2_nand2b_1
X_5096_ net329 VGND VPWR _0553_ videogen.test_lut_thingy.pixel_feeder_inst.row\[47\]\[0\]
+ _0181_ sg13g2_dfrbpq_1
XFILLER_44_509 VPWR VGND sg13g2_fill_1
X_4047_ _1740_ _1756_ _1682_ _1758_ VPWR VGND sg13g2_nand3_1
XFILLER_24_233 VPWR VGND sg13g2_fill_2
XFILLER_25_756 VPWR VGND sg13g2_fill_1
XFILLER_25_767 VPWR VGND sg13g2_decap_8
X_4949_ net359 VGND VPWR _0001_ videogen.test_lut_thingy.pixel_feeder_inst.state\[3\]
+ net641 sg13g2_dfrbpq_1
XFILLER_21_940 VPWR VGND sg13g2_decap_8
XFILLER_24_299 VPWR VGND sg13g2_fill_1
XFILLER_33_58 VPWR VGND sg13g2_fill_1
XFILLER_32_1017 VPWR VGND sg13g2_decap_8
XFILLER_3_104 VPWR VGND sg13g2_decap_8
XFILLER_0_833 VPWR VGND sg13g2_decap_8
XFILLER_48_859 VPWR VGND sg13g2_decap_8
XFILLER_43_520 VPWR VGND sg13g2_decap_4
XFILLER_15_200 VPWR VGND sg13g2_decap_8
XFILLER_16_767 VPWR VGND sg13g2_decap_8
XFILLER_16_789 VPWR VGND sg13g2_decap_8
XFILLER_30_214 VPWR VGND sg13g2_fill_1
XFILLER_8_922 VPWR VGND sg13g2_decap_8
XFILLER_12_951 VPWR VGND sg13g2_decap_8
XFILLER_8_999 VPWR VGND sg13g2_decap_8
X_4916__411 VPWR VGND net411 sg13g2_tiehi
XFILLER_48_1013 VPWR VGND sg13g2_decap_8
X_3280_ videogen.fancy_shader.shader_counter_reg\[1\] videogen.fancy_shader.video_y\[1\]
+ _0998_ VPWR VGND sg13g2_xor2_1
XFILLER_0_1015 VPWR VGND sg13g2_decap_8
XFILLER_19_572 VPWR VGND sg13g2_fill_1
XFILLER_46_391 VPWR VGND sg13g2_fill_2
XFILLER_34_520 VPWR VGND sg13g2_decap_4
XFILLER_34_542 VPWR VGND sg13g2_decap_8
X_4803_ net175 VGND VPWR _0264_ serialize.shift_reg_r\[9\] clknet_3_4__leaf_clk_regs
+ sg13g2_dfrbpq_1
XFILLER_22_759 VPWR VGND sg13g2_decap_8
X_4734_ net672 net717 _0198_ VPWR VGND sg13g2_nor2_1
X_2995_ _0727_ _0749_ _0823_ VPWR VGND sg13g2_nor2_2
X_4665_ net690 net734 _0129_ VPWR VGND sg13g2_nor2_1
X_4596_ net687 net731 _0060_ VPWR VGND sg13g2_nor2_1
X_3616_ videogen.test_lut_thingy.pixel_feeder_inst.row\[2\]\[2\] net592 _1334_ VPWR
+ VGND sg13g2_nor2_1
X_3547_ net600 VPWR _1265_ VGND videogen.test_lut_thingy.pixel_feeder_inst.row\[39\]\[3\]
+ net565 sg13g2_o21ai_1
X_3478_ VGND VPWR _1192_ _1195_ _1196_ net550 sg13g2_a21oi_1
XFILLER_29_303 VPWR VGND sg13g2_fill_2
XFILLER_29_314 VPWR VGND sg13g2_decap_8
XFILLER_29_325 VPWR VGND sg13g2_fill_1
XFILLER_29_336 VPWR VGND sg13g2_decap_8
X_5148_ net399 VGND VPWR _0605_ videogen.test_lut_thingy.pixel_feeder_inst.row\[49\]\[0\]
+ _0233_ sg13g2_dfrbpq_1
XFILLER_45_807 VPWR VGND sg13g2_decap_8
X_5024__218 VPWR VGND net218 sg13g2_tiehi
XFILLER_17_509 VPWR VGND sg13g2_fill_1
X_5079_ net436 VGND VPWR _0536_ videogen.test_lut_thingy.pixel_feeder_inst.row\[51\]\[3\]
+ _0164_ sg13g2_dfrbpq_1
XFILLER_44_328 VPWR VGND sg13g2_decap_8
XFILLER_44_35 VPWR VGND sg13g2_fill_2
X_5104__297 VPWR VGND net297 sg13g2_tiehi
XFILLER_48_612 VPWR VGND sg13g2_fill_1
XFILLER_0_663 VPWR VGND sg13g2_decap_8
XFILLER_48_678 VPWR VGND sg13g2_fill_2
XFILLER_47_133 VPWR VGND sg13g2_decap_8
XFILLER_43_394 VPWR VGND sg13g2_decap_4
XFILLER_16_597 VPWR VGND sg13g2_fill_1
XFILLER_15_1001 VPWR VGND sg13g2_decap_8
X_2780_ videogen.test_lut_thingy.pixel_feeder_inst.row\[46\]\[1\] net784 _0777_ _0558_
+ VPWR VGND sg13g2_mux2_1
XFILLER_12_792 VPWR VGND sg13g2_fill_1
X_4450_ net554 _2129_ _0495_ VPWR VGND sg13g2_and2_1
XFILLER_7_251 VPWR VGND sg13g2_fill_1
X_4381_ net607 _2061_ _2063_ VPWR VGND sg13g2_and2_1
X_3401_ VGND VPWR _1106_ _1109_ _1119_ _1107_ sg13g2_a21oi_1
X_3332_ VPWR _1050_ _1049_ VGND sg13g2_inv_1
Xfanout709 net710 net709 VPWR VGND sg13g2_buf_8
X_3263_ net757 _0982_ _0983_ _0355_ VPWR VGND sg13g2_nor3_1
X_3194_ VGND VPWR videogen.fancy_shader.shader_counter_reg\[0\] _0937_ _0331_ _0938_
+ sg13g2_a21oi_1
X_5002_ net262 VGND VPWR _0459_ videogen.test_lut_thingy.pixel_feeder_inst.row\[7\]\[3\]
+ _0096_ sg13g2_dfrbpq_1
XFILLER_15_0 VPWR VGND sg13g2_fill_2
XFILLER_39_689 VPWR VGND sg13g2_fill_2
XFILLER_26_306 VPWR VGND sg13g2_decap_8
X_4927__392 VPWR VGND net392 sg13g2_tiehi
XFILLER_22_523 VPWR VGND sg13g2_decap_8
XFILLER_34_372 VPWR VGND sg13g2_decap_8
X_2978_ videogen.test_lut_thingy.pixel_feeder_inst.row\[13\]\[1\] net792 _0819_ _0381_
+ VPWR VGND sg13g2_mux2_1
X_4717_ net668 net712 _0181_ VPWR VGND sg13g2_nor2_1
X_4648_ net707 net755 _0112_ VPWR VGND sg13g2_nor2_1
XFILLER_2_928 VPWR VGND sg13g2_decap_8
X_4579_ net701 net745 _0043_ VPWR VGND sg13g2_nor2_1
XFILLER_29_133 VPWR VGND sg13g2_decap_8
XFILLER_45_626 VPWR VGND sg13g2_fill_1
XFILLER_17_328 VPWR VGND sg13g2_fill_1
XFILLER_44_136 VPWR VGND sg13g2_decap_8
X_4906__421 VPWR VGND net421 sg13g2_tiehi
X_4941__367 VPWR VGND net367 sg13g2_tiehi
XFILLER_38_1012 VPWR VGND sg13g2_decap_8
X_4824__143 VPWR VGND net143 sg13g2_tiehi
XFILLER_40_320 VPWR VGND sg13g2_fill_2
XFILLER_13_534 VPWR VGND sg13g2_decap_8
XFILLER_40_342 VPWR VGND sg13g2_fill_1
XFILLER_9_505 VPWR VGND sg13g2_decap_8
XFILLER_13_545 VPWR VGND sg13g2_fill_1
X_5191__395 VPWR VGND net395 sg13g2_tiehi
XFILLER_4_232 VPWR VGND sg13g2_fill_1
XFILLER_4_221 VPWR VGND sg13g2_decap_8
X_4913__414 VPWR VGND net414 sg13g2_tiehi
XFILLER_4_243 VPWR VGND sg13g2_decap_4
XFILLER_49_910 VPWR VGND sg13g2_decap_8
XFILLER_0_493 VPWR VGND sg13g2_decap_8
XFILLER_49_987 VPWR VGND sg13g2_decap_8
XFILLER_48_486 VPWR VGND sg13g2_decap_8
XFILLER_36_615 VPWR VGND sg13g2_decap_8
XFILLER_17_840 VPWR VGND sg13g2_decap_8
XFILLER_16_350 VPWR VGND sg13g2_fill_1
X_3950_ _1326_ _1425_ _1664_ VPWR VGND sg13g2_nor2_1
X_2901_ videogen.test_lut_thingy.pixel_feeder_inst.row\[8\]\[3\] net770 _0804_ _0455_
+ VPWR VGND sg13g2_mux2_1
XFILLER_32_832 VPWR VGND sg13g2_decap_8
X_3881_ _1084_ _1592_ _1595_ VPWR VGND sg13g2_and2_1
X_2832_ _0735_ _0769_ _0788_ VPWR VGND sg13g2_nor2_2
X_2763_ videogen.test_lut_thingy.pixel_feeder_inst.row\[43\]\[0\] net795 _0771_ _0569_
+ VPWR VGND sg13g2_mux2_1
X_4502_ VPWR _0645_ _2165_ VGND sg13g2_inv_1
XFILLER_8_582 VPWR VGND sg13g2_decap_4
X_2694_ _0746_ _0706_ _0718_ VPWR VGND sg13g2_nand2_1
X_4433_ _2113_ _2085_ _2112_ VPWR VGND sg13g2_nand2_1
X_4364_ _2039_ _2051_ _2011_ _2052_ VPWR VGND sg13g2_nand3_1
X_3315_ videogen.fancy_shader.shader_counter_reg\[4\] videogen.fancy_shader.video_x\[4\]
+ _1033_ VPWR VGND sg13g2_xor2_1
X_4295_ _1992_ _0683_ tmds_green.dc_balancing_reg\[4\] VPWR VGND sg13g2_nand2_1
X_3246_ _0971_ net612 net611 _0973_ VPWR VGND sg13g2_a21o_1
X_4847__110 VPWR VGND net110 sg13g2_tiehi
X_3177_ _0898_ _0925_ _0928_ VPWR VGND sg13g2_nor2_1
XFILLER_23_832 VPWR VGND sg13g2_fill_1
XFILLER_41_14 VPWR VGND sg13g2_decap_4
XFILLER_2_725 VPWR VGND sg13g2_decap_8
XFILLER_49_239 VPWR VGND sg13g2_decap_8
XFILLER_46_968 VPWR VGND sg13g2_decap_8
XFILLER_13_397 VPWR VGND sg13g2_decap_8
XFILLER_5_530 VPWR VGND sg13g2_decap_8
XFILLER_5_585 VPWR VGND sg13g2_fill_2
X_3100_ net809 _0876_ _0287_ VPWR VGND sg13g2_and2_1
X_4080_ _1791_ _1589_ _1685_ VPWR VGND sg13g2_nand2_1
XFILLER_49_784 VPWR VGND sg13g2_decap_8
X_3031_ VGND VPWR _0845_ videogen.test_lut_thingy.pixel_feeder_inst.state\[3\] videogen.test_lut_thingy.pixel_feeder_inst.state\[1\]
+ sg13g2_or2_1
XFILLER_37_968 VPWR VGND sg13g2_decap_8
XFILLER_36_412 VPWR VGND sg13g2_decap_8
X_4982_ net302 VGND VPWR _0439_ videogen.test_lut_thingy.pixel_feeder_inst.row\[30\]\[3\]
+ _0076_ sg13g2_dfrbpq_1
X_4807__171 VPWR VGND net171 sg13g2_tiehi
XFILLER_17_670 VPWR VGND sg13g2_fill_2
XFILLER_17_692 VPWR VGND sg13g2_decap_8
X_3933_ _1647_ _1639_ _1646_ VPWR VGND sg13g2_nand2_1
X_3864_ _1523_ _1579_ _0360_ VPWR VGND sg13g2_nor2b_1
X_2815_ videogen.test_lut_thingy.pixel_feeder_inst.row\[52\]\[1\] net785 _0784_ _0530_
+ VPWR VGND sg13g2_mux2_1
X_3795_ videogen.test_lut_thingy.pixel_feeder_inst.row\[1\]\[1\] net562 _1513_ VPWR
+ VGND sg13g2_nor2_1
X_2746_ videogen.test_lut_thingy.pixel_feeder_inst.row\[40\]\[0\] net794 _0766_ _0581_
+ VPWR VGND sg13g2_mux2_1
X_2677_ _0737_ net632 VPWR VGND net628 sg13g2_nand2b_2
X_4416_ _2097_ net606 _2071_ VPWR VGND sg13g2_nand2_1
XFILLER_28_1000 VPWR VGND sg13g2_decap_8
X_4347_ _2034_ _2032_ _2036_ VPWR VGND sg13g2_xor2_1
X_4278_ _1981_ _1914_ _1954_ VPWR VGND sg13g2_nand2_1
XFILLER_46_209 VPWR VGND sg13g2_fill_1
X_3229_ net806 VPWR _0961_ VGND _0851_ _0878_ sg13g2_o21ai_1
XFILLER_28_979 VPWR VGND sg13g2_decap_8
XFILLER_36_47 VPWR VGND sg13g2_decap_8
XFILLER_43_949 VPWR VGND sg13g2_decap_8
XFILLER_14_128 VPWR VGND sg13g2_decap_8
X_4903__424 VPWR VGND net424 sg13g2_tiehi
XFILLER_42_459 VPWR VGND sg13g2_fill_1
XFILLER_42_448 VPWR VGND sg13g2_fill_2
XFILLER_22_183 VPWR VGND sg13g2_fill_1
XFILLER_6_327 VPWR VGND sg13g2_decap_8
XFILLER_10_378 VPWR VGND sg13g2_decap_8
X_4910__417 VPWR VGND net417 sg13g2_tiehi
XFILLER_18_401 VPWR VGND sg13g2_decap_4
XFILLER_37_209 VPWR VGND sg13g2_decap_4
XFILLER_46_743 VPWR VGND sg13g2_fill_2
XFILLER_19_935 VPWR VGND sg13g2_decap_8
XFILLER_46_754 VPWR VGND sg13g2_decap_4
XFILLER_45_253 VPWR VGND sg13g2_fill_1
XFILLER_34_949 VPWR VGND sg13g2_decap_8
XFILLER_14_673 VPWR VGND sg13g2_decap_8
XFILLER_14_695 VPWR VGND sg13g2_decap_8
XFILLER_9_176 VPWR VGND sg13g2_fill_1
X_3580_ _1294_ _1295_ _1296_ _1297_ _1298_ VPWR VGND sg13g2_nor4_1
X_2600_ VPWR _0673_ videogen.test_lut_thingy.pixel_feeder_inst.row\[62\]\[1\] VGND
+ sg13g2_inv_1
XFILLER_6_861 VPWR VGND sg13g2_fill_1
X_4201_ _1898_ _1905_ _1896_ _1907_ VPWR VGND sg13g2_nand3_1
X_5181_ net95 VGND VPWR _0638_ videogen.test_lut_thingy.pixel_feeder_inst.row\[22\]\[3\]
+ _0256_ sg13g2_dfrbpq_1
XFILLER_3_62 VPWR VGND sg13g2_decap_4
X_4132_ _1841_ _1790_ _1843_ VPWR VGND sg13g2_xor2_1
X_4063_ _1773_ VPWR _1774_ VGND _1757_ _1765_ sg13g2_o21ai_1
XFILLER_28_209 VPWR VGND sg13g2_fill_1
XFILLER_37_743 VPWR VGND sg13g2_fill_1
X_3014_ videogen.test_lut_thingy.pixel_feeder_inst.v_counter\[2\] videogen.test_lut_thingy.pixel_feeder_inst.v_counter\[1\]
+ _0829_ _0830_ VPWR VGND sg13g2_nor3_1
XFILLER_40_919 VPWR VGND sg13g2_decap_4
X_4965_ net336 VGND VPWR _0422_ videogen.test_lut_thingy.pixel_feeder_inst.row\[33\]\[2\]
+ _0059_ sg13g2_dfrbpq_1
X_3916_ _1586_ _1629_ _1630_ VPWR VGND sg13g2_nor2_1
XFILLER_33_993 VPWR VGND sg13g2_decap_8
X_4896_ net431 VGND VPWR _0357_ hsync net647 sg13g2_dfrbpq_1
X_3847_ net633 videogen.test_lut_thingy.pixel_feeder_inst.row\[56\]\[0\] videogen.test_lut_thingy.pixel_feeder_inst.row\[57\]\[0\]
+ videogen.test_lut_thingy.pixel_feeder_inst.row\[58\]\[0\] videogen.test_lut_thingy.pixel_feeder_inst.row\[59\]\[0\]
+ net629 _1564_ VPWR VGND sg13g2_mux4_1
X_3778_ videogen.test_lut_thingy.pixel_feeder_inst.row\[15\]\[1\] net573 _1496_ VPWR
+ VGND sg13g2_nor2_1
X_2729_ net799 videogen.test_lut_thingy.pixel_feeder_inst.row\[63\]\[0\] _0761_ _0593_
+ VPWR VGND sg13g2_mux2_1
XFILLER_47_35 VPWR VGND sg13g2_decap_4
XFILLER_47_57 VPWR VGND sg13g2_decap_4
XFILLER_28_710 VPWR VGND sg13g2_fill_1
XFILLER_27_220 VPWR VGND sg13g2_decap_4
XFILLER_42_201 VPWR VGND sg13g2_decap_8
XFILLER_27_264 VPWR VGND sg13g2_decap_8
XFILLER_27_275 VPWR VGND sg13g2_fill_2
XFILLER_28_787 VPWR VGND sg13g2_fill_2
XFILLER_42_245 VPWR VGND sg13g2_decap_8
X_5003__260 VPWR VGND net260 sg13g2_tiehi
XFILLER_23_470 VPWR VGND sg13g2_decap_4
XFILLER_6_102 VPWR VGND sg13g2_fill_1
XFILLER_12_93 VPWR VGND sg13g2_fill_1
XFILLER_3_853 VPWR VGND sg13g2_decap_8
XFILLER_2_352 VPWR VGND sg13g2_fill_1
XFILLER_46_551 VPWR VGND sg13g2_fill_1
X_4947__181 VPWR VGND net181 sg13g2_tiehi
X_4750_ net704 net748 _0214_ VPWR VGND sg13g2_nor2_1
X_4804__174 VPWR VGND net174 sg13g2_tiehi
X_4681_ net677 net721 _0145_ VPWR VGND sg13g2_nor2_1
X_3701_ net626 _1413_ _1418_ _1419_ VPWR VGND sg13g2_nor3_1
X_5091__358 VPWR VGND net358 sg13g2_tiehi
XFILLER_30_996 VPWR VGND sg13g2_decap_8
X_3632_ net616 _1338_ _1349_ _1350_ VPWR VGND sg13g2_nor3_1
X_3563_ videogen.test_lut_thingy.pixel_feeder_inst.row\[23\]\[3\] net571 _1281_ VPWR
+ VGND sg13g2_nor2_1
XFILLER_45_0 VPWR VGND sg13g2_decap_4
XFILLER_5_190 VPWR VGND sg13g2_fill_2
X_3494_ VGND VPWR _1199_ _1208_ _1212_ _1209_ sg13g2_a21oi_1
XFILLER_25_1003 VPWR VGND sg13g2_decap_8
X_5164_ net291 VGND VPWR _0621_ serialize.tmds_parallel_b\[9\] net654 sg13g2_dfrbpq_1
X_4811__167 VPWR VGND net167 sg13g2_tiehi
X_4115_ _1826_ _1742_ _1586_ VPWR VGND sg13g2_nand2b_1
X_5095_ net333 VGND VPWR _0552_ videogen.test_lut_thingy.pixel_feeder_inst.row\[39\]\[3\]
+ _0180_ sg13g2_dfrbpq_1
XFILLER_37_551 VPWR VGND sg13g2_fill_2
X_4046_ _1757_ _1682_ _1756_ VPWR VGND sg13g2_nand2_1
XFILLER_40_716 VPWR VGND sg13g2_fill_1
XFILLER_40_705 VPWR VGND sg13g2_fill_1
XFILLER_13_919 VPWR VGND sg13g2_decap_8
XFILLER_24_278 VPWR VGND sg13g2_fill_1
X_4948_ net87 VGND VPWR _0000_ videogen.mem_read net639 sg13g2_dfrbpq_2
X_4900__427 VPWR VGND net427 sg13g2_tiehi
X_4879_ net46 VGND VPWR _0340_ videogen.fancy_shader.shader_counter_reg\[9\] net642
+ sg13g2_dfrbpq_2
XFILLER_20_440 VPWR VGND sg13g2_decap_4
XFILLER_21_996 VPWR VGND sg13g2_decap_8
XFILLER_4_628 VPWR VGND sg13g2_decap_8
X_5183__71 VPWR VGND net71 sg13g2_tiehi
XFILLER_0_812 VPWR VGND sg13g2_decap_8
XFILLER_0_889 VPWR VGND sg13g2_decap_8
XFILLER_48_838 VPWR VGND sg13g2_decap_8
XFILLER_47_348 VPWR VGND sg13g2_fill_1
XFILLER_28_551 VPWR VGND sg13g2_fill_1
XFILLER_16_702 VPWR VGND sg13g2_decap_8
XFILLER_28_584 VPWR VGND sg13g2_decap_8
XFILLER_16_746 VPWR VGND sg13g2_fill_2
XFILLER_12_930 VPWR VGND sg13g2_decap_8
XFILLER_24_790 VPWR VGND sg13g2_decap_8
XFILLER_31_738 VPWR VGND sg13g2_decap_8
X_5038__197 VPWR VGND net197 sg13g2_tiehi
XFILLER_8_978 VPWR VGND sg13g2_decap_8
XFILLER_7_499 VPWR VGND sg13g2_decap_4
XFILLER_3_683 VPWR VGND sg13g2_decap_8
XFILLER_39_827 VPWR VGND sg13g2_fill_2
XFILLER_39_805 VPWR VGND sg13g2_decap_8
XFILLER_39_849 VPWR VGND sg13g2_fill_1
XFILLER_17_4 VPWR VGND sg13g2_fill_1
XFILLER_47_893 VPWR VGND sg13g2_decap_8
XFILLER_46_370 VPWR VGND sg13g2_fill_2
XFILLER_19_584 VPWR VGND sg13g2_decap_8
XFILLER_0_85 VPWR VGND sg13g2_decap_8
X_4802_ net176 VGND VPWR _0263_ serialize.shift_reg_r\[8\] clknet_3_6__leaf_clk_regs
+ sg13g2_dfrbpq_1
XFILLER_21_204 VPWR VGND sg13g2_decap_8
X_2994_ videogen.test_lut_thingy.pixel_feeder_inst.row\[18\]\[0\] net799 _0822_ _0288_
+ VPWR VGND sg13g2_mux2_1
XFILLER_34_598 VPWR VGND sg13g2_fill_2
X_4733_ net671 net714 _0197_ VPWR VGND sg13g2_nor2_1
XFILLER_30_760 VPWR VGND sg13g2_decap_8
X_4664_ net706 net750 _0128_ VPWR VGND sg13g2_nor2_1
X_5132__152 VPWR VGND net152 sg13g2_tiehi
X_4595_ net687 net731 _0059_ VPWR VGND sg13g2_nor2_1
X_3615_ net597 VPWR _1333_ VGND videogen.test_lut_thingy.pixel_feeder_inst.row\[1\]\[2\]
+ net562 sg13g2_o21ai_1
X_3546_ net626 _1258_ _1263_ _1264_ VPWR VGND sg13g2_nor3_1
XFILLER_1_609 VPWR VGND sg13g2_decap_4
XFILLER_0_119 VPWR VGND sg13g2_decap_8
X_3477_ _1181_ _1191_ _1193_ _1195_ VPWR VGND sg13g2_or3_1
X_4967__332 VPWR VGND net332 sg13g2_tiehi
X_5147_ net407 VGND VPWR _0604_ videogen.test_lut_thingy.pixel_feeder_inst.row\[38\]\[3\]
+ _0232_ sg13g2_dfrbpq_1
X_5078_ net440 VGND VPWR _0535_ videogen.test_lut_thingy.pixel_feeder_inst.row\[51\]\[2\]
+ _0163_ sg13g2_dfrbpq_1
XFILLER_38_860 VPWR VGND sg13g2_fill_1
X_4029_ _1740_ _1687_ _1738_ VPWR VGND sg13g2_xnor2_1
XFILLER_40_502 VPWR VGND sg13g2_decap_4
XFILLER_12_215 VPWR VGND sg13g2_decap_8
X_5174__219 VPWR VGND net219 sg13g2_tiehi
XFILLER_21_760 VPWR VGND sg13g2_decap_8
XFILLER_5_948 VPWR VGND sg13g2_decap_8
Xheichips25_bagel_30 VPWR VGND uio_out[5] sg13g2_tielo
X_5111__269 VPWR VGND net269 sg13g2_tiehi
XFILLER_0_631 VPWR VGND sg13g2_decap_8
XFILLER_47_145 VPWR VGND sg13g2_decap_8
XFILLER_43_351 VPWR VGND sg13g2_fill_1
XFILLER_31_535 VPWR VGND sg13g2_fill_1
X_4801__177 VPWR VGND net177 sg13g2_tiehi
XFILLER_11_292 VPWR VGND sg13g2_decap_4
XFILLER_8_775 VPWR VGND sg13g2_decap_8
X_4380_ _2062_ _2060_ VPWR VGND tmds_blue.dc_balancing_reg\[4\] sg13g2_nand2b_2
X_3400_ _1118_ _1100_ _1114_ net550 VPWR VGND sg13g2_and3_1
X_3331_ _1047_ VPWR _1049_ VGND _1045_ _1048_ sg13g2_o21ai_1
XFILLER_4_992 VPWR VGND sg13g2_decap_8
X_3262_ _0983_ videogen.test_lut_thingy.gol_counter_reg\[0\] videogen.test_lut_thingy.gol_counter_reg\[1\]
+ videogen.test_lut_thingy.gol_counter_reg\[2\] VPWR VGND sg13g2_and3_1
X_3193_ VGND VPWR net808 _0937_ _0938_ videogen.fancy_shader.shader_counter_reg\[0\]
+ sg13g2_a21oi_1
X_5001_ net264 VGND VPWR _0458_ videogen.test_lut_thingy.pixel_feeder_inst.row\[7\]\[2\]
+ _0095_ sg13g2_dfrbpq_1
XFILLER_39_668 VPWR VGND sg13g2_decap_8
X_5075__37 VPWR VGND net37 sg13g2_tiehi
X_2977_ videogen.test_lut_thingy.pixel_feeder_inst.row\[13\]\[2\] net782 _0819_ _0382_
+ VPWR VGND sg13g2_mux2_1
X_4716_ net677 net721 _0180_ VPWR VGND sg13g2_nor2_1
XFILLER_30_27 VPWR VGND sg13g2_decap_8
X_4647_ net707 net751 _0111_ VPWR VGND sg13g2_nor2_1
XFILLER_2_907 VPWR VGND sg13g2_decap_8
X_4578_ net702 net746 _0042_ VPWR VGND sg13g2_nor2_1
XFILLER_39_14 VPWR VGND sg13g2_fill_1
X_3529_ net617 VPWR _1247_ VGND videogen.test_lut_thingy.pixel_feeder_inst.row\[57\]\[3\]
+ net556 sg13g2_o21ai_1
XFILLER_45_605 VPWR VGND sg13g2_decap_4
XFILLER_18_819 VPWR VGND sg13g2_fill_2
XFILLER_29_178 VPWR VGND sg13g2_fill_2
XFILLER_44_115 VPWR VGND sg13g2_decap_4
XFILLER_44_148 VPWR VGND sg13g2_decap_4
XFILLER_41_811 VPWR VGND sg13g2_fill_2
XFILLER_25_384 VPWR VGND sg13g2_fill_1
XFILLER_9_539 VPWR VGND sg13g2_decap_8
XFILLER_5_712 VPWR VGND sg13g2_decap_4
XFILLER_5_734 VPWR VGND sg13g2_decap_4
XFILLER_0_472 VPWR VGND sg13g2_decap_8
XFILLER_1_995 VPWR VGND sg13g2_decap_8
XFILLER_49_966 VPWR VGND sg13g2_decap_8
XFILLER_48_465 VPWR VGND sg13g2_decap_8
XFILLER_45_90 VPWR VGND sg13g2_fill_1
XFILLER_43_170 VPWR VGND sg13g2_decap_8
X_2900_ _0740_ _0803_ _0804_ VPWR VGND sg13g2_nor2_2
XFILLER_17_896 VPWR VGND sg13g2_fill_2
XFILLER_43_192 VPWR VGND sg13g2_decap_4
X_3880_ _1594_ _1095_ _1593_ VPWR VGND sg13g2_xnor2_1
XFILLER_31_321 VPWR VGND sg13g2_fill_2
X_2831_ videogen.test_lut_thingy.pixel_feeder_inst.row\[55\]\[0\] net801 _0787_ _0517_
+ VPWR VGND sg13g2_mux2_1
XFILLER_32_888 VPWR VGND sg13g2_fill_2
XFILLER_32_899 VPWR VGND sg13g2_fill_2
X_2762_ videogen.test_lut_thingy.pixel_feeder_inst.row\[43\]\[1\] net785 _0771_ _0570_
+ VPWR VGND sg13g2_mux2_1
X_4501_ _2165_ net658 net461 net664 serialize.tmds_parallel_b\[6\] VPWR VGND sg13g2_a22oi_1
X_2693_ videogen.test_lut_thingy.pixel_feeder_inst.row\[25\]\[0\] net797 _0745_ _0623_
+ VPWR VGND sg13g2_mux2_1
X_4432_ _2112_ _2072_ _2086_ VPWR VGND sg13g2_nand2_1
X_4363_ _2051_ _2048_ _2050_ VPWR VGND sg13g2_xnor2_1
X_3314_ net636 videogen.fancy_shader.shader_counter_reg\[4\] _1032_ VPWR VGND sg13g2_nor2_1
X_4294_ green\[7\] net605 _1991_ VPWR VGND sg13g2_xor2_1
XFILLER_6_1011 VPWR VGND sg13g2_decap_8
X_3245_ net757 _0972_ _0348_ VPWR VGND sg13g2_nor2_1
X_3176_ _0894_ _0924_ _0927_ _0316_ VPWR VGND sg13g2_nor3_1
XFILLER_25_16 VPWR VGND sg13g2_decap_8
XFILLER_22_365 VPWR VGND sg13g2_fill_1
XFILLER_23_888 VPWR VGND sg13g2_decap_8
XFILLER_2_704 VPWR VGND sg13g2_decap_8
XFILLER_49_218 VPWR VGND sg13g2_decap_8
XFILLER_46_947 VPWR VGND sg13g2_decap_8
X_5041__193 VPWR VGND net193 sg13g2_tiehi
XFILLER_14_844 VPWR VGND sg13g2_fill_2
X_5013__240 VPWR VGND net240 sg13g2_tiehi
XFILLER_31_92 VPWR VGND sg13g2_fill_2
XFILLER_49_7 VPWR VGND sg13g2_decap_8
X_5087__374 VPWR VGND net374 sg13g2_tiehi
XFILLER_49_741 VPWR VGND sg13g2_decap_8
XFILLER_1_792 VPWR VGND sg13g2_decap_8
X_3030_ _0844_ videogen.test_lut_thingy.pixel_feeder_inst.state\[1\] net552 VPWR VGND
+ sg13g2_nand2b_1
X_5163__295 VPWR VGND net295 sg13g2_tiehi
X_4981_ net304 VGND VPWR _0438_ videogen.test_lut_thingy.pixel_feeder_inst.row\[30\]\[2\]
+ _0075_ sg13g2_dfrbpq_1
X_3932_ _1642_ VPWR _1646_ VGND _1644_ _1645_ sg13g2_o21ai_1
XFILLER_20_814 VPWR VGND sg13g2_decap_8
X_3863_ VGND VPWR _1230_ _1578_ _0361_ _1523_ sg13g2_a21oi_1
XFILLER_32_652 VPWR VGND sg13g2_fill_2
X_2814_ videogen.test_lut_thingy.pixel_feeder_inst.row\[52\]\[2\] net774 _0784_ _0531_
+ VPWR VGND sg13g2_mux2_1
XFILLER_31_195 VPWR VGND sg13g2_fill_2
X_3794_ videogen.test_lut_thingy.pixel_feeder_inst.row\[3\]\[1\] net572 _1512_ VPWR
+ VGND sg13g2_nor2_1
X_2745_ videogen.test_lut_thingy.pixel_feeder_inst.row\[40\]\[1\] net784 _0766_ _0582_
+ VPWR VGND sg13g2_mux2_1
X_2676_ net629 net633 _0736_ VPWR VGND sg13g2_nor2b_2
X_4415_ _2094_ _2083_ _2096_ VPWR VGND sg13g2_xor2_1
X_4346_ _2035_ _2034_ _2032_ VPWR VGND sg13g2_nand2b_1
X_4277_ _1960_ VPWR _1980_ VGND _1955_ _1958_ sg13g2_o21ai_1
X_3228_ VGND VPWR net613 _0877_ _0960_ videogen.fancy_shader.video_y\[1\] sg13g2_a21oi_1
X_3159_ _0842_ VPWR _0916_ VGND net624 _0914_ sg13g2_o21ai_1
XFILLER_28_936 VPWR VGND sg13g2_fill_1
XFILLER_43_928 VPWR VGND sg13g2_decap_8
XFILLER_23_630 VPWR VGND sg13g2_decap_8
XFILLER_35_1016 VPWR VGND sg13g2_decap_8
XFILLER_35_1027 VPWR VGND sg13g2_fill_2
XFILLER_10_302 VPWR VGND sg13g2_fill_1
XFILLER_11_858 VPWR VGND sg13g2_decap_8
XFILLER_2_512 VPWR VGND sg13g2_decap_8
XFILLER_2_523 VPWR VGND sg13g2_fill_1
XFILLER_18_468 VPWR VGND sg13g2_fill_2
XFILLER_34_906 VPWR VGND sg13g2_fill_2
XFILLER_26_81 VPWR VGND sg13g2_decap_8
XFILLER_42_983 VPWR VGND sg13g2_decap_8
XFILLER_9_188 VPWR VGND sg13g2_decap_8
XFILLER_6_851 VPWR VGND sg13g2_fill_2
X_4200_ VGND VPWR _1896_ _1898_ _1906_ _1905_ sg13g2_a21oi_1
X_5180_ net111 VGND VPWR _0637_ videogen.test_lut_thingy.pixel_feeder_inst.row\[22\]\[2\]
+ _0255_ sg13g2_dfrbpq_1
X_4131_ _1842_ _1841_ _1790_ VPWR VGND sg13g2_nand2b_1
X_4062_ _1773_ _1740_ _1755_ VPWR VGND sg13g2_xnor2_1
XFILLER_49_593 VPWR VGND sg13g2_decap_8
XFILLER_3_1014 VPWR VGND sg13g2_decap_8
X_3013_ _0829_ videogen.test_lut_thingy.pixel_feeder_inst.v_counter\[3\] videogen.test_lut_thingy.pixel_feeder_inst.v_counter\[0\]
+ VPWR VGND sg13g2_nand2_1
X_4864__76 VPWR VGND net76 sg13g2_tiehi
XFILLER_36_221 VPWR VGND sg13g2_fill_2
XFILLER_18_980 VPWR VGND sg13g2_decap_8
XFILLER_24_438 VPWR VGND sg13g2_decap_8
X_4964_ net338 VGND VPWR _0421_ videogen.test_lut_thingy.pixel_feeder_inst.row\[33\]\[1\]
+ _0058_ sg13g2_dfrbpq_1
XFILLER_36_298 VPWR VGND sg13g2_decap_8
X_3915_ _1629_ _1589_ _1627_ VPWR VGND sg13g2_xnor2_1
XFILLER_33_972 VPWR VGND sg13g2_decap_8
X_4895_ net432 VGND VPWR _0356_ videogen.test_lut_thingy.gol_counter_reg\[3\] net646
+ sg13g2_dfrbpq_1
X_3846_ net597 _1562_ _1563_ VPWR VGND sg13g2_nor2_1
X_3777_ net619 VPWR _1495_ VGND videogen.test_lut_thingy.pixel_feeder_inst.row\[14\]\[1\]
+ net592 sg13g2_o21ai_1
XFILLER_20_699 VPWR VGND sg13g2_decap_4
X_2728_ net789 videogen.test_lut_thingy.pixel_feeder_inst.row\[63\]\[1\] _0761_ _0594_
+ VPWR VGND sg13g2_mux2_1
X_2659_ videogen.test_lut_thingy.pixel_feeder_inst.row\[21\]\[1\] net789 _0728_ _0665_
+ VPWR VGND sg13g2_mux2_1
X_4329_ _2011_ _2018_ _2019_ VPWR VGND sg13g2_nor2_1
XFILLER_47_14 VPWR VGND sg13g2_decap_8
XFILLER_41_1020 VPWR VGND sg13g2_decap_8
X_5107__285 VPWR VGND net285 sg13g2_tiehi
XFILLER_43_714 VPWR VGND sg13g2_fill_2
XFILLER_31_909 VPWR VGND sg13g2_decap_4
X_4977__312 VPWR VGND net312 sg13g2_tiehi
XFILLER_7_626 VPWR VGND sg13g2_decap_8
XFILLER_11_677 VPWR VGND sg13g2_fill_2
XFILLER_3_821 VPWR VGND sg13g2_fill_1
XFILLER_3_832 VPWR VGND sg13g2_decap_8
XFILLER_2_320 VPWR VGND sg13g2_fill_1
XFILLER_2_364 VPWR VGND sg13g2_fill_2
Xfanout690 net691 net690 VPWR VGND sg13g2_buf_8
XFILLER_19_744 VPWR VGND sg13g2_fill_2
XFILLER_33_202 VPWR VGND sg13g2_fill_1
XFILLER_18_1022 VPWR VGND sg13g2_decap_8
XFILLER_21_408 VPWR VGND sg13g2_decap_4
XFILLER_15_994 VPWR VGND sg13g2_decap_8
X_3700_ _1414_ _1415_ _1416_ _1417_ _1418_ VPWR VGND sg13g2_nor4_1
X_4680_ net684 net728 _0144_ VPWR VGND sg13g2_nor2_1
XFILLER_30_975 VPWR VGND sg13g2_decap_8
X_3631_ net601 _1343_ _1348_ _1349_ VPWR VGND sg13g2_nor3_1
X_3562_ videogen.test_lut_thingy.pixel_feeder_inst.row\[20\]\[3\] net581 _1280_ VPWR
+ VGND sg13g2_nor2_1
X_3493_ _1211_ _1142_ _1210_ VPWR VGND sg13g2_nand2_1
X_5163_ net295 VGND VPWR _0620_ serialize.tmds_parallel_b\[8\] net649 sg13g2_dfrbpq_1
XFILLER_38_0 VPWR VGND sg13g2_fill_2
X_4114_ _1823_ _1824_ _1822_ _1825_ VPWR VGND sg13g2_nand3_1
X_5094_ net337 VGND VPWR _0551_ videogen.test_lut_thingy.pixel_feeder_inst.row\[39\]\[2\]
+ _0179_ sg13g2_dfrbpq_1
XFILLER_49_390 VPWR VGND sg13g2_decap_8
XFILLER_37_530 VPWR VGND sg13g2_fill_2
X_4045_ _1756_ _1745_ _1754_ VPWR VGND sg13g2_xnor2_1
XFILLER_37_585 VPWR VGND sg13g2_decap_4
XFILLER_25_714 VPWR VGND sg13g2_decap_8
XFILLER_24_213 VPWR VGND sg13g2_decap_8
X_4947_ net181 VGND VPWR _0003_ videogen.test_lut_thingy.pixel_feeder_inst.state\[1\]
+ net641 sg13g2_dfrbpq_1
X_4878_ net48 VGND VPWR _0339_ videogen.fancy_shader.shader_counter_reg\[8\] net642
+ sg13g2_dfrbpq_2
XFILLER_21_975 VPWR VGND sg13g2_decap_8
X_3829_ net618 VPWR _1546_ VGND net596 _1545_ sg13g2_o21ai_1
XFILLER_48_817 VPWR VGND sg13g2_decap_8
XFILLER_0_868 VPWR VGND sg13g2_decap_8
XFILLER_28_563 VPWR VGND sg13g2_decap_8
XFILLER_43_555 VPWR VGND sg13g2_decap_4
XFILLER_43_599 VPWR VGND sg13g2_fill_2
XFILLER_15_279 VPWR VGND sg13g2_fill_2
XFILLER_8_957 VPWR VGND sg13g2_decap_8
XFILLER_7_423 VPWR VGND sg13g2_decap_4
XFILLER_12_986 VPWR VGND sg13g2_decap_8
XFILLER_23_60 VPWR VGND sg13g2_decap_8
XFILLER_7_478 VPWR VGND sg13g2_decap_4
XFILLER_2_150 VPWR VGND sg13g2_decap_4
XFILLER_38_305 VPWR VGND sg13g2_decap_8
XFILLER_19_530 VPWR VGND sg13g2_fill_1
XFILLER_47_872 VPWR VGND sg13g2_decap_8
XFILLER_0_42 VPWR VGND sg13g2_decap_8
XFILLER_19_563 VPWR VGND sg13g2_fill_2
XFILLER_22_717 VPWR VGND sg13g2_decap_8
X_4801_ net177 VGND VPWR net753 clockdiv.q2temp net446 sg13g2_dfrbpq_2
XFILLER_15_780 VPWR VGND sg13g2_fill_2
XFILLER_21_227 VPWR VGND sg13g2_fill_1
XFILLER_22_728 VPWR VGND sg13g2_fill_1
X_2993_ videogen.test_lut_thingy.pixel_feeder_inst.row\[18\]\[1\] net790 _0822_ _0289_
+ VPWR VGND sg13g2_mux2_1
X_4732_ net674 net718 _0196_ VPWR VGND sg13g2_nor2_1
XFILLER_9_84 VPWR VGND sg13g2_decap_8
X_4663_ net706 net750 _0127_ VPWR VGND sg13g2_nor2_1
X_3614_ _1328_ _1329_ _1330_ _1331_ _1332_ VPWR VGND sg13g2_nor4_1
X_4594_ net687 net731 _0058_ VPWR VGND sg13g2_nor2_1
XFILLER_7_990 VPWR VGND sg13g2_decap_8
X_3545_ _1259_ _1260_ _1261_ _1262_ _1263_ VPWR VGND sg13g2_nor4_1
X_3476_ _1191_ _1193_ _1194_ VPWR VGND sg13g2_nor2_1
X_5146_ net442 VGND VPWR _0603_ videogen.test_lut_thingy.pixel_feeder_inst.row\[38\]\[2\]
+ _0231_ sg13g2_dfrbpq_1
XFILLER_28_16 VPWR VGND sg13g2_fill_1
XFILLER_28_27 VPWR VGND sg13g2_decap_4
XFILLER_28_49 VPWR VGND sg13g2_decap_8
X_5077_ net444 VGND VPWR _0534_ videogen.test_lut_thingy.pixel_feeder_inst.row\[51\]\[1\]
+ _0162_ sg13g2_dfrbpq_1
X_4028_ _1739_ _1687_ _1738_ VPWR VGND sg13g2_nand2b_1
XFILLER_13_717 VPWR VGND sg13g2_fill_1
XFILLER_25_544 VPWR VGND sg13g2_decap_8
XFILLER_12_238 VPWR VGND sg13g2_decap_4
XFILLER_20_260 VPWR VGND sg13g2_decap_4
XFILLER_21_772 VPWR VGND sg13g2_decap_8
XFILLER_21_783 VPWR VGND sg13g2_decap_8
XFILLER_5_927 VPWR VGND sg13g2_decap_8
XFILLER_0_698 VPWR VGND sg13g2_decap_4
XFILLER_47_179 VPWR VGND sg13g2_fill_1
XFILLER_18_60 VPWR VGND sg13g2_decap_8
XFILLER_29_883 VPWR VGND sg13g2_fill_1
XFILLER_28_393 VPWR VGND sg13g2_fill_1
XFILLER_16_555 VPWR VGND sg13g2_decap_8
XFILLER_16_588 VPWR VGND sg13g2_decap_8
X_3330_ _1048_ videogen.fancy_shader.video_y\[4\] videogen.fancy_shader.shader_counter_reg\[4\]
+ VPWR VGND sg13g2_nand2_1
XFILLER_4_971 VPWR VGND sg13g2_decap_8
X_3261_ VGND VPWR videogen.test_lut_thingy.gol_counter_reg\[0\] videogen.test_lut_thingy.gol_counter_reg\[1\]
+ _0982_ videogen.test_lut_thingy.gol_counter_reg\[2\] sg13g2_a21oi_1
X_5000_ net266 VGND VPWR _0457_ videogen.test_lut_thingy.pixel_feeder_inst.row\[7\]\[1\]
+ _0094_ sg13g2_dfrbpq_1
X_3192_ net552 _0895_ _0937_ VPWR VGND sg13g2_nor2_2
XFILLER_15_2 VPWR VGND sg13g2_fill_1
XFILLER_22_1018 VPWR VGND sg13g2_decap_8
XFILLER_38_135 VPWR VGND sg13g2_fill_2
XFILLER_38_179 VPWR VGND sg13g2_decap_8
X_5023__220 VPWR VGND net220 sg13g2_tiehi
XFILLER_19_360 VPWR VGND sg13g2_decap_4
XFILLER_10_709 VPWR VGND sg13g2_fill_2
X_2976_ videogen.test_lut_thingy.pixel_feeder_inst.row\[13\]\[3\] net771 _0819_ _0383_
+ VPWR VGND sg13g2_mux2_1
X_4715_ net670 net714 _0179_ VPWR VGND sg13g2_nor2_1
X_5210__103 VPWR VGND net103 sg13g2_tiehi
X_4646_ net707 net751 _0110_ VPWR VGND sg13g2_nor2_1
XFILLER_30_17 VPWR VGND sg13g2_fill_2
X_4577_ net701 net745 _0041_ VPWR VGND sg13g2_nor2_1
X_3528_ _1242_ _1243_ _1244_ _1245_ _1246_ VPWR VGND sg13g2_nor4_1
X_3459_ net548 _1082_ net546 _1095_ _1177_ VPWR VGND sg13g2_or4_1
X_5129_ net188 VGND VPWR _0586_ videogen.test_lut_thingy.pixel_feeder_inst.row\[3\]\[1\]
+ _0214_ sg13g2_dfrbpq_1
XFILLER_25_330 VPWR VGND sg13g2_fill_1
XFILLER_26_886 VPWR VGND sg13g2_fill_1
XFILLER_40_388 VPWR VGND sg13g2_fill_1
XFILLER_5_757 VPWR VGND sg13g2_fill_1
XFILLER_5_779 VPWR VGND sg13g2_decap_4
XFILLER_45_1007 VPWR VGND sg13g2_decap_8
XFILLER_0_451 VPWR VGND sg13g2_decap_8
XFILLER_1_974 VPWR VGND sg13g2_decap_8
XFILLER_49_945 VPWR VGND sg13g2_decap_8
XFILLER_48_444 VPWR VGND sg13g2_decap_8
X_4985__296 VPWR VGND net296 sg13g2_tiehi
XFILLER_17_875 VPWR VGND sg13g2_decap_8
XFILLER_44_661 VPWR VGND sg13g2_decap_4
XFILLER_16_396 VPWR VGND sg13g2_fill_1
X_2830_ videogen.test_lut_thingy.pixel_feeder_inst.row\[55\]\[1\] net788 _0787_ _0518_
+ VPWR VGND sg13g2_mux2_1
XFILLER_31_366 VPWR VGND sg13g2_decap_8
XFILLER_12_580 VPWR VGND sg13g2_decap_8
X_2761_ videogen.test_lut_thingy.pixel_feeder_inst.row\[43\]\[2\] net775 _0771_ _0571_
+ VPWR VGND sg13g2_mux2_1
X_4500_ VPWR _0644_ _2164_ VGND sg13g2_inv_1
X_2692_ videogen.test_lut_thingy.pixel_feeder_inst.row\[25\]\[1\] net786 _0745_ _0624_
+ VPWR VGND sg13g2_mux2_1
X_4431_ _2109_ _2101_ _2111_ VPWR VGND sg13g2_xor2_1
XFILLER_6_52 VPWR VGND sg13g2_decap_4
XFILLER_6_74 VPWR VGND sg13g2_fill_1
X_4362_ _2050_ tmds_green.dc_balancing_reg\[4\] _2049_ VPWR VGND sg13g2_xnor2_1
X_4293_ _0685_ net555 _0388_ VPWR VGND sg13g2_nor2_1
X_3313_ VPWR VGND _1029_ _1030_ _1008_ videogen.fancy_shader.video_x\[3\] _1031_ videogen.fancy_shader.shader_counter_reg\[3\]
+ sg13g2_a221oi_1
XFILLER_39_411 VPWR VGND sg13g2_decap_8
X_3244_ _0972_ net612 _0971_ VPWR VGND sg13g2_xnor2_1
X_3175_ VGND VPWR _0925_ _0926_ _0927_ _0898_ sg13g2_a21oi_1
XFILLER_26_138 VPWR VGND sg13g2_fill_1
XFILLER_23_823 VPWR VGND sg13g2_decap_8
XFILLER_23_867 VPWR VGND sg13g2_decap_8
XFILLER_10_517 VPWR VGND sg13g2_fill_2
X_2959_ videogen.test_lut_thingy.pixel_feeder_inst.row\[14\]\[0\] net802 _0815_ _0399_
+ VPWR VGND sg13g2_mux2_1
X_4629_ net706 net750 _0093_ VPWR VGND sg13g2_nor2_1
XFILLER_49_208 VPWR VGND sg13g2_decap_4
X_5141__67 VPWR VGND net67 sg13g2_tiehi
XFILLER_46_926 VPWR VGND sg13g2_decap_8
XFILLER_45_436 VPWR VGND sg13g2_fill_2
XFILLER_14_801 VPWR VGND sg13g2_decap_8
XFILLER_13_333 VPWR VGND sg13g2_fill_2
XFILLER_14_856 VPWR VGND sg13g2_decap_8
XFILLER_9_315 VPWR VGND sg13g2_fill_1
XFILLER_13_344 VPWR VGND sg13g2_fill_2
XFILLER_41_697 VPWR VGND sg13g2_fill_1
XFILLER_9_348 VPWR VGND sg13g2_fill_1
XFILLER_12_1028 VPWR VGND sg13g2_fill_1
XFILLER_31_71 VPWR VGND sg13g2_fill_2
Xoutput3 net3 tmds_b VPWR VGND sg13g2_buf_1
X_4876__52 VPWR VGND net52 sg13g2_tiehi
XFILLER_1_771 VPWR VGND sg13g2_decap_8
XFILLER_48_241 VPWR VGND sg13g2_decap_8
XFILLER_36_458 VPWR VGND sg13g2_decap_8
XFILLER_16_160 VPWR VGND sg13g2_decap_8
XFILLER_17_683 VPWR VGND sg13g2_fill_2
X_4980_ net306 VGND VPWR _0437_ videogen.test_lut_thingy.pixel_feeder_inst.row\[30\]\[1\]
+ _0074_ sg13g2_dfrbpq_1
X_3931_ _1629_ _1638_ _1640_ _1645_ VPWR VGND sg13g2_nor3_1
X_3862_ _1424_ _1578_ _1230_ _1579_ VPWR VGND sg13g2_nand3_1
XFILLER_31_152 VPWR VGND sg13g2_fill_1
X_2813_ videogen.test_lut_thingy.pixel_feeder_inst.row\[52\]\[3\] net767 _0784_ _0532_
+ VPWR VGND sg13g2_mux2_1
XFILLER_20_859 VPWR VGND sg13g2_decap_8
XFILLER_31_185 VPWR VGND sg13g2_decap_4
X_3793_ net602 VPWR _1511_ VGND videogen.test_lut_thingy.pixel_feeder_inst.row\[2\]\[1\]
+ net591 sg13g2_o21ai_1
X_2744_ videogen.test_lut_thingy.pixel_feeder_inst.row\[40\]\[2\] net775 _0766_ _0583_
+ VPWR VGND sg13g2_mux2_1
X_2675_ _0735_ _0723_ _0726_ VPWR VGND sg13g2_nand2_2
X_4414_ _2095_ _2083_ _2094_ VPWR VGND sg13g2_nand2_1
X_4345_ _2006_ _2033_ _2034_ VPWR VGND sg13g2_nor2_1
X_4276_ _1978_ _1970_ _1979_ VPWR VGND sg13g2_xor2_1
X_3227_ VGND VPWR net613 _0877_ _0343_ _0959_ sg13g2_a21oi_1
X_3158_ _0843_ _0914_ _0915_ _0310_ VPWR VGND sg13g2_nor3_1
XFILLER_27_458 VPWR VGND sg13g2_decap_4
X_3089_ serialize.tmds_parallel_b\[8\] net664 _0267_ VPWR VGND sg13g2_and2_1
XFILLER_35_491 VPWR VGND sg13g2_fill_2
X_5136__107 VPWR VGND net107 sg13g2_tiehi
XFILLER_23_664 VPWR VGND sg13g2_decap_8
XFILLER_10_314 VPWR VGND sg13g2_fill_1
XFILLER_22_163 VPWR VGND sg13g2_decap_4
XFILLER_23_686 VPWR VGND sg13g2_decap_8
XFILLER_23_697 VPWR VGND sg13g2_fill_1
XFILLER_7_808 VPWR VGND sg13g2_fill_1
XFILLER_6_318 VPWR VGND sg13g2_decap_4
XFILLER_2_579 VPWR VGND sg13g2_decap_8
XFILLER_46_745 VPWR VGND sg13g2_fill_1
XFILLER_33_439 VPWR VGND sg13g2_fill_2
XFILLER_42_962 VPWR VGND sg13g2_decap_8
XFILLER_9_112 VPWR VGND sg13g2_fill_2
XFILLER_13_163 VPWR VGND sg13g2_decap_8
XFILLER_9_156 VPWR VGND sg13g2_fill_1
XFILLER_6_874 VPWR VGND sg13g2_fill_2
X_4130_ _1838_ VPWR _1841_ VGND _1839_ _1840_ sg13g2_o21ai_1
X_4061_ _1770_ VPWR _1772_ VGND _1767_ _1768_ sg13g2_o21ai_1
XFILLER_49_572 VPWR VGND sg13g2_decap_8
XFILLER_37_723 VPWR VGND sg13g2_fill_1
X_3012_ videogen.test_lut_thingy.pixel_feeder_inst.h_counter\[0\] net552 _0828_ VPWR
+ VGND sg13g2_and2_1
X_4963_ net340 VGND VPWR _0420_ videogen.test_lut_thingy.pixel_feeder_inst.row\[33\]\[0\]
+ _0057_ sg13g2_dfrbpq_1
X_3914_ VGND VPWR _1624_ _1626_ _1628_ _1588_ sg13g2_a21oi_1
XFILLER_33_951 VPWR VGND sg13g2_decap_8
X_4894_ net433 VGND VPWR _0355_ videogen.test_lut_thingy.gol_counter_reg\[2\] net646
+ sg13g2_dfrbpq_1
X_3845_ net633 videogen.test_lut_thingy.pixel_feeder_inst.row\[60\]\[0\] videogen.test_lut_thingy.pixel_feeder_inst.row\[61\]\[0\]
+ videogen.test_lut_thingy.pixel_feeder_inst.row\[62\]\[0\] videogen.test_lut_thingy.pixel_feeder_inst.row\[63\]\[0\]
+ net629 _1562_ VPWR VGND sg13g2_mux4_1
XFILLER_20_645 VPWR VGND sg13g2_decap_8
XFILLER_22_18 VPWR VGND sg13g2_decap_4
XFILLER_20_678 VPWR VGND sg13g2_decap_8
X_3776_ _0678_ _1482_ _1493_ _1494_ VPWR VGND sg13g2_nor3_1
X_2727_ net779 videogen.test_lut_thingy.pixel_feeder_inst.row\[63\]\[2\] _0761_ _0595_
+ VPWR VGND sg13g2_mux2_1
X_2658_ videogen.test_lut_thingy.pixel_feeder_inst.row\[21\]\[2\] net778 _0728_ _0666_
+ VPWR VGND sg13g2_mux2_1
X_4328_ _2007_ _2008_ _2018_ VPWR VGND sg13g2_nor2_1
X_4259_ _1963_ _1944_ _1961_ VPWR VGND sg13g2_xnor2_1
XFILLER_24_984 VPWR VGND sg13g2_decap_8
XFILLER_11_656 VPWR VGND sg13g2_decap_8
XFILLER_6_137 VPWR VGND sg13g2_decap_8
XFILLER_12_62 VPWR VGND sg13g2_decap_4
X_5114__257 VPWR VGND net257 sg13g2_tiehi
XFILLER_3_888 VPWR VGND sg13g2_decap_8
Xfanout680 net682 net680 VPWR VGND sg13g2_buf_8
Xfanout691 net692 net691 VPWR VGND sg13g2_buf_8
XFILLER_46_542 VPWR VGND sg13g2_decap_8
XFILLER_37_92 VPWR VGND sg13g2_fill_2
X_5201__263 VPWR VGND net263 sg13g2_tiehi
XFILLER_18_299 VPWR VGND sg13g2_decap_4
XFILLER_15_973 VPWR VGND sg13g2_decap_8
XFILLER_18_1001 VPWR VGND sg13g2_decap_8
XFILLER_30_954 VPWR VGND sg13g2_decap_8
X_3630_ _1344_ _1345_ _1346_ _1347_ _1348_ VPWR VGND sg13g2_nor4_1
X_3561_ videogen.test_lut_thingy.pixel_feeder_inst.row\[21\]\[3\] net561 _1279_ VPWR
+ VGND sg13g2_nor2_1
X_3492_ _1208_ VPWR _1210_ VGND _1199_ _1209_ sg13g2_o21ai_1
XFILLER_5_192 VPWR VGND sg13g2_fill_1
X_5162_ net299 VGND VPWR _0619_ serialize.tmds_parallel_b\[7\] net651 sg13g2_dfrbpq_1
X_4113_ VGND VPWR _1824_ _1819_ _1793_ sg13g2_or2_1
X_5093_ net341 VGND VPWR _0550_ videogen.test_lut_thingy.pixel_feeder_inst.row\[39\]\[1\]
+ _0178_ sg13g2_dfrbpq_1
X_4044_ _1745_ VPWR _1755_ VGND _1747_ _1753_ sg13g2_o21ai_1
XFILLER_25_737 VPWR VGND sg13g2_fill_2
XFILLER_24_269 VPWR VGND sg13g2_fill_1
X_4946_ net180 VGND VPWR _0002_ videogen.test_lut_thingy.pixel_feeder_inst.state\[0\]
+ net641 sg13g2_dfrbpq_1
XFILLER_33_17 VPWR VGND sg13g2_decap_4
X_4877_ net50 VGND VPWR _0338_ videogen.fancy_shader.shader_counter_reg\[7\] net642
+ sg13g2_dfrbpq_2
XFILLER_21_954 VPWR VGND sg13g2_decap_8
X_3828_ net627 videogen.test_lut_thingy.pixel_feeder_inst.row\[28\]\[0\] videogen.test_lut_thingy.pixel_feeder_inst.row\[30\]\[0\]
+ videogen.test_lut_thingy.pixel_feeder_inst.row\[29\]\[0\] videogen.test_lut_thingy.pixel_feeder_inst.row\[31\]\[0\]
+ net632 _1545_ VPWR VGND sg13g2_mux4_1
X_3759_ net601 VPWR _1477_ VGND videogen.test_lut_thingy.pixel_feeder_inst.row\[19\]\[1\]
+ net572 sg13g2_o21ai_1
XFILLER_3_118 VPWR VGND sg13g2_decap_8
XFILLER_0_847 VPWR VGND sg13g2_decap_8
XFILLER_47_306 VPWR VGND sg13g2_fill_1
XFILLER_28_542 VPWR VGND sg13g2_decap_4
XFILLER_43_534 VPWR VGND sg13g2_decap_8
XFILLER_15_214 VPWR VGND sg13g2_decap_8
XFILLER_15_225 VPWR VGND sg13g2_fill_1
XFILLER_16_748 VPWR VGND sg13g2_fill_1
X_5079__436 VPWR VGND net436 sg13g2_tiehi
XFILLER_43_589 VPWR VGND sg13g2_fill_1
XFILLER_31_729 VPWR VGND sg13g2_decap_4
XFILLER_12_965 VPWR VGND sg13g2_decap_8
XFILLER_30_239 VPWR VGND sg13g2_fill_2
XFILLER_8_936 VPWR VGND sg13g2_decap_8
XFILLER_48_1027 VPWR VGND sg13g2_fill_2
XFILLER_47_851 VPWR VGND sg13g2_decap_8
XFILLER_0_21 VPWR VGND sg13g2_decap_8
XFILLER_46_372 VPWR VGND sg13g2_fill_1
X_4800_ net182 VGND VPWR _0262_ clockdiv.q2 clknet_3_0__leaf_clk_regs sg13g2_dfrbpq_1
X_2992_ videogen.test_lut_thingy.pixel_feeder_inst.row\[18\]\[2\] net781 _0822_ _0290_
+ VPWR VGND sg13g2_mux2_1
X_4731_ net669 net713 _0195_ VPWR VGND sg13g2_nor2_1
X_4995__276 VPWR VGND net276 sg13g2_tiehi
X_4662_ net702 net746 _0126_ VPWR VGND sg13g2_nor2_1
X_3613_ videogen.test_lut_thingy.pixel_feeder_inst.row\[5\]\[2\] net563 _1331_ VPWR
+ VGND sg13g2_nor2_1
X_4593_ net672 net716 _0057_ VPWR VGND sg13g2_nor2_1
X_3544_ videogen.test_lut_thingy.pixel_feeder_inst.row\[35\]\[3\] net568 _1262_ VPWR
+ VGND sg13g2_nor2_1
X_3475_ _1105_ _1189_ _1193_ VPWR VGND sg13g2_and2_1
XFILLER_9_1021 VPWR VGND sg13g2_decap_8
X_5145_ net35 VGND VPWR _0602_ videogen.test_lut_thingy.pixel_feeder_inst.row\[38\]\[1\]
+ _0230_ sg13g2_dfrbpq_1
X_5076_ net33 VGND VPWR _0533_ videogen.test_lut_thingy.pixel_feeder_inst.row\[51\]\[0\]
+ _0161_ sg13g2_dfrbpq_1
XFILLER_44_309 VPWR VGND sg13g2_fill_2
XFILLER_37_350 VPWR VGND sg13g2_decap_8
X_4027_ VGND VPWR _1737_ _1738_ _1735_ _1729_ sg13g2_a21oi_2
XFILLER_37_383 VPWR VGND sg13g2_decap_4
XFILLER_25_512 VPWR VGND sg13g2_decap_4
XFILLER_25_567 VPWR VGND sg13g2_fill_1
X_4929_ net390 VGND VPWR _0390_ green_tmds_par\[7\] net651 sg13g2_dfrbpq_1
XFILLER_5_906 VPWR VGND sg13g2_decap_8
XFILLER_20_272 VPWR VGND sg13g2_fill_2
Xheichips25_bagel_21 VPWR VGND uio_oe[0] sg13g2_tielo
XFILLER_0_677 VPWR VGND sg13g2_decap_8
XFILLER_0_688 VPWR VGND sg13g2_fill_1
XFILLER_48_659 VPWR VGND sg13g2_fill_1
XFILLER_48_648 VPWR VGND sg13g2_decap_8
XFILLER_29_840 VPWR VGND sg13g2_fill_1
XFILLER_16_512 VPWR VGND sg13g2_decap_4
XFILLER_16_534 VPWR VGND sg13g2_decap_8
XFILLER_15_1015 VPWR VGND sg13g2_decap_8
XFILLER_8_733 VPWR VGND sg13g2_fill_2
XFILLER_4_950 VPWR VGND sg13g2_decap_8
XFILLER_3_471 VPWR VGND sg13g2_fill_1
X_3260_ VGND VPWR videogen.test_lut_thingy.gol_counter_reg\[0\] videogen.test_lut_thingy.gol_counter_reg\[1\]
+ _0354_ _0981_ sg13g2_a21oi_1
X_5166__283 VPWR VGND net283 sg13g2_tiehi
X_3191_ _0931_ _0936_ _0322_ VPWR VGND sg13g2_nor2_1
XFILLER_22_4 VPWR VGND sg13g2_decap_8
XFILLER_39_648 VPWR VGND sg13g2_fill_1
XFILLER_35_821 VPWR VGND sg13g2_decap_4
XFILLER_34_342 VPWR VGND sg13g2_decap_4
XFILLER_34_386 VPWR VGND sg13g2_decap_8
XFILLER_22_537 VPWR VGND sg13g2_fill_2
X_2975_ _0758_ _0803_ _0819_ VPWR VGND sg13g2_nor2_2
X_4714_ net672 net716 _0178_ VPWR VGND sg13g2_nor2_1
X_4645_ net698 net742 _0109_ VPWR VGND sg13g2_nor2_1
X_4576_ net701 net745 _0040_ VPWR VGND sg13g2_nor2_1
X_3527_ videogen.test_lut_thingy.pixel_feeder_inst.row\[48\]\[3\] net577 _1245_ VPWR
+ VGND sg13g2_nor2_1
X_3458_ _1176_ _1165_ _1167_ VPWR VGND sg13g2_nand2_1
X_3389_ VGND VPWR net547 _1091_ _1107_ _1095_ sg13g2_a21oi_1
X_5128_ net192 VGND VPWR _0585_ videogen.test_lut_thingy.pixel_feeder_inst.row\[3\]\[0\]
+ _0213_ sg13g2_dfrbpq_1
X_5059_ net101 VGND VPWR _0516_ videogen.test_lut_thingy.pixel_feeder_inst.row\[26\]\[3\]
+ _0144_ sg13g2_dfrbpq_1
XFILLER_38_1026 VPWR VGND sg13g2_fill_2
XFILLER_13_526 VPWR VGND sg13g2_decap_4
XFILLER_25_364 VPWR VGND sg13g2_decap_8
XFILLER_40_367 VPWR VGND sg13g2_decap_8
XFILLER_21_570 VPWR VGND sg13g2_fill_1
XFILLER_21_592 VPWR VGND sg13g2_decap_8
X_5144__43 VPWR VGND net43 sg13g2_tiehi
XFILLER_0_430 VPWR VGND sg13g2_decap_8
XFILLER_1_953 VPWR VGND sg13g2_decap_8
XFILLER_49_924 VPWR VGND sg13g2_decap_8
XFILLER_48_423 VPWR VGND sg13g2_decap_8
XFILLER_36_607 VPWR VGND sg13g2_decap_4
XFILLER_35_106 VPWR VGND sg13g2_fill_1
XFILLER_35_128 VPWR VGND sg13g2_decap_8
XFILLER_45_70 VPWR VGND sg13g2_decap_8
XFILLER_17_898 VPWR VGND sg13g2_fill_1
XFILLER_31_301 VPWR VGND sg13g2_decap_4
XFILLER_31_323 VPWR VGND sg13g2_fill_1
XFILLER_31_356 VPWR VGND sg13g2_decap_4
X_4799__178 VPWR VGND net178 sg13g2_tiehi
X_2760_ videogen.test_lut_thingy.pixel_feeder_inst.row\[43\]\[3\] net763 _0771_ _0572_
+ VPWR VGND sg13g2_mux2_1
X_2691_ videogen.test_lut_thingy.pixel_feeder_inst.row\[25\]\[2\] net776 _0745_ _0625_
+ VPWR VGND sg13g2_mux2_1
X_4430_ _2101_ _2109_ _2110_ VPWR VGND sg13g2_and2_1
XFILLER_6_20 VPWR VGND sg13g2_decap_8
X_4361_ _2004_ VPWR _2049_ VGND tmds_green.dc_balancing_reg\[3\] _2003_ sg13g2_o21ai_1
X_3312_ _1030_ videogen.fancy_shader.video_x\[2\] videogen.fancy_shader.shader_counter_reg\[2\]
+ _1003_ VPWR VGND sg13g2_and3_1
X_4292_ VGND VPWR _1887_ _1925_ _0379_ _1990_ sg13g2_a21oi_1
X_3243_ net757 _0970_ _0971_ _0347_ VPWR VGND sg13g2_nor3_1
XFILLER_39_434 VPWR VGND sg13g2_fill_2
X_3174_ videogen.test_lut_thingy.pixel_feeder_inst.v_counter\[3\] _0896_ _0926_ VPWR
+ VGND sg13g2_nor2b_1
XFILLER_39_489 VPWR VGND sg13g2_fill_2
XFILLER_19_191 VPWR VGND sg13g2_fill_1
XFILLER_23_802 VPWR VGND sg13g2_decap_8
X_5071__53 VPWR VGND net53 sg13g2_tiehi
X_2958_ videogen.test_lut_thingy.pixel_feeder_inst.row\[14\]\[1\] net792 _0815_ _0400_
+ VPWR VGND sg13g2_mux2_1
X_4628_ net705 net749 _0092_ VPWR VGND sg13g2_nor2_1
X_2889_ videogen.test_lut_thingy.pixel_feeder_inst.row\[62\]\[3\] net768 _0800_ _0463_
+ VPWR VGND sg13g2_mux2_1
XFILLER_2_739 VPWR VGND sg13g2_decap_8
X_4559_ net677 net721 _0025_ VPWR VGND sg13g2_nor2_1
X_5147__407 VPWR VGND net407 sg13g2_tiehi
XFILLER_46_905 VPWR VGND sg13g2_decap_8
XFILLER_25_172 VPWR VGND sg13g2_fill_2
XFILLER_40_153 VPWR VGND sg13g2_decap_8
XFILLER_40_142 VPWR VGND sg13g2_fill_2
XFILLER_40_131 VPWR VGND sg13g2_decap_8
XFILLER_15_95 VPWR VGND sg13g2_fill_1
XFILLER_12_1007 VPWR VGND sg13g2_decap_8
XFILLER_5_500 VPWR VGND sg13g2_fill_1
XFILLER_5_555 VPWR VGND sg13g2_fill_2
XFILLER_5_544 VPWR VGND sg13g2_decap_8
Xoutput4 net4 tmds_clk VPWR VGND sg13g2_buf_1
XFILLER_1_750 VPWR VGND sg13g2_decap_8
XFILLER_49_798 VPWR VGND sg13g2_decap_8
XFILLER_36_426 VPWR VGND sg13g2_decap_8
X_5198__327 VPWR VGND net327 sg13g2_tiehi
XFILLER_36_437 VPWR VGND sg13g2_fill_1
X_3930_ _1644_ _1616_ _1643_ VPWR VGND sg13g2_xnor2_1
XFILLER_45_993 VPWR VGND sg13g2_decap_8
XFILLER_44_481 VPWR VGND sg13g2_decap_8
X_4924__398 VPWR VGND net398 sg13g2_tiehi
XFILLER_32_610 VPWR VGND sg13g2_decap_8
X_3861_ _1520_ _1577_ _1578_ VPWR VGND sg13g2_nor2b_1
X_3792_ _1506_ _1507_ _1508_ _1509_ _1510_ VPWR VGND sg13g2_nor4_1
X_2812_ _0752_ _0773_ _0784_ VPWR VGND sg13g2_nor2_2
XFILLER_32_687 VPWR VGND sg13g2_decap_4
X_2743_ videogen.test_lut_thingy.pixel_feeder_inst.row\[40\]\[3\] net763 _0766_ _0584_
+ VPWR VGND sg13g2_mux2_1
XFILLER_31_197 VPWR VGND sg13g2_fill_1
XFILLER_9_894 VPWR VGND sg13g2_fill_1
X_2674_ videogen.test_lut_thingy.pixel_feeder_inst.row\[23\]\[0\] net799 _0734_ _0631_
+ VPWR VGND sg13g2_mux2_1
X_4413_ _2084_ VPWR _2094_ VGND tmds_blue.dc_balancing_reg\[1\] _2069_ sg13g2_o21ai_1
X_4344_ VGND VPWR green\[7\] green\[6\] _2033_ _0683_ sg13g2_a21oi_1
XFILLER_28_1014 VPWR VGND sg13g2_decap_8
X_4275_ _1978_ _1975_ _1977_ VPWR VGND sg13g2_xnor2_1
X_3226_ net808 VPWR _0959_ VGND net613 _0877_ sg13g2_o21ai_1
XFILLER_28_916 VPWR VGND sg13g2_decap_4
X_3157_ VGND VPWR net633 _0912_ _0915_ net629 sg13g2_a21oi_1
XFILLER_27_404 VPWR VGND sg13g2_fill_2
XFILLER_27_437 VPWR VGND sg13g2_decap_4
X_3088_ green_tmds_par\[9\] net663 _0266_ VPWR VGND sg13g2_and2_1
XFILLER_36_982 VPWR VGND sg13g2_decap_8
XFILLER_22_131 VPWR VGND sg13g2_decap_4
XFILLER_23_643 VPWR VGND sg13g2_fill_2
X_4821__149 VPWR VGND net149 sg13g2_tiehi
XFILLER_18_426 VPWR VGND sg13g2_fill_1
XFILLER_19_949 VPWR VGND sg13g2_decap_8
XFILLER_45_212 VPWR VGND sg13g2_decap_8
XFILLER_27_982 VPWR VGND sg13g2_decap_8
XFILLER_33_418 VPWR VGND sg13g2_decap_8
XFILLER_42_941 VPWR VGND sg13g2_decap_8
XFILLER_14_621 VPWR VGND sg13g2_decap_8
XFILLER_26_72 VPWR VGND sg13g2_decap_4
XFILLER_14_665 VPWR VGND sg13g2_decap_4
XFILLER_42_82 VPWR VGND sg13g2_fill_2
XFILLER_3_32 VPWR VGND sg13g2_fill_2
XFILLER_49_551 VPWR VGND sg13g2_decap_8
X_4060_ _1769_ _1770_ _1771_ VPWR VGND sg13g2_nor2b_1
X_3011_ _0674_ _0694_ _0701_ _0826_ _0827_ VPWR VGND sg13g2_and4_1
X_5128__192 VPWR VGND net192 sg13g2_tiehi
X_4844__116 VPWR VGND net116 sg13g2_tiehi
XFILLER_25_919 VPWR VGND sg13g2_decap_8
X_4962_ net342 VGND VPWR _0419_ videogen.test_lut_thingy.pixel_feeder_inst.row\[36\]\[3\]
+ _0056_ sg13g2_dfrbpq_1
X_3913_ _1627_ _1624_ _1626_ VPWR VGND sg13g2_nand2_1
X_4893_ net434 VGND VPWR _0354_ videogen.test_lut_thingy.gol_counter_reg\[1\] net646
+ sg13g2_dfrbpq_2
X_5055__117 VPWR VGND net117 sg13g2_tiehi
X_3844_ net619 _1560_ _1561_ VPWR VGND sg13g2_nor2_1
XFILLER_20_657 VPWR VGND sg13g2_decap_8
X_3775_ net598 _1487_ _1492_ _1493_ VPWR VGND sg13g2_nor3_1
X_2726_ net768 videogen.test_lut_thingy.pixel_feeder_inst.row\[63\]\[3\] _0761_ _0596_
+ VPWR VGND sg13g2_mux2_1
X_2657_ videogen.test_lut_thingy.pixel_feeder_inst.row\[21\]\[3\] net767 _0728_ _0667_
+ VPWR VGND sg13g2_mux2_1
X_4327_ _2014_ _2015_ _2017_ VPWR VGND sg13g2_nor2b_1
X_4258_ _1962_ _1961_ _1944_ VPWR VGND sg13g2_nand2b_1
X_3209_ videogen.fancy_shader.shader_counter_reg\[5\] _0947_ _0949_ VPWR VGND sg13g2_and2_1
XFILLER_27_201 VPWR VGND sg13g2_decap_4
X_4189_ VGND VPWR red\[0\] net544 _1895_ _1889_ sg13g2_a21oi_1
XFILLER_24_963 VPWR VGND sg13g2_decap_8
XFILLER_10_101 VPWR VGND sg13g2_decap_4
XFILLER_6_116 VPWR VGND sg13g2_decap_8
XFILLER_11_679 VPWR VGND sg13g2_fill_1
XFILLER_3_867 VPWR VGND sg13g2_decap_8
Xfanout670 net672 net670 VPWR VGND sg13g2_buf_8
Xfanout681 net682 net681 VPWR VGND sg13g2_buf_1
Xfanout692 clockdiv.q2temp net692 VPWR VGND sg13g2_buf_8
XFILLER_46_521 VPWR VGND sg13g2_decap_8
XFILLER_18_223 VPWR VGND sg13g2_fill_2
XFILLER_18_234 VPWR VGND sg13g2_decap_4
XFILLER_19_768 VPWR VGND sg13g2_decap_8
X_5121__229 VPWR VGND net229 sg13g2_tiehi
XFILLER_18_278 VPWR VGND sg13g2_decap_8
XFILLER_15_952 VPWR VGND sg13g2_decap_8
XFILLER_30_933 VPWR VGND sg13g2_decap_8
X_3560_ net624 VPWR _1278_ VGND videogen.test_lut_thingy.pixel_feeder_inst.row\[22\]\[3\]
+ net590 sg13g2_o21ai_1
XFILLER_6_694 VPWR VGND sg13g2_decap_4
X_3491_ _1209_ _1142_ _1205_ VPWR VGND sg13g2_nand2_1
X_5161_ net303 VGND VPWR _0618_ serialize.tmds_parallel_b\[6\] net651 sg13g2_dfrbpq_1
XFILLER_38_2 VPWR VGND sg13g2_fill_1
X_4112_ _1823_ _1793_ _1819_ VPWR VGND sg13g2_nand2_1
X_5092_ net345 VGND VPWR _0549_ videogen.test_lut_thingy.pixel_feeder_inst.row\[39\]\[0\]
+ _0177_ sg13g2_dfrbpq_1
XFILLER_25_1017 VPWR VGND sg13g2_decap_8
XFILLER_25_1028 VPWR VGND sg13g2_fill_1
X_4043_ _1747_ _1753_ _1754_ VPWR VGND sg13g2_nor2_1
XFILLER_49_370 VPWR VGND sg13g2_fill_2
XFILLER_37_532 VPWR VGND sg13g2_fill_1
XFILLER_37_521 VPWR VGND sg13g2_fill_1
X_4945_ net179 VGND VPWR _0406_ videogen.test_lut_thingy.pixel_feeder_inst.row\[15\]\[3\]
+ _0052_ sg13g2_dfrbpq_1
XFILLER_24_248 VPWR VGND sg13g2_fill_2
X_4876_ net52 VGND VPWR _0337_ videogen.fancy_shader.shader_counter_reg\[6\] net642
+ sg13g2_dfrbpq_2
XFILLER_21_933 VPWR VGND sg13g2_decap_8
X_3827_ net623 _1543_ _1544_ VPWR VGND sg13g2_nor2_1
X_3758_ _1472_ _1473_ _1474_ _1475_ _1476_ VPWR VGND sg13g2_nor4_1
X_2709_ videogen.test_lut_thingy.pixel_feeder_inst.row\[49\]\[0\] net797 _0753_ _0605_
+ VPWR VGND sg13g2_mux2_1
X_4937__375 VPWR VGND net375 sg13g2_tiehi
X_3689_ _1403_ _1404_ _1405_ _1406_ _1407_ VPWR VGND sg13g2_nor4_1
XFILLER_0_826 VPWR VGND sg13g2_decap_8
XFILLER_43_524 VPWR VGND sg13g2_fill_2
XFILLER_15_237 VPWR VGND sg13g2_decap_4
XFILLER_15_248 VPWR VGND sg13g2_decap_4
XFILLER_12_944 VPWR VGND sg13g2_decap_8
XFILLER_8_915 VPWR VGND sg13g2_decap_8
XFILLER_23_73 VPWR VGND sg13g2_fill_1
XFILLER_48_1006 VPWR VGND sg13g2_decap_8
XFILLER_2_185 VPWR VGND sg13g2_fill_2
XFILLER_47_830 VPWR VGND sg13g2_decap_8
XFILLER_0_1008 VPWR VGND sg13g2_decap_8
XFILLER_19_565 VPWR VGND sg13g2_fill_1
XFILLER_46_384 VPWR VGND sg13g2_decap_8
XFILLER_0_55 VPWR VGND sg13g2_fill_2
XFILLER_19_598 VPWR VGND sg13g2_decap_8
XFILLER_34_535 VPWR VGND sg13g2_decap_8
XFILLER_0_99 VPWR VGND sg13g2_decap_8
X_2991_ videogen.test_lut_thingy.pixel_feeder_inst.row\[18\]\[3\] net770 _0822_ _0291_
+ VPWR VGND sg13g2_mux2_1
X_4730_ net669 net713 _0194_ VPWR VGND sg13g2_nor2_1
X_4661_ net702 net756 _0125_ VPWR VGND sg13g2_nor2_1
X_3612_ videogen.test_lut_thingy.pixel_feeder_inst.row\[6\]\[2\] net592 _1330_ VPWR
+ VGND sg13g2_nor2_1
XFILLER_31_1021 VPWR VGND sg13g2_decap_8
X_4592_ net677 net721 _0056_ VPWR VGND sg13g2_nor2_1
X_3543_ videogen.test_lut_thingy.pixel_feeder_inst.row\[32\]\[3\] net578 _1261_ VPWR
+ VGND sg13g2_nor2_1
XFILLER_43_0 VPWR VGND sg13g2_decap_8
X_3474_ _1184_ VPWR _1192_ VGND _1186_ _1190_ sg13g2_o21ai_1
X_5213_ net119 VGND VPWR net664 serialize.shift_reg_c\[8\] clknet_3_2__leaf_clk_regs
+ sg13g2_dfrbpq_1
XFILLER_9_1000 VPWR VGND sg13g2_decap_8
X_5144_ net43 VGND VPWR _0601_ videogen.test_lut_thingy.pixel_feeder_inst.row\[38\]\[0\]
+ _0229_ sg13g2_dfrbpq_1
X_5075_ net37 VGND VPWR _0532_ videogen.test_lut_thingy.pixel_feeder_inst.row\[52\]\[3\]
+ _0160_ sg13g2_dfrbpq_1
X_4026_ VGND VPWR _1721_ _1723_ _1737_ _1736_ sg13g2_a21oi_1
X_4898__429 VPWR VGND net429 sg13g2_tiehi
X_4928_ net391 VGND VPWR _0389_ green_tmds_par\[1\] net652 sg13g2_dfrbpq_1
XFILLER_12_229 VPWR VGND sg13g2_decap_4
XFILLER_21_730 VPWR VGND sg13g2_decap_4
X_5000__266 VPWR VGND net266 sg13g2_tiehi
X_4859_ net86 VGND VPWR _0320_ videogen.test_lut_thingy.pixel_feeder_inst.h_counter\[1\]
+ net639 sg13g2_dfrbpq_1
XFILLER_4_428 VPWR VGND sg13g2_decap_4
Xheichips25_bagel_22 VPWR VGND uio_oe[1] sg13g2_tielo
XFILLER_0_612 VPWR VGND sg13g2_decap_8
XFILLER_0_645 VPWR VGND sg13g2_decap_4
XFILLER_48_605 VPWR VGND sg13g2_decap_8
XFILLER_47_126 VPWR VGND sg13g2_decap_8
XFILLER_44_822 VPWR VGND sg13g2_decap_4
XFILLER_24_590 VPWR VGND sg13g2_decap_8
XFILLER_12_752 VPWR VGND sg13g2_decap_8
XFILLER_12_785 VPWR VGND sg13g2_decap_8
XFILLER_3_450 VPWR VGND sg13g2_decap_4
X_3190_ VGND VPWR videogen.test_lut_thingy.pixel_feeder_inst.h_counter\[2\] _0934_
+ _0936_ videogen.test_lut_thingy.pixel_feeder_inst.h_counter\[3\] sg13g2_a21oi_1
XFILLER_38_137 VPWR VGND sg13g2_fill_1
XFILLER_34_321 VPWR VGND sg13g2_fill_1
XFILLER_22_505 VPWR VGND sg13g2_decap_8
XFILLER_22_516 VPWR VGND sg13g2_decap_8
XFILLER_34_365 VPWR VGND sg13g2_decap_8
X_2974_ videogen.test_lut_thingy.pixel_feeder_inst.row\[12\]\[0\] net804 _0818_ _0384_
+ VPWR VGND sg13g2_mux2_1
X_4713_ net670 net714 _0177_ VPWR VGND sg13g2_nor2_1
XFILLER_30_571 VPWR VGND sg13g2_fill_2
X_4644_ net694 net738 _0108_ VPWR VGND sg13g2_nor2_1
X_4575_ net701 net745 _0039_ VPWR VGND sg13g2_nor2_1
X_3526_ videogen.test_lut_thingy.pixel_feeder_inst.row\[51\]\[3\] net567 _1244_ VPWR
+ VGND sg13g2_nor2_1
X_3457_ VPWR VGND _1158_ _1165_ _1167_ _1160_ _1175_ _1164_ sg13g2_a221oi_1
X_3388_ VPWR _1106_ _1105_ VGND sg13g2_inv_1
X_5127_ net205 VGND VPWR _0584_ videogen.test_lut_thingy.pixel_feeder_inst.row\[40\]\[3\]
+ _0212_ sg13g2_dfrbpq_1
XFILLER_29_115 VPWR VGND sg13g2_decap_8
XFILLER_29_126 VPWR VGND sg13g2_fill_2
XFILLER_45_619 VPWR VGND sg13g2_decap_8
X_5058_ net105 VGND VPWR _0515_ videogen.test_lut_thingy.pixel_feeder_inst.row\[26\]\[2\]
+ _0143_ sg13g2_dfrbpq_1
XFILLER_44_129 VPWR VGND sg13g2_decap_8
X_4009_ _1700_ _1712_ _1720_ VPWR VGND sg13g2_and2_1
XFILLER_26_800 VPWR VGND sg13g2_decap_8
XFILLER_38_1005 VPWR VGND sg13g2_decap_8
XFILLER_40_313 VPWR VGND sg13g2_decap_8
XFILLER_4_214 VPWR VGND sg13g2_decap_8
XFILLER_4_247 VPWR VGND sg13g2_fill_2
XFILLER_1_932 VPWR VGND sg13g2_decap_8
XFILLER_49_903 VPWR VGND sg13g2_decap_8
XFILLER_48_402 VPWR VGND sg13g2_decap_8
XFILLER_0_486 VPWR VGND sg13g2_decap_8
XFILLER_48_479 VPWR VGND sg13g2_decap_8
XFILLER_16_321 VPWR VGND sg13g2_fill_2
XFILLER_17_833 VPWR VGND sg13g2_decap_8
XFILLER_16_365 VPWR VGND sg13g2_fill_2
XFILLER_32_825 VPWR VGND sg13g2_decap_8
XFILLER_31_335 VPWR VGND sg13g2_decap_4
XFILLER_32_858 VPWR VGND sg13g2_decap_4
X_2690_ videogen.test_lut_thingy.pixel_feeder_inst.row\[25\]\[3\] net764 _0745_ _0626_
+ VPWR VGND sg13g2_mux2_1
XFILLER_8_553 VPWR VGND sg13g2_fill_1
XFILLER_8_597 VPWR VGND sg13g2_fill_2
XFILLER_8_575 VPWR VGND sg13g2_decap_8
X_4360_ _2035_ VPWR _2048_ VGND _2036_ _2037_ sg13g2_o21ai_1
X_3311_ _1004_ _1009_ _1029_ VPWR VGND sg13g2_nor2_1
X_4291_ _0957_ VPWR _1990_ VGND _1887_ _1925_ sg13g2_o21ai_1
X_3242_ _0853_ _0878_ _0971_ VPWR VGND sg13g2_nor2_2
X_3173_ _0925_ videogen.test_lut_thingy.pixel_feeder_inst.v_counter\[1\] videogen.test_lut_thingy.pixel_feeder_inst.v_counter\[0\]
+ VPWR VGND sg13g2_nand2_1
X_4964__338 VPWR VGND net338 sg13g2_tiehi
XFILLER_22_313 VPWR VGND sg13g2_decap_4
X_2957_ videogen.test_lut_thingy.pixel_feeder_inst.row\[14\]\[2\] net782 _0815_ _0401_
+ VPWR VGND sg13g2_mux2_1
XFILLER_41_18 VPWR VGND sg13g2_fill_1
XFILLER_10_519 VPWR VGND sg13g2_fill_1
XFILLER_31_891 VPWR VGND sg13g2_fill_2
X_2888_ _0748_ _0756_ _0800_ VPWR VGND sg13g2_nor2_2
X_4627_ net703 net747 _0091_ VPWR VGND sg13g2_nor2_1
X_5151__372 VPWR VGND net372 sg13g2_tiehi
XFILLER_2_718 VPWR VGND sg13g2_decap_8
X_4558_ net677 net721 _0024_ VPWR VGND sg13g2_nor2_1
X_4489_ _2159_ net661 net468 net666 blue_tmds_par\[0\] VPWR VGND sg13g2_a22oi_1
XFILLER_9_9 VPWR VGND sg13g2_decap_4
X_3509_ _1223_ _1221_ _1226_ _1227_ VPWR VGND sg13g2_a21o_1
XFILLER_45_416 VPWR VGND sg13g2_fill_2
XFILLER_17_107 VPWR VGND sg13g2_fill_1
XFILLER_38_490 VPWR VGND sg13g2_decap_4
XFILLER_41_622 VPWR VGND sg13g2_decap_8
XFILLER_25_184 VPWR VGND sg13g2_fill_1
XFILLER_40_121 VPWR VGND sg13g2_fill_1
X_5117__245 VPWR VGND net245 sg13g2_tiehi
XFILLER_5_523 VPWR VGND sg13g2_decap_8
XFILLER_31_73 VPWR VGND sg13g2_fill_1
Xoutput5 net5 tmds_g VPWR VGND sg13g2_buf_1
XFILLER_49_722 VPWR VGND sg13g2_decap_4
XFILLER_0_250 VPWR VGND sg13g2_decap_8
XFILLER_49_777 VPWR VGND sg13g2_decap_8
XFILLER_49_755 VPWR VGND sg13g2_decap_4
XFILLER_29_490 VPWR VGND sg13g2_fill_1
XFILLER_45_972 VPWR VGND sg13g2_decap_8
XFILLER_17_685 VPWR VGND sg13g2_fill_1
X_5094__337 VPWR VGND net337 sg13g2_tiehi
XFILLER_16_195 VPWR VGND sg13g2_fill_2
X_3860_ _1576_ VPWR _1577_ VGND videogen.test_lut_thingy.gol_counter_reg\[0\] net2
+ sg13g2_o21ai_1
XFILLER_31_132 VPWR VGND sg13g2_decap_8
X_3791_ videogen.test_lut_thingy.pixel_feeder_inst.row\[10\]\[1\] net591 _1509_ VPWR
+ VGND sg13g2_nor2_1
XFILLER_32_699 VPWR VGND sg13g2_decap_8
X_2811_ videogen.test_lut_thingy.pixel_feeder_inst.row\[51\]\[0\] net797 _0783_ _0533_
+ VPWR VGND sg13g2_mux2_1
X_2742_ _0740_ _0765_ _0766_ VPWR VGND sg13g2_nor2_2
X_4412_ _2093_ _2091_ _2092_ VPWR VGND sg13g2_nand2b_1
X_2673_ videogen.test_lut_thingy.pixel_feeder_inst.row\[23\]\[1\] net793 _0734_ _0632_
+ VPWR VGND sg13g2_mux2_1
X_4343_ _2032_ tmds_green.dc_balancing_reg\[3\] _2005_ VPWR VGND sg13g2_xnor2_1
X_4274_ _1977_ tmds_red.dc_balancing_reg\[4\] _1976_ VPWR VGND sg13g2_xnor2_1
XFILLER_39_210 VPWR VGND sg13g2_fill_1
X_3225_ tmds_red.dc_balancing_reg\[0\] net554 _0342_ VPWR VGND sg13g2_and2_1
XFILLER_28_906 VPWR VGND sg13g2_fill_1
X_3156_ net570 _0911_ _0914_ VPWR VGND sg13g2_nor2_2
XFILLER_39_298 VPWR VGND sg13g2_fill_1
X_3087_ green_tmds_par\[8\] net664 _0265_ VPWR VGND sg13g2_and2_1
XFILLER_36_961 VPWR VGND sg13g2_decap_8
XFILLER_35_493 VPWR VGND sg13g2_fill_1
X_3989_ _1700_ _1692_ _1699_ VPWR VGND sg13g2_xnor2_1
XFILLER_46_725 VPWR VGND sg13g2_decap_4
XFILLER_18_405 VPWR VGND sg13g2_fill_1
XFILLER_19_928 VPWR VGND sg13g2_decap_8
XFILLER_46_758 VPWR VGND sg13g2_fill_1
XFILLER_45_246 VPWR VGND sg13g2_decap_8
XFILLER_26_40 VPWR VGND sg13g2_fill_2
XFILLER_27_961 VPWR VGND sg13g2_decap_8
XFILLER_42_920 VPWR VGND sg13g2_decap_8
XFILLER_42_997 VPWR VGND sg13g2_decap_8
XFILLER_9_114 VPWR VGND sg13g2_fill_1
XFILLER_42_61 VPWR VGND sg13g2_decap_8
XFILLER_6_821 VPWR VGND sg13g2_fill_1
XFILLER_6_810 VPWR VGND sg13g2_decap_8
XFILLER_47_7 VPWR VGND sg13g2_decap_8
XFILLER_3_11 VPWR VGND sg13g2_decap_8
XFILLER_49_530 VPWR VGND sg13g2_decap_8
X_5048__158 VPWR VGND net158 sg13g2_tiehi
XFILLER_3_66 VPWR VGND sg13g2_fill_2
X_3010_ _0826_ videogen.fancy_shader.video_x\[8\] videogen.fancy_shader.video_x\[9\]
+ VPWR VGND sg13g2_nand2_1
XFILLER_3_1028 VPWR VGND sg13g2_fill_1
XFILLER_25_909 VPWR VGND sg13g2_fill_2
X_4961_ net344 VGND VPWR _0418_ videogen.test_lut_thingy.pixel_feeder_inst.row\[36\]\[2\]
+ _0055_ sg13g2_dfrbpq_1
XFILLER_17_471 VPWR VGND sg13g2_decap_4
XFILLER_18_994 VPWR VGND sg13g2_decap_8
XFILLER_33_931 VPWR VGND sg13g2_fill_1
X_3912_ _1612_ _1608_ _1625_ _1626_ VPWR VGND sg13g2_a21o_1
XFILLER_17_493 VPWR VGND sg13g2_decap_8
X_4892_ net435 VGND VPWR _0353_ videogen.test_lut_thingy.gol_counter_reg\[0\] net649
+ sg13g2_dfrbpq_2
X_3843_ net623 _1559_ _1560_ VPWR VGND sg13g2_nor2_1
XFILLER_32_474 VPWR VGND sg13g2_decap_4
XFILLER_33_986 VPWR VGND sg13g2_decap_8
X_5187__39 VPWR VGND net39 sg13g2_tiehi
XFILLER_9_670 VPWR VGND sg13g2_decap_8
X_3774_ _1488_ _1489_ _1490_ _1492_ VGND VPWR _1491_ sg13g2_nor4_2
X_2725_ _0733_ _0747_ net604 _0761_ VPWR VGND sg13g2_nand3_1
X_2656_ _0712_ _0727_ _0728_ VPWR VGND sg13g2_nor2_2
X_4326_ _2014_ _2015_ net605 _2016_ VPWR VGND sg13g2_nand3_1
XFILLER_47_28 VPWR VGND sg13g2_decap_8
X_4257_ _1961_ _1951_ _1959_ VPWR VGND sg13g2_xnor2_1
X_3208_ videogen.fancy_shader.shader_counter_reg\[5\] _0947_ _0948_ VPWR VGND sg13g2_nor2_1
X_4188_ _1894_ red\[0\] net544 VPWR VGND sg13g2_nand2_1
X_3139_ _0895_ VPWR _0903_ VGND videogen.test_lut_thingy.pixel_feeder_inst.v_pix\[1\]
+ _0901_ sg13g2_o21ai_1
XFILLER_27_224 VPWR VGND sg13g2_fill_1
XFILLER_24_942 VPWR VGND sg13g2_decap_8
XFILLER_23_463 VPWR VGND sg13g2_decap_8
XFILLER_23_474 VPWR VGND sg13g2_fill_2
XFILLER_10_179 VPWR VGND sg13g2_decap_4
XFILLER_3_846 VPWR VGND sg13g2_decap_8
XFILLER_2_301 VPWR VGND sg13g2_fill_1
X_5010__246 VPWR VGND net246 sg13g2_tiehi
Xfanout660 net662 net660 VPWR VGND sg13g2_buf_8
Xfanout693 net696 net693 VPWR VGND sg13g2_buf_8
Xfanout671 net672 net671 VPWR VGND sg13g2_buf_1
Xfanout682 net692 net682 VPWR VGND sg13g2_buf_8
XFILLER_15_931 VPWR VGND sg13g2_decap_8
XFILLER_42_772 VPWR VGND sg13g2_fill_2
XFILLER_14_463 VPWR VGND sg13g2_decap_4
XFILLER_41_282 VPWR VGND sg13g2_fill_2
XFILLER_30_989 VPWR VGND sg13g2_decap_8
Xclkbuf_3_7__f_clk_regs clknet_0_clk_regs clknet_3_7__leaf_clk_regs VPWR VGND sg13g2_buf_8
XFILLER_6_640 VPWR VGND sg13g2_decap_8
X_3490_ _1200_ VPWR _1208_ VGND _1206_ _1207_ sg13g2_o21ai_1
XFILLER_45_4 VPWR VGND sg13g2_fill_2
X_5160_ net307 VGND VPWR _0617_ serialize.tmds_parallel_b\[5\] net651 sg13g2_dfrbpq_1
X_4111_ _1807_ _1820_ _1822_ VPWR VGND _1793_ sg13g2_nand3b_1
X_5091_ net358 VGND VPWR _0548_ videogen.test_lut_thingy.pixel_feeder_inst.row\[48\]\[3\]
+ _0176_ sg13g2_dfrbpq_1
X_4042_ _1753_ _1750_ _1751_ _1748_ _1740_ VPWR VGND sg13g2_a22oi_1
XFILLER_37_544 VPWR VGND sg13g2_decap_8
X_4944_ net361 VGND VPWR _0405_ videogen.test_lut_thingy.pixel_feeder_inst.row\[15\]\[2\]
+ _0051_ sg13g2_dfrbpq_1
XFILLER_17_290 VPWR VGND sg13g2_decap_8
XFILLER_21_912 VPWR VGND sg13g2_decap_8
X_4875_ net54 VGND VPWR _0336_ videogen.fancy_shader.shader_counter_reg\[5\] net642
+ sg13g2_dfrbpq_2
XFILLER_33_794 VPWR VGND sg13g2_decap_4
X_3826_ net631 videogen.test_lut_thingy.pixel_feeder_inst.row\[24\]\[0\] videogen.test_lut_thingy.pixel_feeder_inst.row\[25\]\[0\]
+ videogen.test_lut_thingy.pixel_feeder_inst.row\[26\]\[0\] videogen.test_lut_thingy.pixel_feeder_inst.row\[27\]\[0\]
+ net627 _1543_ VPWR VGND sg13g2_mux4_1
XFILLER_21_989 VPWR VGND sg13g2_decap_8
X_5033__202 VPWR VGND net202 sg13g2_tiehi
X_3757_ videogen.test_lut_thingy.pixel_feeder_inst.row\[25\]\[1\] net558 _1475_ VPWR
+ VGND sg13g2_nor2_1
X_2708_ videogen.test_lut_thingy.pixel_feeder_inst.row\[49\]\[1\] net786 _0753_ _0606_
+ VPWR VGND sg13g2_mux2_1
X_3688_ videogen.test_lut_thingy.pixel_feeder_inst.row\[36\]\[2\] net575 _1406_ VPWR
+ VGND sg13g2_nor2_1
XFILLER_0_805 VPWR VGND sg13g2_decap_8
X_2639_ net597 _0707_ _0711_ VPWR VGND sg13g2_nor2_2
X_4309_ net759 _2000_ _0411_ VPWR VGND sg13g2_nor2_1
X_5148__399 VPWR VGND net399 sg13g2_tiehi
XFILLER_28_577 VPWR VGND sg13g2_decap_8
XFILLER_12_923 VPWR VGND sg13g2_decap_8
XFILLER_24_750 VPWR VGND sg13g2_fill_1
XFILLER_24_783 VPWR VGND sg13g2_decap_8
X_5090__362 VPWR VGND net362 sg13g2_tiehi
XFILLER_3_698 VPWR VGND sg13g2_fill_2
XFILLER_3_665 VPWR VGND sg13g2_decap_4
XFILLER_19_500 VPWR VGND sg13g2_fill_2
XFILLER_47_886 VPWR VGND sg13g2_decap_8
XFILLER_46_363 VPWR VGND sg13g2_decap_8
XFILLER_19_577 VPWR VGND sg13g2_decap_8
XFILLER_15_750 VPWR VGND sg13g2_fill_1
X_2990_ _0727_ _0768_ _0822_ VPWR VGND sg13g2_nor2_2
XFILLER_9_32 VPWR VGND sg13g2_fill_2
X_4660_ net675 net719 _0124_ VPWR VGND sg13g2_nor2_1
XFILLER_14_293 VPWR VGND sg13g2_fill_2
X_3611_ videogen.test_lut_thingy.pixel_feeder_inst.row\[7\]\[2\] net573 _1329_ VPWR
+ VGND sg13g2_nor2_1
XFILLER_31_1000 VPWR VGND sg13g2_decap_8
X_4591_ net668 net712 _0055_ VPWR VGND sg13g2_nor2_1
X_3542_ videogen.test_lut_thingy.pixel_feeder_inst.row\[33\]\[3\] net559 _1260_ VPWR
+ VGND sg13g2_nor2_1
X_3473_ VGND VPWR _1184_ _1189_ _1191_ _1105_ sg13g2_a21oi_1
X_5212_ net164 VGND VPWR _0669_ serialize.shift_reg_c\[6\] clknet_3_2__leaf_clk_regs
+ sg13g2_dfrbpq_1
X_5143_ net51 VGND VPWR _0600_ videogen.test_lut_thingy.pixel_feeder_inst.row\[29\]\[3\]
+ _0228_ sg13g2_dfrbpq_1
XFILLER_36_0 VPWR VGND sg13g2_decap_8
X_5074_ net41 VGND VPWR _0531_ videogen.test_lut_thingy.pixel_feeder_inst.row\[52\]\[2\]
+ _0159_ sg13g2_dfrbpq_1
X_4025_ VGND VPWR _1720_ _1723_ _1736_ _1721_ sg13g2_a21oi_1
XFILLER_40_506 VPWR VGND sg13g2_fill_1
X_4927_ net392 VGND VPWR _0388_ green_tmds_par\[0\] net652 sg13g2_dfrbpq_1
XFILLER_40_528 VPWR VGND sg13g2_fill_2
X_4974__318 VPWR VGND net318 sg13g2_tiehi
X_4858_ net88 VGND VPWR _0319_ videogen.test_lut_thingy.pixel_feeder_inst.h_counter\[0\]
+ net639 sg13g2_dfrbpq_1
XFILLER_21_753 VPWR VGND sg13g2_decap_8
XFILLER_20_274 VPWR VGND sg13g2_fill_1
XFILLER_21_797 VPWR VGND sg13g2_fill_2
X_3809_ videogen.test_lut_thingy.pixel_feeder_inst.row\[18\]\[0\] net590 _1526_ VPWR
+ VGND sg13g2_nor2_1
X_4789_ net697 net741 _0251_ VPWR VGND sg13g2_nor2_1
Xheichips25_bagel_23 VPWR VGND uio_oe[2] sg13g2_tielo
XFILLER_0_624 VPWR VGND sg13g2_decap_8
XFILLER_18_41 VPWR VGND sg13g2_fill_2
XFILLER_28_341 VPWR VGND sg13g2_decap_4
XFILLER_18_74 VPWR VGND sg13g2_fill_2
XFILLER_43_311 VPWR VGND sg13g2_decap_8
XFILLER_18_96 VPWR VGND sg13g2_decap_8
XFILLER_16_569 VPWR VGND sg13g2_fill_2
XFILLER_8_735 VPWR VGND sg13g2_fill_1
XFILLER_7_223 VPWR VGND sg13g2_fill_2
XFILLER_11_263 VPWR VGND sg13g2_fill_1
XFILLER_8_768 VPWR VGND sg13g2_decap_8
XFILLER_7_234 VPWR VGND sg13g2_decap_4
XFILLER_11_296 VPWR VGND sg13g2_fill_2
XFILLER_4_985 VPWR VGND sg13g2_decap_8
XFILLER_3_462 VPWR VGND sg13g2_fill_2
XFILLER_39_617 VPWR VGND sg13g2_fill_2
XFILLER_46_160 VPWR VGND sg13g2_decap_4
XFILLER_19_385 VPWR VGND sg13g2_decap_4
X_2973_ videogen.test_lut_thingy.pixel_feeder_inst.row\[12\]\[1\] net792 _0818_ _0385_
+ VPWR VGND sg13g2_mux2_1
X_4897__430 VPWR VGND net430 sg13g2_tiehi
XFILLER_15_591 VPWR VGND sg13g2_fill_2
X_4712_ net681 net725 _0176_ VPWR VGND sg13g2_nor2_1
X_4643_ net694 net738 _0107_ VPWR VGND sg13g2_nor2_1
X_4574_ net688 net732 _0038_ VPWR VGND sg13g2_nor2_1
X_3525_ videogen.test_lut_thingy.pixel_feeder_inst.row\[50\]\[3\] net587 _1243_ VPWR
+ VGND sg13g2_nor2_1
X_5110__273 VPWR VGND net273 sg13g2_tiehi
X_3456_ _1171_ _1172_ _1174_ VPWR VGND sg13g2_nor2b_1
X_3387_ _1105_ _1102_ _1104_ VPWR VGND sg13g2_xnor2_1
X_5126_ net209 VGND VPWR _0583_ videogen.test_lut_thingy.pixel_feeder_inst.row\[40\]\[2\]
+ _0211_ sg13g2_dfrbpq_1
X_5057_ net109 VGND VPWR _0514_ videogen.test_lut_thingy.pixel_feeder_inst.row\[26\]\[1\]
+ _0142_ sg13g2_dfrbpq_1
XFILLER_44_119 VPWR VGND sg13g2_fill_2
XFILLER_44_108 VPWR VGND sg13g2_decap_8
X_4008_ _1719_ net549 _1718_ VPWR VGND sg13g2_xnor2_1
X_5074__41 VPWR VGND net41 sg13g2_tiehi
XFILLER_26_845 VPWR VGND sg13g2_decap_4
XFILLER_38_1028 VPWR VGND sg13g2_fill_1
X_5178__156 VPWR VGND net156 sg13g2_tiehi
XFILLER_41_826 VPWR VGND sg13g2_decap_4
XFILLER_5_716 VPWR VGND sg13g2_fill_1
XFILLER_20_20 VPWR VGND sg13g2_fill_2
XFILLER_1_911 VPWR VGND sg13g2_decap_8
XFILLER_1_988 VPWR VGND sg13g2_decap_8
XFILLER_49_959 VPWR VGND sg13g2_decap_8
XFILLER_0_465 VPWR VGND sg13g2_decap_8
XFILLER_48_458 VPWR VGND sg13g2_decap_8
XFILLER_21_1010 VPWR VGND sg13g2_decap_8
XFILLER_44_631 VPWR VGND sg13g2_fill_1
XFILLER_43_130 VPWR VGND sg13g2_decap_4
XFILLER_17_889 VPWR VGND sg13g2_decap_8
XFILLER_32_804 VPWR VGND sg13g2_decap_8
XFILLER_43_163 VPWR VGND sg13g2_decap_8
XFILLER_8_543 VPWR VGND sg13g2_fill_1
XFILLER_8_532 VPWR VGND sg13g2_decap_8
XFILLER_12_594 VPWR VGND sg13g2_fill_1
X_3310_ VPWR _1028_ _1027_ VGND sg13g2_inv_1
X_4290_ VPWR VGND _1897_ _1989_ _1923_ _1877_ _0377_ _1922_ sg13g2_a221oi_1
X_3241_ videogen.fancy_shader.video_y\[4\] _0969_ _0970_ VPWR VGND sg13g2_nor2_1
XFILLER_6_1004 VPWR VGND sg13g2_decap_8
X_3172_ videogen.test_lut_thingy.pixel_feeder_inst.v_counter\[1\] _0898_ _0924_ VPWR
+ VGND sg13g2_nor2b_1
XFILLER_39_447 VPWR VGND sg13g2_decap_8
XFILLER_48_992 VPWR VGND sg13g2_decap_8
XFILLER_47_491 VPWR VGND sg13g2_fill_1
XFILLER_35_631 VPWR VGND sg13g2_decap_8
XFILLER_35_653 VPWR VGND sg13g2_fill_2
X_5058__105 VPWR VGND net105 sg13g2_tiehi
XFILLER_22_358 VPWR VGND sg13g2_decap_8
X_2956_ videogen.test_lut_thingy.pixel_feeder_inst.row\[14\]\[3\] net769 _0815_ _0402_
+ VPWR VGND sg13g2_mux2_1
X_2887_ videogen.test_lut_thingy.pixel_feeder_inst.row\[61\]\[0\] net799 _0798_ _0464_
+ VPWR VGND sg13g2_mux2_1
X_4626_ net689 net733 _0090_ VPWR VGND sg13g2_nor2_1
X_4557_ net672 net716 _0023_ VPWR VGND sg13g2_nor2_1
X_3508_ _1215_ _1224_ _1225_ _1226_ VPWR VGND sg13g2_nor3_1
X_4488_ _2158_ VPWR _0622_ VGND net481 _0875_ sg13g2_o21ai_1
XFILLER_44_1021 VPWR VGND sg13g2_decap_8
X_3439_ _1156_ _1155_ _1157_ VPWR VGND sg13g2_xor2_1
X_5109_ net277 VGND VPWR _0566_ videogen.test_lut_thingy.pixel_feeder_inst.row\[44\]\[1\]
+ _0194_ sg13g2_dfrbpq_1
XFILLER_26_631 VPWR VGND sg13g2_fill_2
XFILLER_25_141 VPWR VGND sg13g2_fill_1
XFILLER_26_653 VPWR VGND sg13g2_decap_8
XFILLER_41_601 VPWR VGND sg13g2_decap_8
XFILLER_40_100 VPWR VGND sg13g2_decap_8
XFILLER_41_667 VPWR VGND sg13g2_fill_2
XFILLER_40_111 VPWR VGND sg13g2_fill_2
XFILLER_22_892 VPWR VGND sg13g2_decap_8
XFILLER_5_513 VPWR VGND sg13g2_decap_4
XFILLER_31_85 VPWR VGND sg13g2_decap_8
Xoutput6 net6 tmds_r VPWR VGND sg13g2_buf_1
XFILLER_1_785 VPWR VGND sg13g2_decap_8
X_5124__217 VPWR VGND net217 sg13g2_tiehi
XFILLER_48_255 VPWR VGND sg13g2_decap_8
XFILLER_17_620 VPWR VGND sg13g2_decap_8
XFILLER_45_951 VPWR VGND sg13g2_decap_8
X_5020__226 VPWR VGND net226 sg13g2_tiehi
XFILLER_32_667 VPWR VGND sg13g2_fill_1
X_3790_ videogen.test_lut_thingy.pixel_feeder_inst.row\[11\]\[1\] net572 _1508_ VPWR
+ VGND sg13g2_nor2_1
X_2810_ videogen.test_lut_thingy.pixel_feeder_inst.row\[51\]\[1\] net786 _0783_ _0534_
+ VPWR VGND sg13g2_mux2_1
X_2741_ VGND VPWR _0765_ _0754_ _0724_ sg13g2_or2_1
X_4894__433 VPWR VGND net433 sg13g2_tiehi
X_4411_ net554 VPWR _2092_ VGND _2064_ _2084_ sg13g2_o21ai_1
X_2672_ videogen.test_lut_thingy.pixel_feeder_inst.row\[23\]\[2\] net779 _0734_ _0633_
+ VPWR VGND sg13g2_mux2_1
X_4342_ _0683_ _2001_ _2031_ VPWR VGND _2023_ sg13g2_nand3b_1
X_4273_ _1976_ _1952_ _1954_ VPWR VGND sg13g2_nand2_1
X_5146__442 VPWR VGND net442 sg13g2_tiehi
X_3224_ tmds_green.dc_balancing_reg\[0\] net554 _0341_ VPWR VGND sg13g2_and2_1
.ends
