* NGSPICE file created from heichips25_bagel.ext - technology: ihp-sg13g2

* Black-box entry subcircuit for sg13g2_fill_2 abstract view
.subckt sg13g2_fill_2 VDD VSS
.ends

* Black-box entry subcircuit for sg13g2_decap_8 abstract view
.subckt sg13g2_decap_8 VDD VSS
.ends

* Black-box entry subcircuit for sg13g2_nor3_2 abstract view
.subckt sg13g2_nor3_2 A B C Y VDD VSS
.ends

* Black-box entry subcircuit for sg13g2_xnor2_1 abstract view
.subckt sg13g2_xnor2_1 Y A B VDD VSS
.ends

* Black-box entry subcircuit for sg13g2_nand2_1 abstract view
.subckt sg13g2_nand2_1 Y A B VDD VSS
.ends

* Black-box entry subcircuit for sg13g2_o21ai_1 abstract view
.subckt sg13g2_o21ai_1 B1 VDD Y VSS A1 A2
.ends

* Black-box entry subcircuit for sg13g2_buf_8 abstract view
.subckt sg13g2_buf_8 A X VDD VSS
.ends

* Black-box entry subcircuit for sg13g2_decap_4 abstract view
.subckt sg13g2_decap_4 VDD VSS
.ends

* Black-box entry subcircuit for sg13g2_fill_1 abstract view
.subckt sg13g2_fill_1 VDD VSS
.ends

* Black-box entry subcircuit for sg13g2_tiehi abstract view
.subckt sg13g2_tiehi VDD VSS L_HI
.ends

* Black-box entry subcircuit for sg13g2_inv_1 abstract view
.subckt sg13g2_inv_1 VDD Y A VSS
.ends

* Black-box entry subcircuit for sg13g2_or3_1 abstract view
.subckt sg13g2_or3_1 A B C X VDD VSS
.ends

* Black-box entry subcircuit for sg13g2_nor2_1 abstract view
.subckt sg13g2_nor2_1 A B Y VDD VSS
.ends

* Black-box entry subcircuit for sg13g2_dfrbpq_1 abstract view
.subckt sg13g2_dfrbpq_1 RESET_B VSS VDD D Q CLK
.ends

* Black-box entry subcircuit for sg13g2_a21oi_1 abstract view
.subckt sg13g2_a21oi_1 VSS VDD A1 A2 Y B1
.ends

* Black-box entry subcircuit for sg13g2_nor4_1 abstract view
.subckt sg13g2_nor4_1 A B C D Y VDD VSS
.ends

* Black-box entry subcircuit for sg13g2_xor2_1 abstract view
.subckt sg13g2_xor2_1 B A X VDD VSS
.ends

* Black-box entry subcircuit for sg13g2_nor3_1 abstract view
.subckt sg13g2_nor3_1 A B C Y VDD VSS
.ends

* Black-box entry subcircuit for sg13g2_and3_1 abstract view
.subckt sg13g2_and3_1 X A B C VDD VSS
.ends

* Black-box entry subcircuit for sg13g2_and3_2 abstract view
.subckt sg13g2_and3_2 X A B C VDD VSS
.ends

* Black-box entry subcircuit for sg13g2_a21o_1 abstract view
.subckt sg13g2_a21o_1 A2 A1 B1 X VDD VSS
.ends

* Black-box entry subcircuit for sg13g2_mux2_1 abstract view
.subckt sg13g2_mux2_1 A0 A1 S X VDD VSS
.ends

* Black-box entry subcircuit for sg13g2_nor2_2 abstract view
.subckt sg13g2_nor2_2 A B Y VDD VSS
.ends

* Black-box entry subcircuit for sg13g2_dfrbpq_2 abstract view
.subckt sg13g2_dfrbpq_2 RESET_B VSS VDD D Q CLK
.ends

* Black-box entry subcircuit for sg13g2_nor2b_1 abstract view
.subckt sg13g2_nor2b_1 A B_N Y VDD VSS
.ends

* Black-box entry subcircuit for sg13g2_nand4_1 abstract view
.subckt sg13g2_nand4_1 B C A Y VDD VSS D
.ends

* Black-box entry subcircuit for sg13g2_and2_1 abstract view
.subckt sg13g2_and2_1 A B X VDD VSS
.ends

* Black-box entry subcircuit for sg13g2_a22oi_1 abstract view
.subckt sg13g2_a22oi_1 Y B1 B2 A2 A1 VDD VSS
.ends

* Black-box entry subcircuit for sg13g2_tielo abstract view
.subckt sg13g2_tielo VDD VSS L_LO
.ends

* Black-box entry subcircuit for sg13g2_nand3b_1 abstract view
.subckt sg13g2_nand3b_1 B C Y VDD VSS A_N
.ends

* Black-box entry subcircuit for sg13g2_or2_1 abstract view
.subckt sg13g2_or2_1 VSS VDD X B A
.ends

* Black-box entry subcircuit for sg13g2_or4_1 abstract view
.subckt sg13g2_or4_1 A B C D X VDD VSS
.ends

* Black-box entry subcircuit for sg13g2_dlygate4sd3_1 abstract view
.subckt sg13g2_dlygate4sd3_1 A VDD VSS X
.ends

* Black-box entry subcircuit for sg13g2_nand2b_1 abstract view
.subckt sg13g2_nand2b_1 Y B A_N VDD VSS
.ends

* Black-box entry subcircuit for sg13g2_buf_1 abstract view
.subckt sg13g2_buf_1 A X VDD VSS
.ends

* Black-box entry subcircuit for sg13g2_a221oi_1 abstract view
.subckt sg13g2_a221oi_1 VDD VSS B2 C1 B1 A1 Y A2
.ends

* Black-box entry subcircuit for sg13g2_nor2b_2 abstract view
.subckt sg13g2_nor2b_2 A B_N Y VDD VSS
.ends

* Black-box entry subcircuit for sg13g2_nand3_1 abstract view
.subckt sg13g2_nand3_1 B C A Y VDD VSS
.ends

* Black-box entry subcircuit for sg13g2_a21o_2 abstract view
.subckt sg13g2_a21o_2 A2 A1 B1 X VDD VSS
.ends

* Black-box entry subcircuit for sg13g2_inv_2 abstract view
.subckt sg13g2_inv_2 Y A VDD VSS
.ends

* Black-box entry subcircuit for sg13g2_mux4_1 abstract view
.subckt sg13g2_mux4_1 S0 A0 A1 A2 A3 S1 X VDD VSS
.ends

* Black-box entry subcircuit for sg13g2_buf_2 abstract view
.subckt sg13g2_buf_2 A X VDD VSS
.ends

* Black-box entry subcircuit for sg13g2_a21oi_2 abstract view
.subckt sg13g2_a21oi_2 VSS VDD B1 Y A2 A1
.ends

* Black-box entry subcircuit for sg13g2_nand2_2 abstract view
.subckt sg13g2_nand2_2 Y A B VDD VSS
.ends

* Black-box entry subcircuit for sg13g2_and4_1 abstract view
.subckt sg13g2_and4_1 A B C D X VDD VSS
.ends

* Black-box entry subcircuit for sg13g2_nand2b_2 abstract view
.subckt sg13g2_nand2b_2 Y B VDD VSS A_N
.ends

* Black-box entry subcircuit for sg13g2_inv_4 abstract view
.subckt sg13g2_inv_4 A Y VDD VSS
.ends

.subckt heichips25_bagel VGND VPWR clk ena rst_n tmds_b tmds_clk tmds_g tmds_r ui_in[0]
+ ui_in[1] ui_in[2] ui_in[3] ui_in[4] ui_in[5] ui_in[6] ui_in[7] uio_in[0] uio_in[1]
+ uio_in[2] uio_in[3] uio_in[4] uio_in[5] uio_in[6] uio_in[7] uio_oe[0] uio_oe[1]
+ uio_oe[2] uio_oe[3] uio_oe[4] uio_oe[5] uio_oe[6] uio_oe[7] uio_out[0] uio_out[1]
+ uio_out[2] uio_out[3] uio_out[4] uio_out[5] uio_out[6] uio_out[7] uo_out[0] uo_out[1]
+ uo_out[2] uo_out[3] uo_out[4] uo_out[5] uo_out[6] uo_out[7]
XFILLER_27_439 VPWR VGND sg13g2_fill_2
XFILLER_36_973 VPWR VGND sg13g2_decap_8
X_3988_ _0727_ _1025_ _1032_ _1033_ VPWR VGND sg13g2_nor3_2
XFILLER_10_339 VPWR VGND sg13g2_fill_2
X_5727_ _2687_ blue\[0\] blue\[1\] VPWR VGND sg13g2_xnor2_1
X_5658_ _2626_ _2579_ _2624_ VPWR VGND sg13g2_nand2_1
X_5589_ _2566_ green\[2\] _2564_ VPWR VGND sg13g2_xnor2_1
X_4609_ _1615_ VPWR _1616_ VGND _1580_ _1591_ sg13g2_o21ai_1
XFILLER_2_516 VPWR VGND sg13g2_decap_8
Xfanout831 net832 net831 VPWR VGND sg13g2_buf_8
Xfanout820 net841 net820 VPWR VGND sg13g2_buf_8
Xfanout842 net848 net842 VPWR VGND sg13g2_buf_8
Xfanout853 net859 net853 VPWR VGND sg13g2_buf_8
Xfanout875 ui_in[5] net875 VPWR VGND sg13g2_buf_8
Xfanout864 ui_in[6] net864 VPWR VGND sg13g2_buf_8
Xfanout886 net887 net886 VPWR VGND sg13g2_buf_8
Xfanout897 net900 net897 VPWR VGND sg13g2_buf_8
XFILLER_46_748 VPWR VGND sg13g2_fill_2
XFILLER_46_737 VPWR VGND sg13g2_decap_8
XFILLER_42_910 VPWR VGND sg13g2_decap_8
XFILLER_26_63 VPWR VGND sg13g2_decap_8
XFILLER_42_987 VPWR VGND sg13g2_decap_8
XFILLER_41_453 VPWR VGND sg13g2_fill_2
XFILLER_14_667 VPWR VGND sg13g2_fill_2
XFILLER_42_40 VPWR VGND sg13g2_decap_4
XFILLER_9_137 VPWR VGND sg13g2_decap_4
XFILLER_13_188 VPWR VGND sg13g2_fill_1
Xclkbuf_3_6__f_clk_regs clknet_0_clk_regs clknet_3_6__leaf_clk_regs VPWR VGND sg13g2_buf_8
XFILLER_10_840 VPWR VGND sg13g2_decap_8
XFILLER_10_851 VPWR VGND sg13g2_fill_2
XFILLER_6_855 VPWR VGND sg13g2_fill_1
XFILLER_6_833 VPWR VGND sg13g2_decap_8
X_6295__270 VPWR VGND net270 sg13g2_tiehi
XFILLER_49_597 VPWR VGND sg13g2_decap_8
XFILLER_18_962 VPWR VGND sg13g2_fill_2
XFILLER_45_792 VPWR VGND sg13g2_decap_8
XFILLER_45_770 VPWR VGND sg13g2_fill_2
X_4960_ VPWR _1967_ _1966_ VGND sg13g2_inv_1
X_4891_ _1866_ _1880_ _1897_ _1898_ VPWR VGND sg13g2_or3_1
XFILLER_44_291 VPWR VGND sg13g2_fill_1
X_3911_ _0981_ VPWR _0982_ VGND videogen.test_lut_thingy.pixel_feeder_inst.v_counter\[1\]
+ _0949_ sg13g2_o21ai_1
XFILLER_32_420 VPWR VGND sg13g2_fill_2
X_3842_ net615 _0941_ _0277_ VPWR VGND sg13g2_nor2_1
X_6630_ net207 VGND VPWR _0685_ serialize.shift_reg_b\[0\] clknet_3_1__leaf_clk_regs
+ sg13g2_dfrbpq_1
X_6561_ net461 VGND VPWR _0616_ videogen.test_lut_thingy.pixel_feeder_inst.row\[42\]\[2\]
+ _0203_ sg13g2_dfrbpq_1
X_5512_ net632 VPWR _2498_ VGND _2472_ _2497_ sg13g2_o21ai_1
X_3773_ VGND VPWR net619 _0902_ net10 _0743_ sg13g2_a21oi_1
XFILLER_9_682 VPWR VGND sg13g2_decap_4
X_6492_ net315 VGND VPWR _0547_ videogen.test_lut_thingy.pixel_feeder_inst.row\[54\]\[2\]
+ _0143_ sg13g2_dfrbpq_1
X_5443_ _0416_ _2273_ _2434_ VPWR VGND sg13g2_nand2_1
X_5374_ _2367_ _2278_ _2347_ VPWR VGND sg13g2_xnor2_1
X_6612__487 VPWR VGND net487 sg13g2_tiehi
X_4325_ net694 _1328_ _1329_ _1331_ _1332_ VPWR VGND sg13g2_nor4_1
X_4256_ _1189_ _1257_ _1263_ VPWR VGND sg13g2_nor2_1
XFILLER_47_29 VPWR VGND sg13g2_decap_8
X_4187_ _1160_ VPWR _1194_ VGND _1191_ _1193_ sg13g2_o21ai_1
X_6348__171 VPWR VGND net171 sg13g2_tiehi
X_6604__70 VPWR VGND net70 sg13g2_tiehi
XFILLER_7_608 VPWR VGND sg13g2_decap_8
XFILLER_11_659 VPWR VGND sg13g2_fill_1
XFILLER_6_118 VPWR VGND sg13g2_fill_1
X_6355__164 VPWR VGND net164 sg13g2_tiehi
XFILLER_5_4 VPWR VGND sg13g2_decap_8
Xfanout650 net651 net650 VPWR VGND sg13g2_buf_8
Xfanout672 videogen.another_shader.video_y\[5\] net672 VPWR VGND sg13g2_buf_8
Xfanout683 videogen.test_lut_thingy.pixel_feeder_inst.h_pix\[4\] net683 VPWR VGND
+ sg13g2_buf_8
Xfanout661 net663 net661 VPWR VGND sg13g2_buf_8
Xfanout694 net695 net694 VPWR VGND sg13g2_buf_8
X_6624__325 VPWR VGND net325 sg13g2_tiehi
XFILLER_46_534 VPWR VGND sg13g2_decap_8
X_6362__157 VPWR VGND net157 sg13g2_tiehi
XFILLER_33_239 VPWR VGND sg13g2_fill_2
XFILLER_6_696 VPWR VGND sg13g2_decap_8
XFILLER_5_151 VPWR VGND sg13g2_fill_2
X_5090_ VPWR _2097_ _2096_ VGND sg13g2_inv_1
X_4110_ videogen.fancy_shader.shader_counter_reg\[1\] videogen.another_shader.video_x\[1\]
+ _1117_ VPWR VGND sg13g2_xor2_1
X_4041_ _1067_ _1069_ _1070_ _0378_ VPWR VGND sg13g2_nor3_1
XFILLER_49_361 VPWR VGND sg13g2_decap_8
X_5992_ net760 net803 _0053_ VPWR VGND sg13g2_nor2_1
X_4943_ _1950_ _1740_ _1946_ _1948_ VPWR VGND sg13g2_and3_1
XFILLER_24_239 VPWR VGND sg13g2_fill_1
XFILLER_33_773 VPWR VGND sg13g2_decap_8
X_4874_ _1869_ _1875_ _1879_ _1881_ VPWR VGND sg13g2_nor3_1
X_6613_ net479 VGND VPWR _0668_ videogen.test_lut_thingy.pixel_feeder_inst.row\[24\]\[3\]
+ _0244_ sg13g2_dfrbpq_1
X_3825_ net717 _0887_ _0932_ VPWR VGND sg13g2_nor2_1
XFILLER_32_294 VPWR VGND sg13g2_fill_2
X_3756_ _0892_ net712 net713 _0890_ VPWR VGND sg13g2_and3_2
X_6544_ net72 VGND VPWR _0599_ videogen.test_lut_thingy.pixel_feeder_inst.row\[46\]\[1\]
+ _0186_ sg13g2_dfrbpq_1
X_6475_ net391 VGND VPWR _0530_ videogen.test_lut_thingy.pixel_feeder_inst.row\[56\]\[1\]
+ _0126_ sg13g2_dfrbpq_1
X_5426_ _2409_ _2402_ _2405_ _2419_ VPWR VGND sg13g2_a21o_1
X_3687_ videogen.test_lut_thingy.pixel_feeder_inst.row\[15\]\[1\] net876 _0868_ _0445_
+ VPWR VGND sg13g2_mux2_1
X_5357_ _2350_ _2281_ _2349_ VPWR VGND sg13g2_xnor2_1
X_4308_ _1315_ _0739_ net705 VPWR VGND sg13g2_nand2_1
X_5288_ _2281_ _1140_ _2279_ VPWR VGND sg13g2_nand2_1
X_4239_ _1235_ VPWR _1246_ VGND _1240_ _1245_ sg13g2_o21ai_1
X_6435__43 VPWR VGND net43 sg13g2_tiehi
XFILLER_43_504 VPWR VGND sg13g2_fill_2
XFILLER_15_206 VPWR VGND sg13g2_fill_2
XFILLER_11_423 VPWR VGND sg13g2_fill_1
XFILLER_3_633 VPWR VGND sg13g2_decap_8
XFILLER_2_110 VPWR VGND sg13g2_fill_1
XFILLER_2_154 VPWR VGND sg13g2_decap_8
XFILLER_2_165 VPWR VGND sg13g2_fill_1
XFILLER_2_198 VPWR VGND sg13g2_fill_2
XFILLER_48_50 VPWR VGND sg13g2_fill_1
XFILLER_47_832 VPWR VGND sg13g2_decap_8
XFILLER_0_35 VPWR VGND sg13g2_decap_8
XFILLER_30_710 VPWR VGND sg13g2_fill_1
XFILLER_9_66 VPWR VGND sg13g2_decap_4
X_6301__258 VPWR VGND net258 sg13g2_tiehi
X_4590_ net692 VPWR _1597_ VGND videogen.test_lut_thingy.pixel_feeder_inst.row\[12\]\[0\]
+ net648 sg13g2_o21ai_1
X_3610_ videogen.test_lut_thingy.pixel_feeder_inst.row\[5\]\[0\] net882 _0850_ _0513_
+ VPWR VGND sg13g2_mux2_1
XFILLER_31_1023 VPWR VGND sg13g2_decap_4
X_3541_ _0803_ _0805_ _0837_ VPWR VGND sg13g2_nor2_2
X_6260_ net340 VGND VPWR _0319_ videogen.test_lut_thingy.pixel_feeder_inst.v_pix\[3\]
+ net724 sg13g2_dfrbpq_2
X_3472_ _0794_ _0815_ _0820_ VPWR VGND sg13g2_nor2_2
X_6338__181 VPWR VGND net181 sg13g2_tiehi
X_5211_ _2209_ _2208_ _2210_ VPWR VGND sg13g2_nor2b_1
X_6191_ net791 net834 _0251_ VPWR VGND sg13g2_nor2_1
X_5142_ _1670_ _2147_ _0401_ _2149_ VPWR VGND _2148_ sg13g2_nand4_1
XFILLER_29_0 VPWR VGND sg13g2_fill_2
X_5073_ _2078_ _2079_ _2080_ VPWR VGND sg13g2_and2_1
XFILLER_49_191 VPWR VGND sg13g2_fill_2
X_4024_ VGND VPWR _0723_ _1056_ _0373_ _1058_ sg13g2_a21oi_1
XFILLER_38_843 VPWR VGND sg13g2_fill_2
XFILLER_37_342 VPWR VGND sg13g2_fill_1
XFILLER_38_887 VPWR VGND sg13g2_fill_1
X_5975_ net783 net826 _0036_ VPWR VGND sg13g2_nor2_1
X_6345__174 VPWR VGND net174 sg13g2_tiehi
X_4926_ _1931_ _1930_ _1927_ _1933_ VPWR VGND sg13g2_a21o_1
X_4857_ _1864_ _1860_ _1862_ _1749_ _1747_ VPWR VGND sg13g2_a22oi_1
X_3808_ net792 net834 _0005_ VPWR VGND sg13g2_nor2_1
X_4788_ _1795_ _1772_ _1776_ VPWR VGND sg13g2_xnor2_1
XFILLER_5_909 VPWR VGND sg13g2_decap_4
X_6527_ net189 VGND VPWR _0582_ videogen.test_lut_thingy.pixel_feeder_inst.row\[50\]\[0\]
+ _0169_ sg13g2_dfrbpq_1
Xheichips25_bagel_24 VPWR VGND uio_oe[3] sg13g2_tielo
X_3739_ _0797_ _0825_ _0879_ VPWR VGND sg13g2_nor2_2
X_6458_ net454 VGND VPWR _0513_ videogen.test_lut_thingy.pixel_feeder_inst.row\[5\]\[0\]
+ _0109_ sg13g2_dfrbpq_1
X_5409_ _2399_ _2391_ _2402_ VPWR VGND _2401_ sg13g2_nand3b_1
X_6389_ net118 VGND VPWR _0448_ videogen.test_lut_thingy.pixel_feeder_inst.row\[11\]\[0\]
+ _0053_ sg13g2_dfrbpq_1
X_6352__167 VPWR VGND net167 sg13g2_tiehi
XFILLER_48_607 VPWR VGND sg13g2_fill_1
XFILLER_0_658 VPWR VGND sg13g2_decap_8
XFILLER_29_821 VPWR VGND sg13g2_fill_1
XFILLER_28_353 VPWR VGND sg13g2_fill_1
XFILLER_44_835 VPWR VGND sg13g2_decap_8
XFILLER_43_345 VPWR VGND sg13g2_decap_8
XFILLER_31_507 VPWR VGND sg13g2_fill_2
XFILLER_15_1018 VPWR VGND sg13g2_decap_8
XFILLER_4_975 VPWR VGND sg13g2_decap_8
X_6485__343 VPWR VGND net343 sg13g2_tiehi
XFILLER_19_320 VPWR VGND sg13g2_fill_2
XFILLER_35_846 VPWR VGND sg13g2_decap_8
X_5760_ _2689_ _2719_ _2720_ VPWR VGND sg13g2_and2_1
X_5691_ _2656_ VPWR _2657_ VGND _2625_ _2636_ sg13g2_o21ai_1
X_4711_ _1716_ _1717_ _1718_ VPWR VGND sg13g2_nor2_1
X_4642_ net664 _1643_ _1648_ _1649_ VPWR VGND sg13g2_nor3_1
X_6457__456 VPWR VGND net456 sg13g2_tiehi
X_4573_ net700 _1574_ _1579_ _1580_ VPWR VGND sg13g2_nor3_1
X_6312_ net236 VGND VPWR _0371_ videogen.another_shader.time_cnt\[27\] net731 sg13g2_dfrbpq_1
X_3524_ net872 videogen.test_lut_thingy.pixel_feeder_inst.row\[48\]\[1\] _0833_ _0591_
+ VPWR VGND sg13g2_mux2_1
X_3455_ VGND VPWR _0815_ _0814_ _0789_ sg13g2_or2_1
X_6243_ net368 VGND VPWR _0302_ serialize.shift_reg_c\[0\] clknet_3_0__leaf_clk_regs
+ sg13g2_dfrbpq_1
X_6174_ net769 net812 _0234_ VPWR VGND sg13g2_nor2_1
X_3386_ net664 _0739_ net705 _0771_ _0778_ VPWR VGND sg13g2_or4_1
X_5125_ _2116_ _2131_ _2132_ VPWR VGND sg13g2_nor2_1
X_5056_ _2052_ _2060_ _2063_ VPWR VGND sg13g2_and2_1
X_4007_ net847 _1045_ _1046_ _0368_ VPWR VGND sg13g2_nor3_1
XFILLER_37_172 VPWR VGND sg13g2_fill_2
XFILLER_38_1007 VPWR VGND sg13g2_decap_8
XFILLER_13_507 VPWR VGND sg13g2_fill_1
X_5958_ net784 net827 _0019_ VPWR VGND sg13g2_nor2_1
X_4909_ _1912_ _1915_ _1916_ VPWR VGND sg13g2_nor2b_1
XFILLER_21_573 VPWR VGND sg13g2_fill_2
X_5889_ _2836_ hsync tmds_blue.vsync VPWR VGND sg13g2_xnor2_1
XFILLER_0_455 VPWR VGND sg13g2_decap_8
XFILLER_1_956 VPWR VGND sg13g2_decap_8
Xhold30 serialize.shift_reg_g\[2\] VPWR VGND net518 sg13g2_dlygate4sd3_1
XFILLER_29_96 VPWR VGND sg13g2_fill_1
XFILLER_16_301 VPWR VGND sg13g2_decap_8
XFILLER_16_312 VPWR VGND sg13g2_fill_2
XFILLER_45_51 VPWR VGND sg13g2_fill_2
XFILLER_43_186 VPWR VGND sg13g2_decap_8
XFILLER_16_389 VPWR VGND sg13g2_fill_1
XFILLER_31_326 VPWR VGND sg13g2_fill_1
XFILLER_8_511 VPWR VGND sg13g2_fill_1
XFILLER_8_500 VPWR VGND sg13g2_fill_1
XFILLER_6_56 VPWR VGND sg13g2_fill_2
XFILLER_39_404 VPWR VGND sg13g2_fill_1
XFILLER_20_4 VPWR VGND sg13g2_decap_8
XFILLER_48_993 VPWR VGND sg13g2_decap_8
X_5812_ tmds_blue.dc_balancing_reg\[1\] _2732_ _2771_ VPWR VGND sg13g2_nor2_1
XFILLER_35_698 VPWR VGND sg13g2_fill_1
X_6342__177 VPWR VGND net177 sg13g2_tiehi
X_5743_ _2703_ _2702_ _2697_ VPWR VGND sg13g2_nand2b_1
X_5674_ _2631_ _2640_ _2641_ VPWR VGND sg13g2_nor2b_1
X_4625_ net689 _1628_ _1629_ _1631_ _1632_ VPWR VGND sg13g2_nor4_1
X_6615__463 VPWR VGND net463 sg13g2_tiehi
X_4556_ net891 VPWR _1563_ VGND _1551_ _1562_ sg13g2_o21ai_1
X_3507_ videogen.test_lut_thingy.pixel_feeder_inst.row\[45\]\[3\] net856 _0830_ _0605_
+ VPWR VGND sg13g2_mux2_1
X_4487_ net664 _1488_ _1493_ _1494_ VPWR VGND sg13g2_nor3_1
X_6226_ net397 VGND VPWR _0285_ serialize.shift_reg_g\[9\] clknet_3_4__leaf_clk_regs
+ sg13g2_dfrbpq_1
X_3438_ net862 videogen.test_lut_thingy.pixel_feeder_inst.row\[49\]\[2\] _0808_ _0652_
+ VPWR VGND sg13g2_mux2_1
X_6157_ net783 net826 _0217_ VPWR VGND sg13g2_nor2_1
X_3369_ _0758_ _0760_ _0761_ VPWR VGND sg13g2_and2_1
X_5108_ _2113_ _2114_ _2115_ VPWR VGND sg13g2_and2_1
X_6088_ net756 net798 _0148_ VPWR VGND sg13g2_nor2_1
XFILLER_26_632 VPWR VGND sg13g2_decap_8
X_5039_ _2046_ _2021_ _2027_ VPWR VGND sg13g2_xnor2_1
XFILLER_26_643 VPWR VGND sg13g2_fill_2
XFILLER_13_304 VPWR VGND sg13g2_fill_2
XFILLER_41_668 VPWR VGND sg13g2_decap_8
Xclkbuf_3_5__f_clk_regs clknet_0_clk_regs clknet_3_5__leaf_clk_regs VPWR VGND sg13g2_buf_8
XFILLER_5_525 VPWR VGND sg13g2_decap_8
XFILLER_31_75 VPWR VGND sg13g2_fill_2
Xoutput20 net20 uo_out[7] VPWR VGND sg13g2_buf_1
XFILLER_1_720 VPWR VGND sg13g2_decap_8
Xoutput7 net7 uio_out[0] VPWR VGND sg13g2_buf_1
XFILLER_49_713 VPWR VGND sg13g2_decap_8
XFILLER_0_252 VPWR VGND sg13g2_decap_4
XFILLER_36_429 VPWR VGND sg13g2_decap_8
XFILLER_45_974 VPWR VGND sg13g2_decap_8
XFILLER_16_131 VPWR VGND sg13g2_fill_2
XFILLER_31_123 VPWR VGND sg13g2_decap_8
XFILLER_31_134 VPWR VGND sg13g2_decap_8
X_4410_ videogen.test_lut_thingy.pixel_feeder_inst.row\[26\]\[1\] net635 _1417_ VPWR
+ VGND sg13g2_nor2_1
XFILLER_8_374 VPWR VGND sg13g2_fill_2
X_5390_ _2381_ _2382_ _2383_ VPWR VGND sg13g2_nor2_1
X_4341_ _1344_ _1345_ _1346_ _1347_ _1348_ VPWR VGND sg13g2_nor4_1
X_4272_ _1268_ VPWR _1279_ VGND _1269_ _1278_ sg13g2_o21ai_1
X_6011_ net792 net835 _0072_ VPWR VGND sg13g2_nor2_1
XFILLER_48_790 VPWR VGND sg13g2_decap_8
XFILLER_36_952 VPWR VGND sg13g2_decap_8
X_3987_ _1032_ videogen.another_shader.time_cnt\[19\] videogen.another_shader.time_cnt\[18\]
+ VPWR VGND sg13g2_nand2_1
XFILLER_22_189 VPWR VGND sg13g2_fill_1
X_5726_ _2686_ blue\[0\] blue\[1\] VPWR VGND sg13g2_nand2_1
X_5657_ _2625_ _2580_ _2623_ VPWR VGND sg13g2_nand2_1
X_5588_ green\[2\] _2564_ _2565_ VPWR VGND sg13g2_and2_1
X_4608_ net682 _1614_ _1615_ VPWR VGND sg13g2_nor2_1
X_4539_ VPWR _1546_ _1545_ VGND sg13g2_inv_1
Xfanout832 net833 net832 VPWR VGND sg13g2_buf_8
Xfanout810 net813 net810 VPWR VGND sg13g2_buf_8
Xfanout821 net822 net821 VPWR VGND sg13g2_buf_8
X_6209_ net418 VGND VPWR _0268_ videogen.another_shader.video_x\[0\] net727 sg13g2_dfrbpq_2
Xfanout843 net848 net843 VPWR VGND sg13g2_buf_8
Xfanout854 net858 net854 VPWR VGND sg13g2_buf_8
Xfanout876 net880 net876 VPWR VGND sg13g2_buf_8
Xfanout865 net869 net865 VPWR VGND sg13g2_buf_8
XFILLER_18_407 VPWR VGND sg13g2_fill_2
Xfanout887 net890 net887 VPWR VGND sg13g2_buf_8
Xfanout898 net900 net898 VPWR VGND sg13g2_buf_1
XFILLER_42_966 VPWR VGND sg13g2_decap_8
XFILLER_41_421 VPWR VGND sg13g2_fill_2
XFILLER_41_410 VPWR VGND sg13g2_fill_1
XFILLER_13_112 VPWR VGND sg13g2_fill_2
XFILLER_13_123 VPWR VGND sg13g2_decap_8
X_6223__402 VPWR VGND net402 sg13g2_tiehi
XFILLER_41_476 VPWR VGND sg13g2_fill_1
XFILLER_41_443 VPWR VGND sg13g2_fill_2
XFILLER_42_96 VPWR VGND sg13g2_fill_1
XFILLER_42_85 VPWR VGND sg13g2_decap_8
XFILLER_5_300 VPWR VGND sg13g2_fill_1
XFILLER_5_366 VPWR VGND sg13g2_fill_1
X_6550__48 VPWR VGND net48 sg13g2_tiehi
XFILLER_3_46 VPWR VGND sg13g2_decap_4
XFILLER_49_510 VPWR VGND sg13g2_decap_8
XFILLER_1_594 VPWR VGND sg13g2_decap_8
XFILLER_3_1008 VPWR VGND sg13g2_decap_8
XFILLER_36_237 VPWR VGND sg13g2_decap_4
X_4890_ VPWR VGND _1894_ _1888_ _1886_ _1750_ _1897_ _1882_ sg13g2_a221oi_1
X_3910_ _0949_ VPWR _0981_ VGND videogen.test_lut_thingy.pixel_feeder_inst.v_counter\[3\]
+ _0980_ sg13g2_o21ai_1
X_3841_ _0940_ net708 _0941_ VPWR VGND sg13g2_xor2_1
X_3772_ _0902_ net696 net652 VPWR VGND sg13g2_xnor2_1
X_6560_ net465 VGND VPWR _0615_ videogen.test_lut_thingy.pixel_feeder_inst.row\[42\]\[1\]
+ _0202_ sg13g2_dfrbpq_1
XFILLER_34_1021 VPWR VGND sg13g2_decap_8
X_5511_ _2496_ VPWR _2497_ VGND _2457_ _2495_ sg13g2_o21ai_1
XFILLER_9_661 VPWR VGND sg13g2_decap_8
X_6491_ net319 VGND VPWR _0546_ videogen.test_lut_thingy.pixel_feeder_inst.row\[54\]\[1\]
+ _0142_ sg13g2_dfrbpq_1
X_5442_ VPWR _0418_ _2434_ VGND sg13g2_inv_1
X_5373_ _2366_ _2357_ _2362_ VPWR VGND sg13g2_xnor2_1
X_4324_ _1330_ VPWR _1331_ VGND videogen.test_lut_thingy.pixel_feeder_inst.row\[23\]\[2\]
+ net660 sg13g2_o21ai_1
X_6311__238 VPWR VGND net238 sg13g2_tiehi
X_4255_ _1184_ VPWR _1262_ VGND _1190_ _1258_ sg13g2_o21ai_1
X_4186_ VPWR _1193_ _1192_ VGND sg13g2_inv_1
XFILLER_27_204 VPWR VGND sg13g2_fill_2
XFILLER_27_237 VPWR VGND sg13g2_fill_2
XFILLER_42_207 VPWR VGND sg13g2_fill_2
XFILLER_24_955 VPWR VGND sg13g2_fill_2
XFILLER_23_465 VPWR VGND sg13g2_decap_4
XFILLER_10_159 VPWR VGND sg13g2_fill_2
X_5709_ _2607_ VPWR _2674_ VGND _2658_ _2673_ sg13g2_o21ai_1
XFILLER_3_837 VPWR VGND sg13g2_decap_8
Xfanout640 net641 net640 VPWR VGND sg13g2_buf_8
Xfanout651 _0776_ net651 VPWR VGND sg13g2_buf_8
Xfanout673 videogen.another_shader.video_y\[4\] net673 VPWR VGND sg13g2_buf_8
Xfanout684 videogen.test_lut_thingy.pixel_feeder_inst.h_pix\[4\] net684 VPWR VGND
+ sg13g2_buf_1
Xfanout662 net663 net662 VPWR VGND sg13g2_buf_8
Xfanout695 videogen.test_lut_thingy.pixel_feeder_inst.h_pix\[3\] net695 VPWR VGND
+ sg13g2_buf_8
XFILLER_18_248 VPWR VGND sg13g2_fill_1
XFILLER_15_933 VPWR VGND sg13g2_fill_1
XFILLER_26_281 VPWR VGND sg13g2_fill_1
XFILLER_27_782 VPWR VGND sg13g2_decap_8
XFILLER_14_498 VPWR VGND sg13g2_fill_2
XFILLER_5_163 VPWR VGND sg13g2_decap_4
XFILLER_2_881 VPWR VGND sg13g2_decap_8
XFILLER_49_340 VPWR VGND sg13g2_fill_2
X_4040_ videogen.fancy_shader.shader_counter_reg\[2\] _1066_ _1070_ VPWR VGND sg13g2_nor2_1
X_5991_ net778 net821 _0052_ VPWR VGND sg13g2_nor2_1
X_4942_ VGND VPWR _1946_ _1948_ _1949_ _1740_ sg13g2_a21oi_1
X_4873_ _1880_ _1876_ _1878_ _1868_ _1751_ VPWR VGND sg13g2_a22oi_1
X_6612_ net487 VGND VPWR _0667_ videogen.test_lut_thingy.pixel_feeder_inst.row\[24\]\[2\]
+ _0243_ sg13g2_dfrbpq_1
X_3824_ _0767_ _0887_ _0930_ _0269_ VPWR VGND sg13g2_nor3_1
X_3755_ _0891_ videogen.another_shader.video_x\[6\] net714 VPWR VGND sg13g2_nand2_1
XFILLER_20_479 VPWR VGND sg13g2_decap_4
X_6543_ net76 VGND VPWR _0598_ videogen.test_lut_thingy.pixel_feeder_inst.row\[46\]\[0\]
+ _0185_ sg13g2_dfrbpq_1
X_3686_ videogen.test_lut_thingy.pixel_feeder_inst.row\[15\]\[2\] net865 _0868_ _0446_
+ VPWR VGND sg13g2_mux2_1
X_6474_ net399 VGND VPWR _0529_ videogen.test_lut_thingy.pixel_feeder_inst.row\[56\]\[0\]
+ _0125_ sg13g2_dfrbpq_1
X_5425_ VGND VPWR _2399_ _2412_ _2418_ _2417_ sg13g2_a21oi_1
X_5356_ _2349_ _1159_ _2348_ VPWR VGND sg13g2_nand2_1
X_5287_ _2280_ _2201_ _2279_ VPWR VGND sg13g2_xnor2_1
X_4307_ _1312_ _1313_ _1314_ VPWR VGND sg13g2_nor2b_2
X_4238_ _1244_ _1242_ _1239_ _1245_ VPWR VGND sg13g2_a21o_1
X_6467__436 VPWR VGND net436 sg13g2_tiehi
XFILLER_28_524 VPWR VGND sg13g2_decap_4
X_4169_ _1176_ videogen.another_shader.video_y\[9\] videogen.fancy_shader.shader_counter_reg\[9\]
+ VPWR VGND sg13g2_xnor2_1
XFILLER_7_406 VPWR VGND sg13g2_fill_1
XFILLER_23_98 VPWR VGND sg13g2_decap_8
XFILLER_3_612 VPWR VGND sg13g2_decap_8
XFILLER_2_122 VPWR VGND sg13g2_decap_4
XFILLER_3_689 VPWR VGND sg13g2_decap_8
XFILLER_2_177 VPWR VGND sg13g2_decap_8
XFILLER_47_811 VPWR VGND sg13g2_decap_8
XFILLER_48_62 VPWR VGND sg13g2_decap_8
XFILLER_19_513 VPWR VGND sg13g2_fill_1
XFILLER_0_14 VPWR VGND sg13g2_decap_8
XFILLER_47_888 VPWR VGND sg13g2_decap_8
XFILLER_46_365 VPWR VGND sg13g2_decap_4
X_6264__332 VPWR VGND net332 sg13g2_tiehi
XFILLER_42_582 VPWR VGND sg13g2_decap_4
XFILLER_15_785 VPWR VGND sg13g2_decap_8
XFILLER_9_56 VPWR VGND sg13g2_decap_4
XFILLER_30_744 VPWR VGND sg13g2_fill_1
XFILLER_31_1002 VPWR VGND sg13g2_fill_2
XFILLER_11_980 VPWR VGND sg13g2_decap_8
X_3540_ videogen.test_lut_thingy.pixel_feeder_inst.row\[51\]\[0\] net883 _0836_ _0578_
+ VPWR VGND sg13g2_mux2_1
XFILLER_7_995 VPWR VGND sg13g2_decap_8
XFILLER_6_472 VPWR VGND sg13g2_decap_8
XFILLER_6_494 VPWR VGND sg13g2_fill_1
X_3471_ videogen.test_lut_thingy.pixel_feeder_inst.row\[38\]\[0\] net887 _0819_ _0630_
+ VPWR VGND sg13g2_mux2_1
X_5210_ _2194_ _2206_ _2207_ _2209_ VPWR VGND sg13g2_nor3_1
X_6190_ net791 net834 _0250_ VPWR VGND sg13g2_nor2_1
XFILLER_9_1025 VPWR VGND sg13g2_decap_4
X_5141_ _2148_ net678 videogen.another_shader.time_cnt\[0\] VPWR VGND sg13g2_nand2_1
X_5072_ _2050_ VPWR _2079_ VGND _2063_ _2077_ sg13g2_o21ai_1
X_4023_ _1058_ net899 _1057_ VPWR VGND sg13g2_nand2_1
XFILLER_49_181 VPWR VGND sg13g2_decap_4
XFILLER_49_170 VPWR VGND sg13g2_fill_2
XFILLER_25_505 VPWR VGND sg13g2_fill_1
X_5974_ net783 net826 _0035_ VPWR VGND sg13g2_nor2_1
X_4925_ VGND VPWR _1930_ _1931_ _1932_ _1927_ sg13g2_a21oi_1
XFILLER_40_519 VPWR VGND sg13g2_decap_4
X_4856_ VPWR _1863_ _1862_ VGND sg13g2_inv_1
X_3807_ serialize.shift_reg_r\[1\] serialize.shift_reg_r\[0\] clknet_1_1__leaf_clk
+ net6 VPWR VGND sg13g2_mux2_1
X_4787_ _1782_ _1784_ _1794_ VPWR VGND sg13g2_nor2b_1
X_6526_ net193 VGND VPWR _0581_ videogen.test_lut_thingy.pixel_feeder_inst.row\[51\]\[3\]
+ _0168_ sg13g2_dfrbpq_1
X_3738_ videogen.test_lut_thingy.pixel_feeder_inst.row\[20\]\[0\] net888 _0878_ _0280_
+ VPWR VGND sg13g2_mux2_1
Xheichips25_bagel_25 VPWR VGND uio_oe[4] sg13g2_tielo
X_6317__222 VPWR VGND net222 sg13g2_tiehi
X_3669_ _0817_ _0854_ _0865_ VPWR VGND sg13g2_nor2_2
X_6457_ net456 VGND VPWR _0512_ videogen.test_lut_thingy.pixel_feeder_inst.row\[60\]\[3\]
+ _0108_ sg13g2_dfrbpq_1
X_6388_ net120 VGND VPWR _0447_ videogen.test_lut_thingy.pixel_feeder_inst.row\[15\]\[3\]
+ _0052_ sg13g2_dfrbpq_1
X_5408_ _2401_ _1231_ _2400_ VPWR VGND sg13g2_xnor2_1
XFILLER_0_637 VPWR VGND sg13g2_decap_8
X_5339_ _2332_ _2314_ _2331_ VPWR VGND sg13g2_xnor2_1
XFILLER_44_814 VPWR VGND sg13g2_decap_8
XFILLER_34_31 VPWR VGND sg13g2_decap_4
XFILLER_12_711 VPWR VGND sg13g2_fill_1
XFILLER_24_560 VPWR VGND sg13g2_decap_8
XFILLER_24_593 VPWR VGND sg13g2_decap_8
XFILLER_34_75 VPWR VGND sg13g2_decap_8
XFILLER_34_86 VPWR VGND sg13g2_decap_4
XFILLER_4_954 VPWR VGND sg13g2_decap_8
XFILLER_3_486 VPWR VGND sg13g2_fill_2
XFILLER_46_140 VPWR VGND sg13g2_fill_1
XFILLER_19_343 VPWR VGND sg13g2_fill_2
XFILLER_46_184 VPWR VGND sg13g2_fill_2
XFILLER_15_560 VPWR VGND sg13g2_decap_8
XFILLER_43_891 VPWR VGND sg13g2_decap_8
X_5690_ _2655_ _2649_ _2656_ VPWR VGND sg13g2_xor2_1
X_4710_ _1698_ _1705_ _1706_ _1711_ _1717_ VPWR VGND sg13g2_nor4_1
X_4641_ net691 _1644_ _1645_ _1647_ _1648_ VPWR VGND sg13g2_nor4_1
X_6492__315 VPWR VGND net315 sg13g2_tiehi
X_4572_ net690 _1575_ _1576_ _1578_ _1579_ VPWR VGND sg13g2_nor4_1
X_6311_ net238 VGND VPWR _0370_ videogen.another_shader.time_cnt\[26\] net742 sg13g2_dfrbpq_2
X_3523_ net862 videogen.test_lut_thingy.pixel_feeder_inst.row\[48\]\[2\] _0833_ _0592_
+ VPWR VGND sg13g2_mux2_1
X_3454_ _0782_ _0784_ net617 _0814_ VPWR VGND sg13g2_nand3_1
X_6242_ net369 VGND VPWR _0301_ serialize.bit_cnt\[1\] clknet_3_2__leaf_clk_regs sg13g2_dfrbpq_1
XFILLER_41_0 VPWR VGND sg13g2_fill_1
X_6173_ net769 net812 _0233_ VPWR VGND sg13g2_nor2_1
X_3385_ net661 net652 _0777_ VPWR VGND sg13g2_nor2_1
X_6648__421 VPWR VGND net421 sg13g2_tiehi
X_5124_ _2131_ net678 _2130_ VPWR VGND sg13g2_xnor2_1
X_5055_ _2058_ _2054_ _2061_ _2062_ VPWR VGND sg13g2_a21o_2
X_4006_ _0726_ _1043_ _1046_ VPWR VGND sg13g2_nor2_1
XFILLER_38_663 VPWR VGND sg13g2_decap_4
XFILLER_26_847 VPWR VGND sg13g2_fill_1
XFILLER_40_316 VPWR VGND sg13g2_fill_2
XFILLER_13_519 VPWR VGND sg13g2_decap_8
X_5957_ net781 net824 _0018_ VPWR VGND sg13g2_nor2_1
X_4908_ _1903_ _1914_ _1915_ VPWR VGND sg13g2_and2_1
Xclkbuf_3_4__f_clk_regs clknet_0_clk_regs clknet_3_4__leaf_clk_regs VPWR VGND sg13g2_buf_8
X_5888_ VGND VPWR net668 _2717_ _0662_ _2824_ sg13g2_a21oi_1
X_4839_ _1846_ _1844_ _1845_ VPWR VGND sg13g2_nand2_1
X_6509_ net265 VGND VPWR _0564_ videogen.test_lut_thingy.pixel_feeder_inst.row\[28\]\[2\]
+ _0151_ sg13g2_dfrbpq_1
XFILLER_20_11 VPWR VGND sg13g2_fill_1
XFILLER_20_66 VPWR VGND sg13g2_fill_1
XFILLER_1_935 VPWR VGND sg13g2_decap_8
XFILLER_0_434 VPWR VGND sg13g2_decap_8
XFILLER_49_939 VPWR VGND sg13g2_decap_8
Xhold20 serialize.shift_reg_b\[6\] VPWR VGND net508 sg13g2_dlygate4sd3_1
Xhold31 serialize.shift_reg_b\[8\] VPWR VGND net519 sg13g2_dlygate4sd3_1
XFILLER_48_449 VPWR VGND sg13g2_decap_8
XFILLER_21_1023 VPWR VGND sg13g2_decap_4
XFILLER_44_611 VPWR VGND sg13g2_fill_2
XFILLER_17_858 VPWR VGND sg13g2_fill_1
XFILLER_17_869 VPWR VGND sg13g2_decap_8
XFILLER_25_880 VPWR VGND sg13g2_fill_2
XFILLER_43_198 VPWR VGND sg13g2_decap_8
X_6591__203 VPWR VGND net203 sg13g2_tiehi
XFILLER_6_79 VPWR VGND sg13g2_fill_2
XFILLER_6_1006 VPWR VGND sg13g2_decap_8
XFILLER_48_972 VPWR VGND sg13g2_decap_8
XFILLER_35_600 VPWR VGND sg13g2_fill_1
XFILLER_35_622 VPWR VGND sg13g2_fill_2
X_6526__193 VPWR VGND net193 sg13g2_tiehi
XFILLER_34_132 VPWR VGND sg13g2_fill_1
X_5811_ _2717_ _2733_ _2770_ VPWR VGND sg13g2_nor2_1
XFILLER_22_338 VPWR VGND sg13g2_decap_4
XFILLER_22_349 VPWR VGND sg13g2_fill_1
X_5742_ _2690_ _2696_ _2686_ _2702_ VPWR VGND sg13g2_nand3_1
X_6637__111 VPWR VGND net111 sg13g2_tiehi
X_5673_ VGND VPWR _0741_ _2595_ _2640_ _2632_ sg13g2_a21oi_1
X_4624_ _1630_ VPWR _1631_ VGND videogen.test_lut_thingy.pixel_feeder_inst.row\[53\]\[0\]
+ net624 sg13g2_o21ai_1
X_4555_ videogen.test_lut_thingy.pixel_feeder_inst.h_pix\[5\] VPWR _1562_ VGND _1556_
+ _1561_ sg13g2_o21ai_1
X_3506_ _0778_ _0821_ _0830_ VPWR VGND sg13g2_nor2_2
X_4486_ net691 _1489_ _1490_ _1492_ _1493_ VPWR VGND sg13g2_nor4_1
X_6225_ net398 VGND VPWR _0284_ serialize.shift_reg_g\[8\] clknet_3_6__leaf_clk_regs
+ sg13g2_dfrbpq_1
X_3437_ net851 videogen.test_lut_thingy.pixel_feeder_inst.row\[49\]\[3\] _0808_ _0653_
+ VPWR VGND sg13g2_mux2_1
X_6156_ net756 net798 _0216_ VPWR VGND sg13g2_nor2_1
X_3368_ net674 net675 _0759_ _0760_ VPWR VGND sg13g2_nor3_1
X_5107_ _2105_ _2110_ _2103_ _2114_ VPWR VGND sg13g2_nand3_1
X_6087_ net756 net798 _0147_ VPWR VGND sg13g2_nor2_1
X_5038_ _2030_ _2039_ _2028_ _2045_ VPWR VGND sg13g2_nand3_1
XFILLER_25_187 VPWR VGND sg13g2_fill_1
XFILLER_9_309 VPWR VGND sg13g2_fill_1
Xoutput8 net8 uio_out[2] VPWR VGND sg13g2_buf_1
Xoutput10 net10 uio_out[4] VPWR VGND sg13g2_buf_1
XFILLER_0_231 VPWR VGND sg13g2_decap_8
XFILLER_49_758 VPWR VGND sg13g2_fill_1
XFILLER_49_736 VPWR VGND sg13g2_decap_8
XFILLER_0_286 VPWR VGND sg13g2_decap_4
XFILLER_45_953 VPWR VGND sg13g2_decap_8
XFILLER_16_154 VPWR VGND sg13g2_decap_8
XFILLER_9_898 VPWR VGND sg13g2_fill_1
X_4340_ videogen.test_lut_thingy.pixel_feeder_inst.row\[14\]\[2\] net637 _1347_ VPWR
+ VGND sg13g2_nor2_1
X_4271_ _1278_ _1211_ _1277_ VPWR VGND sg13g2_nand2_1
X_6010_ net792 net835 _0071_ VPWR VGND sg13g2_nor2_1
XFILLER_36_931 VPWR VGND sg13g2_decap_8
XFILLER_35_474 VPWR VGND sg13g2_decap_8
XFILLER_23_625 VPWR VGND sg13g2_decap_8
X_3986_ VGND VPWR videogen.another_shader.time_cnt\[18\] _1028_ _1031_ videogen.another_shader.time_cnt\[19\]
+ sg13g2_a21oi_1
XFILLER_11_809 VPWR VGND sg13g2_fill_2
XFILLER_22_157 VPWR VGND sg13g2_fill_1
X_5725_ VGND VPWR net669 _2611_ _0553_ net845 sg13g2_a21oi_1
X_5656_ _2624_ _2623_ VPWR VGND sg13g2_inv_2
XFILLER_11_1022 VPWR VGND sg13g2_decap_8
X_4607_ net685 _1602_ _1613_ _1614_ VPWR VGND sg13g2_nor3_1
X_5587_ green\[0\] green\[1\] _2564_ VPWR VGND sg13g2_xor2_1
X_4538_ net706 videogen.test_lut_thingy.pixel_feeder_inst.row\[44\]\[3\] videogen.test_lut_thingy.pixel_feeder_inst.row\[45\]\[3\]
+ videogen.test_lut_thingy.pixel_feeder_inst.row\[46\]\[3\] videogen.test_lut_thingy.pixel_feeder_inst.row\[47\]\[3\]
+ net703 _1545_ VPWR VGND sg13g2_mux4_1
Xfanout800 net802 net800 VPWR VGND sg13g2_buf_8
X_4469_ _1475_ VPWR _1476_ VGND videogen.test_lut_thingy.pixel_feeder_inst.row\[53\]\[1\]
+ net624 sg13g2_o21ai_1
Xfanout811 net813 net811 VPWR VGND sg13g2_buf_1
Xfanout822 net825 net822 VPWR VGND sg13g2_buf_8
X_6208_ net420 VGND VPWR _0267_ videogen.test_lut_thingy.pixel_feeder_inst.row\[34\]\[3\]
+ _0008_ sg13g2_dfrbpq_1
Xfanout833 net840 net833 VPWR VGND sg13g2_buf_8
Xfanout855 net858 net855 VPWR VGND sg13g2_buf_1
Xfanout844 net847 net844 VPWR VGND sg13g2_buf_8
Xfanout866 net869 net866 VPWR VGND sg13g2_buf_2
Xfanout877 net880 net877 VPWR VGND sg13g2_buf_8
Xfanout899 net900 net899 VPWR VGND sg13g2_buf_8
Xfanout888 net890 net888 VPWR VGND sg13g2_buf_8
X_6139_ net793 net831 _0199_ VPWR VGND sg13g2_nor2_1
XFILLER_39_791 VPWR VGND sg13g2_decap_8
XFILLER_42_945 VPWR VGND sg13g2_decap_8
XFILLER_41_455 VPWR VGND sg13g2_fill_1
XFILLER_42_64 VPWR VGND sg13g2_decap_8
XFILLER_10_875 VPWR VGND sg13g2_fill_2
XFILLER_5_334 VPWR VGND sg13g2_fill_1
XFILLER_1_573 VPWR VGND sg13g2_decap_8
XFILLER_20_606 VPWR VGND sg13g2_fill_2
X_3840_ _0939_ _0940_ _0276_ VPWR VGND sg13g2_nor2b_1
XFILLER_33_989 VPWR VGND sg13g2_decap_8
XFILLER_34_1000 VPWR VGND sg13g2_decap_8
X_3771_ VGND VPWR net619 _0777_ net9 _0743_ sg13g2_a21oi_1
X_5510_ _2496_ _2457_ _2491_ VPWR VGND sg13g2_nand2_1
X_6490_ net323 VGND VPWR _0545_ videogen.test_lut_thingy.pixel_feeder_inst.row\[54\]\[0\]
+ _0141_ sg13g2_dfrbpq_1
X_6274__312 VPWR VGND net312 sg13g2_tiehi
X_5441_ VGND VPWR _2431_ _2434_ _2433_ _2271_ sg13g2_a21oi_2
X_5372_ _2365_ _2351_ _2363_ VPWR VGND sg13g2_xnor2_1
X_4323_ VGND VPWR _1330_ net640 videogen.test_lut_thingy.pixel_feeder_inst.row\[22\]\[2\]
+ sg13g2_or2_1
X_4254_ _1190_ _1259_ _1261_ VPWR VGND sg13g2_nor2_1
XFILLER_41_1015 VPWR VGND sg13g2_decap_8
XFILLER_28_706 VPWR VGND sg13g2_fill_2
X_4185_ _1179_ VPWR _1192_ VGND _1183_ _1189_ sg13g2_o21ai_1
XFILLER_23_433 VPWR VGND sg13g2_decap_4
X_3969_ _0729_ _1011_ _1015_ _1019_ VPWR VGND sg13g2_nor3_1
X_5708_ _2673_ _2669_ _2672_ VPWR VGND sg13g2_xnor2_1
XFILLER_6_109 VPWR VGND sg13g2_decap_8
X_5639_ VPWR VGND _2614_ net643 _2613_ _2582_ _0437_ net610 sg13g2_a221oi_1
XFILLER_2_348 VPWR VGND sg13g2_decap_4
Xfanout641 _1319_ net641 VPWR VGND sg13g2_buf_8
Xfanout630 net631 net630 VPWR VGND sg13g2_buf_2
Xfanout685 videogen.test_lut_thingy.pixel_feeder_inst.h_pix\[4\] net685 VPWR VGND
+ sg13g2_buf_8
Xfanout674 videogen.another_shader.video_y\[3\] net674 VPWR VGND sg13g2_buf_8
Xfanout652 net653 net652 VPWR VGND sg13g2_buf_8
Xfanout663 _0773_ net663 VPWR VGND sg13g2_buf_8
Xfanout696 net697 net696 VPWR VGND sg13g2_buf_8
XFILLER_18_216 VPWR VGND sg13g2_fill_2
X_6327__202 VPWR VGND net202 sg13g2_tiehi
XFILLER_18_227 VPWR VGND sg13g2_fill_1
XFILLER_14_455 VPWR VGND sg13g2_fill_2
XFILLER_18_1028 VPWR VGND sg13g2_fill_1
XFILLER_26_293 VPWR VGND sg13g2_decap_4
XFILLER_10_694 VPWR VGND sg13g2_fill_1
X_6488__331 VPWR VGND net331 sg13g2_tiehi
X_6234__384 VPWR VGND net384 sg13g2_tiehi
XFILLER_49_396 VPWR VGND sg13g2_decap_8
X_5990_ net778 net822 _0051_ VPWR VGND sg13g2_nor2_1
X_4941_ _1933_ VPWR _1948_ VGND _1937_ _1947_ sg13g2_o21ai_1
XFILLER_33_731 VPWR VGND sg13g2_fill_1
X_4872_ VPWR _1879_ _1878_ VGND sg13g2_inv_1
X_6611_ net38 VGND VPWR _0666_ videogen.test_lut_thingy.pixel_feeder_inst.row\[24\]\[1\]
+ _0242_ sg13g2_dfrbpq_1
X_3823_ videogen.another_shader.video_x\[0\] net615 _0268_ VPWR VGND sg13g2_nor2_1
XFILLER_32_296 VPWR VGND sg13g2_fill_1
X_3754_ net715 _0889_ _0890_ VPWR VGND sg13g2_and2_1
X_6542_ net80 VGND VPWR _0597_ videogen.test_lut_thingy.pixel_feeder_inst.row\[47\]\[3\]
+ _0184_ sg13g2_dfrbpq_1
X_3685_ videogen.test_lut_thingy.pixel_feeder_inst.row\[15\]\[3\] net854 _0868_ _0447_
+ VPWR VGND sg13g2_mux2_1
X_6473_ net403 VGND VPWR _0528_ videogen.test_lut_thingy.pixel_feeder_inst.row\[57\]\[3\]
+ _0124_ sg13g2_dfrbpq_1
X_5424_ _2417_ _2413_ _2416_ VPWR VGND sg13g2_xnor2_1
X_5355_ _2347_ _1197_ _2348_ VPWR VGND sg13g2_nor2b_1
X_5286_ _1198_ _2278_ _2279_ VPWR VGND sg13g2_and2_1
X_4306_ net846 net2 _0750_ _1313_ VPWR VGND sg13g2_nor3_2
X_4237_ _1243_ _1223_ _1244_ VPWR VGND sg13g2_xor2_1
X_6385__126 VPWR VGND net126 sg13g2_tiehi
X_4168_ _1170_ VPWR _1175_ VGND _1171_ _1174_ sg13g2_o21ai_1
X_4099_ VGND VPWR videogen.test_lut_thingy.gol_counter_reg\[0\] videogen.test_lut_thingy.gol_counter_reg\[1\]
+ _0397_ _1109_ sg13g2_a21oi_1
XFILLER_24_753 VPWR VGND sg13g2_fill_2
XFILLER_23_11 VPWR VGND sg13g2_decap_8
XFILLER_23_263 VPWR VGND sg13g2_fill_2
XFILLER_8_908 VPWR VGND sg13g2_fill_1
XFILLER_7_418 VPWR VGND sg13g2_fill_2
XFILLER_3_668 VPWR VGND sg13g2_decap_8
XFILLER_47_867 VPWR VGND sg13g2_decap_8
XFILLER_46_355 VPWR VGND sg13g2_decap_4
XFILLER_7_974 VPWR VGND sg13g2_decap_8
X_3470_ videogen.test_lut_thingy.pixel_feeder_inst.row\[38\]\[1\] net877 _0819_ _0631_
+ VPWR VGND sg13g2_mux2_1
XFILLER_9_1004 VPWR VGND sg13g2_decap_8
X_5140_ VGND VPWR _2147_ videogen.another_shader.time_cnt\[0\] net677 sg13g2_or2_1
X_5071_ _2050_ _2063_ _2077_ _2078_ VPWR VGND sg13g2_or3_1
X_4022_ videogen.another_shader.time_cnt\[28\] _1054_ videogen.another_shader.time_cnt\[29\]
+ _1057_ VPWR VGND sg13g2_nand3_1
XFILLER_37_366 VPWR VGND sg13g2_fill_1
X_5973_ net783 net826 _0034_ VPWR VGND sg13g2_nor2_1
XFILLER_25_539 VPWR VGND sg13g2_fill_1
X_4924_ _1904_ VPWR _1931_ VGND _1909_ _1929_ sg13g2_o21ai_1
Xclkbuf_3_3__f_clk_regs clknet_0_clk_regs clknet_3_3__leaf_clk_regs VPWR VGND sg13g2_buf_8
XFILLER_33_572 VPWR VGND sg13g2_fill_2
X_4855_ VGND VPWR _1843_ _1847_ _1862_ _1861_ sg13g2_a21oi_1
X_4786_ _1786_ _1787_ _1762_ _1793_ VPWR VGND _1789_ sg13g2_nand4_1
X_3806_ serialize.shift_reg_g\[1\] serialize.shift_reg_g\[0\] clknet_1_1__leaf_clk
+ net5 VPWR VGND sg13g2_mux2_1
X_3737_ videogen.test_lut_thingy.pixel_feeder_inst.row\[20\]\[1\] net879 _0878_ _0281_
+ VPWR VGND sg13g2_mux2_1
X_6525_ net197 VGND VPWR _0580_ videogen.test_lut_thingy.pixel_feeder_inst.row\[51\]\[2\]
+ _0167_ sg13g2_dfrbpq_1
X_3668_ videogen.test_lut_thingy.pixel_feeder_inst.row\[36\]\[0\] net886 _0864_ _0469_
+ VPWR VGND sg13g2_mux2_1
X_6456_ net458 VGND VPWR _0511_ videogen.test_lut_thingy.pixel_feeder_inst.row\[60\]\[2\]
+ _0107_ sg13g2_dfrbpq_1
Xheichips25_bagel_26 VPWR VGND uio_oe[5] sg13g2_tielo
XFILLER_47_1021 VPWR VGND sg13g2_decap_8
X_6387_ net122 VGND VPWR _0446_ videogen.test_lut_thingy.pixel_feeder_inst.row\[15\]\[2\]
+ _0051_ sg13g2_dfrbpq_1
X_5407_ _2400_ _1238_ _2274_ VPWR VGND sg13g2_xnor2_1
X_3599_ net872 videogen.test_lut_thingy.pixel_feeder_inst.row\[58\]\[1\] _0848_ _0522_
+ VPWR VGND sg13g2_mux2_1
XFILLER_0_616 VPWR VGND sg13g2_decap_8
X_5338_ _2318_ VPWR _2331_ VGND _2319_ _2326_ sg13g2_o21ai_1
XFILLER_47_108 VPWR VGND sg13g2_fill_1
X_5269_ _2266_ VPWR _0414_ VGND _1566_ _2267_ sg13g2_o21ai_1
XFILLER_29_812 VPWR VGND sg13g2_decap_8
XFILLER_29_856 VPWR VGND sg13g2_fill_1
XFILLER_16_539 VPWR VGND sg13g2_decap_8
XFILLER_24_583 VPWR VGND sg13g2_fill_2
X_6300__260 VPWR VGND net260 sg13g2_tiehi
XFILLER_4_933 VPWR VGND sg13g2_decap_8
XFILLER_1_0 VPWR VGND sg13g2_decap_8
XFILLER_35_815 VPWR VGND sg13g2_decap_4
XFILLER_34_325 VPWR VGND sg13g2_fill_2
XFILLER_46_196 VPWR VGND sg13g2_decap_4
XFILLER_34_358 VPWR VGND sg13g2_fill_2
XFILLER_43_870 VPWR VGND sg13g2_decap_8
XFILLER_30_531 VPWR VGND sg13g2_fill_1
X_4640_ _1646_ VPWR _1647_ VGND videogen.test_lut_thingy.pixel_feeder_inst.row\[39\]\[0\]
+ net658 sg13g2_o21ai_1
XFILLER_30_553 VPWR VGND sg13g2_decap_4
X_4571_ _1577_ VPWR _1578_ VGND videogen.test_lut_thingy.pixel_feeder_inst.row\[16\]\[0\]
+ net646 sg13g2_o21ai_1
X_6310_ net240 VGND VPWR _0369_ videogen.another_shader.time_cnt\[25\] net729 sg13g2_dfrbpq_2
XFILLER_7_760 VPWR VGND sg13g2_fill_1
XFILLER_7_782 VPWR VGND sg13g2_fill_2
X_3522_ net851 videogen.test_lut_thingy.pixel_feeder_inst.row\[48\]\[3\] _0833_ _0593_
+ VPWR VGND sg13g2_mux2_1
X_3453_ VGND VPWR _0714_ _0811_ _0642_ _0813_ sg13g2_a21oi_1
X_6241_ net370 VGND VPWR _0300_ serialize.bit_cnt\[0\] clknet_3_5__leaf_clk_regs sg13g2_dfrbpq_1
X_6172_ net765 net807 _0232_ VPWR VGND sg13g2_nor2_1
X_5123_ _2130_ videogen.another_shader.time_cnt\[0\] videogen.another_shader.video_x\[0\]
+ VPWR VGND sg13g2_xnor2_1
X_3384_ VGND VPWR _0776_ net707 net702 sg13g2_or2_1
XFILLER_34_0 VPWR VGND sg13g2_decap_4
X_5054_ VGND VPWR _2054_ _2059_ _2061_ _2058_ sg13g2_a21oi_1
XFILLER_29_119 VPWR VGND sg13g2_fill_2
X_4005_ _0726_ _1043_ _1045_ VPWR VGND sg13g2_and2_1
XFILLER_26_804 VPWR VGND sg13g2_decap_8
XFILLER_1_91 VPWR VGND sg13g2_decap_8
X_5956_ net781 net824 _0017_ VPWR VGND sg13g2_nor2_1
X_6282__296 VPWR VGND net296 sg13g2_tiehi
X_4907_ _1914_ _1742_ _1913_ VPWR VGND sg13g2_nand2_2
X_5887_ VGND VPWR _2833_ _2835_ _0661_ _2817_ sg13g2_a21oi_1
XFILLER_34_892 VPWR VGND sg13g2_decap_8
X_4838_ _1832_ _1839_ _1841_ _1845_ VPWR VGND sg13g2_or3_1
XFILLER_21_542 VPWR VGND sg13g2_fill_2
X_4769_ VPWR VGND _1773_ _1775_ _1770_ _1765_ _1776_ _1766_ sg13g2_a221oi_1
X_6508_ net269 VGND VPWR _0563_ videogen.test_lut_thingy.pixel_feeder_inst.row\[28\]\[1\]
+ _0150_ sg13g2_dfrbpq_1
XFILLER_20_23 VPWR VGND sg13g2_decap_4
X_6439_ net35 VGND VPWR _0494_ videogen.test_lut_thingy.pixel_feeder_inst.row\[10\]\[1\]
+ _0090_ sg13g2_dfrbpq_1
XFILLER_0_413 VPWR VGND sg13g2_decap_8
XFILLER_1_914 VPWR VGND sg13g2_decap_8
XFILLER_20_78 VPWR VGND sg13g2_fill_2
XFILLER_49_918 VPWR VGND sg13g2_decap_8
Xhold21 serialize.shift_reg_g\[3\] VPWR VGND net509 sg13g2_dlygate4sd3_1
Xhold10 serialize.shift_reg_c\[6\] VPWR VGND net498 sg13g2_dlygate4sd3_1
Xhold32 serialize.shift_reg_b\[9\] VPWR VGND net520 sg13g2_dlygate4sd3_1
XFILLER_48_428 VPWR VGND sg13g2_decap_8
XFILLER_29_54 VPWR VGND sg13g2_fill_1
XFILLER_45_31 VPWR VGND sg13g2_decap_8
XFILLER_17_848 VPWR VGND sg13g2_fill_2
XFILLER_44_645 VPWR VGND sg13g2_decap_8
XFILLER_40_895 VPWR VGND sg13g2_decap_8
XFILLER_8_524 VPWR VGND sg13g2_fill_1
X_6335__186 VPWR VGND net186 sg13g2_tiehi
XFILLER_0_991 VPWR VGND sg13g2_decap_8
XFILLER_48_951 VPWR VGND sg13g2_decap_8
XFILLER_19_185 VPWR VGND sg13g2_fill_2
X_5810_ _2757_ VPWR _2769_ VGND _2767_ _2768_ sg13g2_o21ai_1
X_5741_ VGND VPWR blue\[7\] _2700_ _2701_ _2699_ sg13g2_a21oi_1
X_5672_ _2579_ net612 _2639_ VPWR VGND sg13g2_and2_1
XFILLER_30_350 VPWR VGND sg13g2_fill_1
X_4623_ _1630_ net663 videogen.test_lut_thingy.pixel_feeder_inst.row\[55\]\[0\] VPWR
+ VGND sg13g2_nand2b_1
X_4554_ net683 VPWR _1561_ VGND net689 _1560_ sg13g2_o21ai_1
X_3505_ videogen.test_lut_thingy.pixel_feeder_inst.row\[44\]\[0\] net886 _0829_ _0606_
+ VPWR VGND sg13g2_mux2_1
X_6224_ net400 VGND VPWR _0283_ videogen.test_lut_thingy.pixel_feeder_inst.row\[20\]\[3\]
+ _0012_ sg13g2_dfrbpq_1
X_4485_ _1491_ VPWR _1492_ VGND videogen.test_lut_thingy.pixel_feeder_inst.row\[37\]\[1\]
+ net627 sg13g2_o21ai_1
X_3436_ VGND VPWR _0808_ _0807_ _0805_ sg13g2_or2_1
XFILLER_44_1024 VPWR VGND sg13g2_decap_4
X_6155_ net757 net799 _0215_ VPWR VGND sg13g2_nor2_1
X_3367_ VGND VPWR _0759_ net677 net676 sg13g2_or2_1
X_6086_ net756 net798 _0146_ VPWR VGND sg13g2_nor2_1
X_5106_ _2111_ _2105_ _2103_ _2113_ VPWR VGND sg13g2_a21o_1
X_5037_ _2028_ _2042_ _2044_ VPWR VGND _1713_ sg13g2_nand3b_1
XFILLER_39_984 VPWR VGND sg13g2_decap_8
XFILLER_38_483 VPWR VGND sg13g2_decap_4
XFILLER_14_829 VPWR VGND sg13g2_decap_4
XFILLER_41_637 VPWR VGND sg13g2_decap_8
XFILLER_40_158 VPWR VGND sg13g2_fill_1
X_5939_ VPWR _0707_ _2861_ VGND sg13g2_inv_1
XFILLER_22_851 VPWR VGND sg13g2_fill_2
XFILLER_40_169 VPWR VGND sg13g2_fill_2
X_6655__267 VPWR VGND net267 sg13g2_tiehi
Xoutput9 net9 uio_out[3] VPWR VGND sg13g2_buf_1
Xoutput11 net11 uio_out[6] VPWR VGND sg13g2_buf_1
XFILLER_45_932 VPWR VGND sg13g2_decap_8
XFILLER_17_689 VPWR VGND sg13g2_decap_8
XFILLER_8_310 VPWR VGND sg13g2_decap_8
XFILLER_8_354 VPWR VGND sg13g2_fill_1
X_6553__36 VPWR VGND net36 sg13g2_tiehi
XFILLER_8_376 VPWR VGND sg13g2_fill_1
XFILLER_8_398 VPWR VGND sg13g2_decap_4
X_4270_ _1277_ _1274_ _1276_ VPWR VGND sg13g2_nand2_1
XFILLER_39_258 VPWR VGND sg13g2_fill_1
XFILLER_36_987 VPWR VGND sg13g2_decap_8
XFILLER_23_648 VPWR VGND sg13g2_fill_1
X_3985_ net843 _1030_ _0362_ VPWR VGND sg13g2_nor2_1
X_5724_ VGND VPWR net667 _2580_ _0552_ net844 sg13g2_a21oi_1
X_5655_ _2623_ _0741_ _2595_ VPWR VGND sg13g2_xnor2_1
XFILLER_11_1001 VPWR VGND sg13g2_decap_8
X_4606_ net696 _1607_ _1612_ _1613_ VPWR VGND sg13g2_nor3_1
X_5586_ VGND VPWR _2446_ _2497_ _0431_ _2563_ sg13g2_a21oi_1
X_4537_ net682 _1533_ _1543_ _1544_ VPWR VGND sg13g2_nor3_1
X_6216__411 VPWR VGND net411 sg13g2_tiehi
X_4468_ _1475_ net663 videogen.test_lut_thingy.pixel_feeder_inst.row\[55\]\[1\] VPWR
+ VGND sg13g2_nand2b_1
Xfanout812 net813 net812 VPWR VGND sg13g2_buf_8
X_3419_ _0790_ net616 _0799_ VPWR VGND sg13g2_nor2_2
Xfanout823 net825 net823 VPWR VGND sg13g2_buf_8
Xfanout801 net802 net801 VPWR VGND sg13g2_buf_1
Xfanout834 net835 net834 VPWR VGND sg13g2_buf_8
X_6207_ net422 VGND VPWR _0266_ videogen.test_lut_thingy.pixel_feeder_inst.row\[34\]\[2\]
+ _0007_ sg13g2_dfrbpq_1
Xfanout867 net868 net867 VPWR VGND sg13g2_buf_8
Xfanout845 net846 net845 VPWR VGND sg13g2_buf_1
Xfanout856 net858 net856 VPWR VGND sg13g2_buf_8
X_6138_ net792 net830 _0198_ VPWR VGND sg13g2_nor2_1
X_4399_ _1405_ VPWR _1406_ VGND videogen.test_lut_thingy.pixel_feeder_inst.row\[34\]\[2\]
+ net639 sg13g2_o21ai_1
X_6251__357 VPWR VGND net357 sg13g2_tiehi
Xfanout878 net879 net878 VPWR VGND sg13g2_buf_8
Xfanout889 net890 net889 VPWR VGND sg13g2_buf_8
XFILLER_46_718 VPWR VGND sg13g2_fill_2
X_6069_ net772 net815 _0130_ VPWR VGND sg13g2_nor2_1
XFILLER_42_924 VPWR VGND sg13g2_decap_8
XFILLER_41_423 VPWR VGND sg13g2_fill_1
XFILLER_26_77 VPWR VGND sg13g2_decap_4
XFILLER_14_659 VPWR VGND sg13g2_decap_4
X_6395__106 VPWR VGND net106 sg13g2_tiehi
XFILLER_1_552 VPWR VGND sg13g2_decap_8
XFILLER_49_534 VPWR VGND sg13g2_decap_8
XFILLER_44_283 VPWR VGND sg13g2_fill_2
X_3770_ VGND VPWR net704 net619 net8 _0743_ sg13g2_a21oi_1
XFILLER_32_478 VPWR VGND sg13g2_fill_1
XFILLER_8_151 VPWR VGND sg13g2_decap_8
X_5440_ net897 _2432_ _2433_ VPWR VGND sg13g2_and2_1
X_5371_ _2351_ _2363_ _2364_ VPWR VGND sg13g2_nor2_1
X_4322_ videogen.test_lut_thingy.pixel_feeder_inst.row\[21\]\[2\] net628 _1329_ VPWR
+ VGND sg13g2_nor2_1
X_4253_ _1260_ _1180_ _1259_ VPWR VGND sg13g2_nand2_2
X_4184_ _1180_ _1183_ _1189_ _1191_ VPWR VGND sg13g2_nor3_1
XFILLER_27_206 VPWR VGND sg13g2_fill_1
XFILLER_27_239 VPWR VGND sg13g2_fill_1
XFILLER_42_209 VPWR VGND sg13g2_fill_1
XFILLER_24_957 VPWR VGND sg13g2_fill_1
X_3968_ _1016_ _1017_ _0357_ VPWR VGND sg13g2_nor2b_1
X_5707_ _2672_ tmds_green.dc_balancing_reg\[4\] _2671_ VPWR VGND sg13g2_xnor2_1
X_3899_ _0897_ _0973_ _0325_ VPWR VGND sg13g2_nor2_1
XFILLER_12_79 VPWR VGND sg13g2_fill_1
X_5638_ VGND VPWR _2564_ net613 _2614_ net611 sg13g2_a21oi_1
X_5569_ _2530_ VPWR _2552_ VGND _2524_ _2532_ sg13g2_o21ai_1
Xfanout642 net643 net642 VPWR VGND sg13g2_buf_8
Xfanout620 _0769_ net620 VPWR VGND sg13g2_buf_8
Xfanout631 _1315_ net631 VPWR VGND sg13g2_buf_8
Xfanout653 _0775_ net653 VPWR VGND sg13g2_buf_8
Xfanout675 videogen.another_shader.video_y\[2\] net675 VPWR VGND sg13g2_buf_8
Xfanout664 _0738_ net664 VPWR VGND sg13g2_buf_8
Xfanout697 videogen.test_lut_thingy.pixel_feeder_inst.h_pix\[2\] net697 VPWR VGND
+ sg13g2_buf_8
Xfanout686 net695 net686 VPWR VGND sg13g2_buf_8
XFILLER_46_548 VPWR VGND sg13g2_decap_8
XFILLER_2_1021 VPWR VGND sg13g2_decap_8
XFILLER_37_43 VPWR VGND sg13g2_fill_1
XFILLER_33_209 VPWR VGND sg13g2_fill_2
XFILLER_42_721 VPWR VGND sg13g2_fill_2
XFILLER_42_765 VPWR VGND sg13g2_fill_1
XFILLER_15_957 VPWR VGND sg13g2_fill_2
X_6592__195 VPWR VGND net195 sg13g2_tiehi
XFILLER_5_198 VPWR VGND sg13g2_fill_1
XFILLER_2_850 VPWR VGND sg13g2_decap_8
XFILLER_49_342 VPWR VGND sg13g2_fill_1
XFILLER_1_393 VPWR VGND sg13g2_decap_8
XFILLER_49_375 VPWR VGND sg13g2_decap_8
X_6310__240 VPWR VGND net240 sg13g2_tiehi
XFILLER_37_526 VPWR VGND sg13g2_fill_2
XFILLER_37_559 VPWR VGND sg13g2_decap_8
XFILLER_18_751 VPWR VGND sg13g2_decap_8
X_4940_ _1947_ _1934_ _1936_ _1931_ _1930_ VPWR VGND sg13g2_a22oi_1
Xclkbuf_3_2__f_clk_regs clknet_0_clk_regs clknet_3_2__leaf_clk_regs VPWR VGND sg13g2_buf_8
X_4871_ VGND VPWR _1878_ _1877_ _1859_ sg13g2_or2_1
X_6610_ net46 VGND VPWR _0665_ videogen.test_lut_thingy.pixel_feeder_inst.row\[24\]\[0\]
+ _0241_ sg13g2_dfrbpq_1
X_3822_ VPWR _0931_ net615 VGND sg13g2_inv_1
XFILLER_32_253 VPWR VGND sg13g2_fill_2
XFILLER_33_787 VPWR VGND sg13g2_fill_2
XFILLER_14_990 VPWR VGND sg13g2_decap_8
X_6541_ net84 VGND VPWR _0596_ videogen.test_lut_thingy.pixel_feeder_inst.row\[47\]\[2\]
+ _0183_ sg13g2_dfrbpq_1
X_3753_ net716 _0888_ _0889_ VPWR VGND sg13g2_and2_1
X_3684_ net616 _0854_ _0868_ VPWR VGND sg13g2_nor2_2
X_6472_ net419 VGND VPWR _0527_ videogen.test_lut_thingy.pixel_feeder_inst.row\[57\]\[2\]
+ _0123_ sg13g2_dfrbpq_1
X_5423_ _2398_ _2391_ _2416_ VPWR VGND sg13g2_xor2_1
X_5354_ _2347_ _1209_ _2346_ VPWR VGND sg13g2_nand2_1
XFILLER_0_809 VPWR VGND sg13g2_decap_8
X_4305_ _1256_ _1307_ _1309_ _1311_ _1312_ VPWR VGND sg13g2_nor4_1
X_6213__414 VPWR VGND net414 sg13g2_tiehi
X_5285_ _1143_ _2277_ _2278_ VPWR VGND sg13g2_nor2b_2
X_4236_ VGND VPWR _1227_ _1236_ _1243_ _1226_ sg13g2_a21oi_1
X_4167_ _1173_ VPWR _1174_ VGND net670 videogen.fancy_shader.shader_counter_reg\[7\]
+ sg13g2_o21ai_1
X_4098_ net899 VPWR _1109_ VGND videogen.test_lut_thingy.gol_counter_reg\[0\] videogen.test_lut_thingy.gol_counter_reg\[1\]
+ sg13g2_o21ai_1
XFILLER_23_220 VPWR VGND sg13g2_decap_4
XFILLER_24_732 VPWR VGND sg13g2_decap_8
XFILLER_24_776 VPWR VGND sg13g2_decap_8
X_6220__407 VPWR VGND net407 sg13g2_tiehi
XFILLER_23_275 VPWR VGND sg13g2_fill_2
XFILLER_3_647 VPWR VGND sg13g2_decap_8
XFILLER_3_4 VPWR VGND sg13g2_decap_4
X_6292__276 VPWR VGND net276 sg13g2_tiehi
XFILLER_48_42 VPWR VGND sg13g2_decap_4
XFILLER_47_846 VPWR VGND sg13g2_decap_8
XFILLER_0_49 VPWR VGND sg13g2_decap_8
X_6641__483 VPWR VGND net483 sg13g2_tiehi
XFILLER_42_562 VPWR VGND sg13g2_decap_4
XFILLER_7_953 VPWR VGND sg13g2_decap_8
XFILLER_6_430 VPWR VGND sg13g2_fill_1
XFILLER_10_492 VPWR VGND sg13g2_decap_8
X_5070_ VPWR VGND _2070_ _2064_ _2062_ _1701_ _2077_ _1702_ sg13g2_a221oi_1
XFILLER_2_691 VPWR VGND sg13g2_decap_8
X_4021_ _0372_ net899 _1055_ _1056_ VPWR VGND sg13g2_and3_1
XFILLER_49_172 VPWR VGND sg13g2_fill_1
XFILLER_38_857 VPWR VGND sg13g2_decap_8
X_6417__79 VPWR VGND net79 sg13g2_tiehi
X_5972_ net783 net826 _0033_ VPWR VGND sg13g2_nor2_1
X_4923_ _1903_ _1910_ _1930_ VPWR VGND _1929_ sg13g2_nand3b_1
XFILLER_46_890 VPWR VGND sg13g2_decap_8
X_6432__49 VPWR VGND net49 sg13g2_tiehi
X_4854_ _1847_ _1849_ _1861_ VPWR VGND sg13g2_nor2b_1
X_4785_ _1762_ _1786_ _1787_ _1789_ _1792_ VPWR VGND sg13g2_and4_1
X_3805_ serialize.shift_reg_b\[1\] serialize.shift_reg_b\[0\] clknet_1_0__leaf_clk
+ net3 VPWR VGND sg13g2_mux2_1
X_6524_ net201 VGND VPWR _0579_ videogen.test_lut_thingy.pixel_feeder_inst.row\[51\]\[1\]
+ _0166_ sg13g2_dfrbpq_1
X_3736_ videogen.test_lut_thingy.pixel_feeder_inst.row\[20\]\[2\] net868 _0878_ _0282_
+ VPWR VGND sg13g2_mux2_1
X_3667_ videogen.test_lut_thingy.pixel_feeder_inst.row\[36\]\[1\] net876 _0864_ _0470_
+ VPWR VGND sg13g2_mux2_1
X_6455_ net460 VGND VPWR _0510_ videogen.test_lut_thingy.pixel_feeder_inst.row\[60\]\[1\]
+ _0106_ sg13g2_dfrbpq_1
Xheichips25_bagel_27 VPWR VGND uio_oe[6] sg13g2_tielo
XFILLER_47_1000 VPWR VGND sg13g2_decap_8
X_5406_ _2399_ _2345_ _2397_ VPWR VGND sg13g2_xnor2_1
X_6386_ net124 VGND VPWR _0445_ videogen.test_lut_thingy.pixel_feeder_inst.row\[15\]\[1\]
+ _0050_ sg13g2_dfrbpq_1
X_3598_ net864 videogen.test_lut_thingy.pixel_feeder_inst.row\[58\]\[2\] _0848_ _0523_
+ VPWR VGND sg13g2_mux2_1
X_5337_ _2330_ _2246_ _2329_ VPWR VGND sg13g2_xnor2_1
X_5268_ _2267_ _1413_ _1565_ VPWR VGND sg13g2_xnor2_1
XFILLER_29_802 VPWR VGND sg13g2_fill_2
X_4219_ _1138_ _1225_ _1226_ VPWR VGND sg13g2_nor2_1
X_5199_ _2195_ _1183_ _2198_ VPWR VGND sg13g2_xor2_1
XFILLER_29_835 VPWR VGND sg13g2_fill_2
XFILLER_44_849 VPWR VGND sg13g2_decap_8
XFILLER_24_551 VPWR VGND sg13g2_fill_1
XFILLER_8_728 VPWR VGND sg13g2_decap_4
XFILLER_11_278 VPWR VGND sg13g2_fill_2
XFILLER_4_989 VPWR VGND sg13g2_decap_8
XFILLER_3_488 VPWR VGND sg13g2_fill_1
XFILLER_3_455 VPWR VGND sg13g2_decap_4
XFILLER_19_312 VPWR VGND sg13g2_fill_1
XFILLER_19_345 VPWR VGND sg13g2_fill_1
XFILLER_46_164 VPWR VGND sg13g2_decap_4
XFILLER_15_584 VPWR VGND sg13g2_fill_2
X_4570_ VGND VPWR _1577_ net634 videogen.test_lut_thingy.pixel_feeder_inst.row\[18\]\[0\]
+ sg13g2_or2_1
XFILLER_30_598 VPWR VGND sg13g2_fill_2
X_3521_ VGND VPWR _0833_ _0807_ _0801_ sg13g2_or2_1
X_6572__385 VPWR VGND net385 sg13g2_tiehi
X_6240_ net372 VGND VPWR _0299_ videogen.test_lut_thingy.pixel_feeder_inst.row\[17\]\[3\]
+ _0024_ sg13g2_dfrbpq_1
XFILLER_6_282 VPWR VGND sg13g2_fill_1
X_3452_ net886 _0811_ _0813_ VPWR VGND sg13g2_nor2_1
X_3383_ net701 net704 _0775_ VPWR VGND sg13g2_nor2_1
X_6171_ net780 net823 _0231_ VPWR VGND sg13g2_nor2_1
X_5122_ _2129_ _1676_ _2127_ VPWR VGND sg13g2_xnor2_1
XFILLER_27_0 VPWR VGND sg13g2_decap_4
X_5053_ _2058_ _2054_ _2059_ _2060_ VPWR VGND sg13g2_a21o_1
X_6210__417 VPWR VGND net417 sg13g2_tiehi
X_4004_ _1044_ _1043_ _0367_ VPWR VGND sg13g2_nor2b_1
XFILLER_1_70 VPWR VGND sg13g2_decap_8
XFILLER_25_337 VPWR VGND sg13g2_fill_1
X_5955_ net756 net798 _0016_ VPWR VGND sg13g2_nor2_1
X_4906_ _1737_ net680 videogen.another_shader.time_cnt\[17\] _1913_ VPWR VGND sg13g2_a21o_1
X_5886_ _2834_ VPWR _2835_ VGND _2723_ _2752_ sg13g2_o21ai_1
X_4837_ _1832_ VPWR _1844_ VGND _1839_ _1841_ sg13g2_o21ai_1
X_4768_ _1775_ videogen.another_shader.time_cnt\[31\] _1769_ VPWR VGND sg13g2_xnor2_1
X_6507_ net273 VGND VPWR _0562_ videogen.test_lut_thingy.pixel_feeder_inst.row\[28\]\[0\]
+ _0149_ sg13g2_dfrbpq_1
X_4699_ _1706_ net715 videogen.another_shader.time_cnt\[4\] net713 videogen.another_shader.time_cnt\[5\]
+ VPWR VGND sg13g2_a22oi_1
X_3719_ _0790_ _0805_ _0875_ VPWR VGND sg13g2_nor2_2
X_6438_ net37 VGND VPWR _0493_ videogen.test_lut_thingy.pixel_feeder_inst.row\[10\]\[0\]
+ _0089_ sg13g2_dfrbpq_1
X_6369_ net150 VGND VPWR _0428_ red_tmds_par\[1\] net738 sg13g2_dfrbpq_1
XFILLER_48_407 VPWR VGND sg13g2_decap_8
XFILLER_0_469 VPWR VGND sg13g2_decap_8
Xhold11 serialize.shift_reg_r\[6\] VPWR VGND net499 sg13g2_dlygate4sd3_1
Xhold22 serialize.shift_reg_g\[6\] VPWR VGND net510 sg13g2_dlygate4sd3_1
XFILLER_29_33 VPWR VGND sg13g2_decap_8
Xhold33 serialize.shift_reg_r\[7\] VPWR VGND net521 sg13g2_dlygate4sd3_1
XFILLER_44_613 VPWR VGND sg13g2_fill_1
XFILLER_44_657 VPWR VGND sg13g2_fill_1
XFILLER_43_123 VPWR VGND sg13g2_fill_2
XFILLER_12_532 VPWR VGND sg13g2_fill_1
XFILLER_10_90 VPWR VGND sg13g2_decap_8
XFILLER_48_930 VPWR VGND sg13g2_decap_8
XFILLER_0_970 VPWR VGND sg13g2_decap_8
XFILLER_34_101 VPWR VGND sg13g2_decap_8
X_5740_ _2698_ _2687_ _2700_ VPWR VGND sg13g2_xor2_1
XFILLER_31_852 VPWR VGND sg13g2_fill_1
X_5671_ net610 net612 _2637_ _2638_ VPWR VGND sg13g2_nor3_1
X_4622_ videogen.test_lut_thingy.pixel_feeder_inst.row\[54\]\[0\] net635 _1629_ VPWR
+ VGND sg13g2_nor2_1
X_4553_ _1558_ VPWR _1560_ VGND net698 _1559_ sg13g2_o21ai_1
XFILLER_7_580 VPWR VGND sg13g2_fill_2
X_4484_ VGND VPWR _1491_ net638 videogen.test_lut_thingy.pixel_feeder_inst.row\[38\]\[1\]
+ sg13g2_or2_1
X_3504_ videogen.test_lut_thingy.pixel_feeder_inst.row\[44\]\[1\] net877 _0829_ _0607_
+ VPWR VGND sg13g2_mux2_1
X_3435_ VGND VPWR _0807_ _0806_ _0789_ sg13g2_or2_1
X_6223_ net402 VGND VPWR _0282_ videogen.test_lut_thingy.pixel_feeder_inst.row\[20\]\[2\]
+ _0011_ sg13g2_dfrbpq_1
XFILLER_44_1003 VPWR VGND sg13g2_decap_8
X_6154_ net757 net799 _0214_ VPWR VGND sg13g2_nor2_1
X_3366_ videogen.another_shader.video_y\[9\] net673 _0757_ _0758_ VPWR VGND sg13g2_nor3_1
X_6085_ net756 net798 _0145_ VPWR VGND sg13g2_nor2_1
X_5105_ VGND VPWR _2105_ _2111_ _2112_ _2103_ sg13g2_a21oi_1
XFILLER_39_963 VPWR VGND sg13g2_decap_8
X_5036_ VPWR _2043_ _2042_ VGND sg13g2_inv_1
XFILLER_15_57 VPWR VGND sg13g2_decap_8
X_5938_ _2861_ net746 net503 net751 red_tmds_par\[6\] VPWR VGND sg13g2_a22oi_1
XFILLER_15_68 VPWR VGND sg13g2_fill_2
X_6401__233 VPWR VGND net233 sg13g2_tiehi
XFILLER_21_362 VPWR VGND sg13g2_decap_8
X_5869_ VGND VPWR _2820_ _2823_ _0655_ _2817_ sg13g2_a21oi_1
XFILLER_5_506 VPWR VGND sg13g2_decap_8
Xoutput12 net12 uio_out[7] VPWR VGND sg13g2_buf_1
XFILLER_0_266 VPWR VGND sg13g2_fill_2
XFILLER_48_248 VPWR VGND sg13g2_decap_8
XFILLER_45_911 VPWR VGND sg13g2_decap_8
XFILLER_44_421 VPWR VGND sg13g2_fill_2
XFILLER_29_495 VPWR VGND sg13g2_fill_1
XFILLER_45_988 VPWR VGND sg13g2_decap_8
XFILLER_9_801 VPWR VGND sg13g2_fill_2
XFILLER_13_852 VPWR VGND sg13g2_fill_1
XFILLER_9_834 VPWR VGND sg13g2_decap_8
XFILLER_9_889 VPWR VGND sg13g2_decap_8
XFILLER_4_550 VPWR VGND sg13g2_decap_8
XFILLER_36_966 VPWR VGND sg13g2_decap_8
X_3984_ _1030_ videogen.another_shader.time_cnt\[18\] _1028_ VPWR VGND sg13g2_xnor2_1
X_5723_ VGND VPWR net667 _2685_ _0551_ net844 sg13g2_a21oi_1
XFILLER_31_660 VPWR VGND sg13g2_decap_8
X_5654_ VGND VPWR net667 _2520_ _0464_ net844 sg13g2_a21oi_1
X_4605_ net686 _1608_ _1609_ _1611_ _1612_ VPWR VGND sg13g2_nor4_1
X_5585_ net632 VPWR _2563_ VGND _2446_ _2497_ sg13g2_o21ai_1
X_4536_ VGND VPWR net665 _1536_ _1543_ _1542_ sg13g2_a21oi_1
XFILLER_2_509 VPWR VGND sg13g2_decap_8
X_4467_ videogen.test_lut_thingy.pixel_feeder_inst.row\[52\]\[1\] net645 _1474_ VPWR
+ VGND sg13g2_nor2_1
Xfanout813 net814 net813 VPWR VGND sg13g2_buf_8
Xfanout824 net825 net824 VPWR VGND sg13g2_buf_8
Xfanout802 net803 net802 VPWR VGND sg13g2_buf_8
X_6206_ net424 VGND VPWR _0265_ videogen.test_lut_thingy.pixel_feeder_inst.row\[34\]\[1\]
+ _0006_ sg13g2_dfrbpq_1
X_3418_ videogen.test_lut_thingy.pixel_feeder_inst.row\[35\]\[0\] net889 _0798_ _0673_
+ VPWR VGND sg13g2_mux2_1
X_4398_ _1405_ net662 videogen.test_lut_thingy.pixel_feeder_inst.row\[35\]\[2\] VPWR
+ VGND sg13g2_nand2b_1
X_3349_ _0742_ tmds_green.dc_balancing_reg\[3\] VPWR VGND sg13g2_inv_2
Xfanout846 net847 net846 VPWR VGND sg13g2_buf_8
Xfanout835 net839 net835 VPWR VGND sg13g2_buf_8
X_6137_ net787 net830 _0197_ VPWR VGND sg13g2_nor2_1
Xfanout857 net858 net857 VPWR VGND sg13g2_buf_8
Xfanout868 net869 net868 VPWR VGND sg13g2_buf_8
Xfanout879 net880 net879 VPWR VGND sg13g2_buf_8
X_6068_ net772 net815 _0129_ VPWR VGND sg13g2_nor2_1
X_5019_ _2025_ VPWR _2026_ VGND _2020_ _2023_ sg13g2_o21ai_1
XFILLER_42_903 VPWR VGND sg13g2_decap_8
X_6481__360 VPWR VGND net360 sg13g2_tiehi
XFILLER_13_137 VPWR VGND sg13g2_fill_2
XFILLER_42_44 VPWR VGND sg13g2_fill_1
XFILLER_42_33 VPWR VGND sg13g2_decap_8
XFILLER_10_833 VPWR VGND sg13g2_decap_8
XFILLER_21_170 VPWR VGND sg13g2_fill_2
XFILLER_22_693 VPWR VGND sg13g2_decap_4
XFILLER_6_826 VPWR VGND sg13g2_decap_8
XFILLER_5_347 VPWR VGND sg13g2_decap_4
XFILLER_1_531 VPWR VGND sg13g2_decap_8
XFILLER_18_922 VPWR VGND sg13g2_fill_2
XFILLER_18_955 VPWR VGND sg13g2_fill_1
Xclkbuf_3_1__f_clk_regs clknet_0_clk_regs clknet_3_1__leaf_clk_regs VPWR VGND sg13g2_buf_8
XFILLER_41_980 VPWR VGND sg13g2_decap_8
XFILLER_32_468 VPWR VGND sg13g2_fill_2
XFILLER_12_170 VPWR VGND sg13g2_decap_4
XFILLER_9_675 VPWR VGND sg13g2_decap_8
X_5370_ _2363_ _2362_ _2357_ VPWR VGND sg13g2_nand2b_1
X_4321_ videogen.test_lut_thingy.pixel_feeder_inst.row\[20\]\[2\] net650 _1328_ VPWR
+ VGND sg13g2_nor2_1
XFILLER_5_892 VPWR VGND sg13g2_fill_1
X_4252_ _1259_ _1202_ _1257_ VPWR VGND sg13g2_nand2_1
X_4183_ _1188_ _1186_ _1190_ VPWR VGND sg13g2_xor2_1
XFILLER_28_708 VPWR VGND sg13g2_fill_1
XFILLER_27_229 VPWR VGND sg13g2_fill_2
X_3967_ _0730_ _1013_ _1018_ VPWR VGND sg13g2_nor2_1
X_5706_ VGND VPWR _0742_ _2650_ _2671_ _2670_ sg13g2_a21oi_1
X_3898_ _0973_ net691 _0971_ VPWR VGND sg13g2_xnor2_1
XFILLER_12_47 VPWR VGND sg13g2_decap_4
X_5637_ VGND VPWR _2613_ net613 _2581_ sg13g2_or2_1
X_5568_ _2551_ _2540_ _2550_ VPWR VGND sg13g2_nand2_1
X_4519_ _1522_ _1523_ _1524_ _1525_ _1526_ VPWR VGND sg13g2_or4_1
X_5499_ _2471_ _2484_ _2485_ VPWR VGND sg13g2_nor2_2
Xfanout621 _0881_ net621 VPWR VGND sg13g2_buf_2
Xfanout610 _2606_ net610 VPWR VGND sg13g2_buf_2
Xfanout632 _0924_ net632 VPWR VGND sg13g2_buf_8
Xfanout654 net657 net654 VPWR VGND sg13g2_buf_8
Xfanout676 videogen.another_shader.video_y\[1\] net676 VPWR VGND sg13g2_buf_8
Xfanout665 _0738_ net665 VPWR VGND sg13g2_buf_8
Xfanout643 _0925_ net643 VPWR VGND sg13g2_buf_8
Xfanout687 net695 net687 VPWR VGND sg13g2_buf_2
Xfanout698 net700 net698 VPWR VGND sg13g2_buf_8
XFILLER_39_590 VPWR VGND sg13g2_decap_8
XFILLER_2_1000 VPWR VGND sg13g2_decap_8
XFILLER_18_218 VPWR VGND sg13g2_fill_1
XFILLER_30_939 VPWR VGND sg13g2_decap_4
XFILLER_41_298 VPWR VGND sg13g2_decap_8
XFILLER_6_612 VPWR VGND sg13g2_decap_8
XFILLER_10_641 VPWR VGND sg13g2_decap_4
XFILLER_6_689 VPWR VGND sg13g2_decap_8
XFILLER_2_895 VPWR VGND sg13g2_decap_8
XFILLER_1_372 VPWR VGND sg13g2_decap_8
X_6429__55 VPWR VGND net55 sg13g2_tiehi
XFILLER_49_354 VPWR VGND sg13g2_decap_8
X_4870_ _1877_ _1863_ _1854_ _1858_ _1857_ VPWR VGND sg13g2_a22oi_1
X_3821_ _0930_ net894 _0929_ VPWR VGND sg13g2_nand2_2
XFILLER_32_243 VPWR VGND sg13g2_fill_2
X_6540_ net97 VGND VPWR _0595_ videogen.test_lut_thingy.pixel_feeder_inst.row\[47\]\[1\]
+ _0182_ sg13g2_dfrbpq_1
X_6501__293 VPWR VGND net293 sg13g2_tiehi
X_3752_ net717 _0887_ _0888_ VPWR VGND sg13g2_and2_1
X_3683_ videogen.test_lut_thingy.pixel_feeder_inst.row\[11\]\[0\] net881 _0867_ _0448_
+ VPWR VGND sg13g2_mux2_1
X_6471_ net423 VGND VPWR _0526_ videogen.test_lut_thingy.pixel_feeder_inst.row\[57\]\[1\]
+ _0122_ sg13g2_dfrbpq_1
X_5422_ _2415_ _2399_ _2412_ VPWR VGND sg13g2_nand2_1
X_5353_ _1136_ _2343_ _2346_ VPWR VGND sg13g2_and2_1
X_4304_ _1305_ VPWR _1311_ VGND _1299_ _1310_ sg13g2_o21ai_1
X_5284_ _1125_ _2275_ _2277_ VPWR VGND sg13g2_nor2b_2
X_4235_ _1242_ _1227_ _1241_ VPWR VGND sg13g2_nand2_1
X_4166_ videogen.fancy_shader.shader_counter_reg\[7\] net670 _1172_ _1173_ VPWR VGND
+ sg13g2_a21o_1
X_4097_ net847 videogen.test_lut_thingy.gol_counter_reg\[0\] _0396_ VPWR VGND sg13g2_nor2_1
XFILLER_36_582 VPWR VGND sg13g2_fill_2
XFILLER_12_917 VPWR VGND sg13g2_decap_4
XFILLER_11_416 VPWR VGND sg13g2_decap_8
X_4999_ _2006_ _1989_ _2004_ VPWR VGND sg13g2_xnor2_1
X_6537__109 VPWR VGND net109 sg13g2_tiehi
XFILLER_3_626 VPWR VGND sg13g2_decap_8
XFILLER_2_103 VPWR VGND sg13g2_decap_8
XFILLER_48_21 VPWR VGND sg13g2_decap_8
XFILLER_48_76 VPWR VGND sg13g2_fill_1
XFILLER_24_1023 VPWR VGND sg13g2_decap_4
XFILLER_47_825 VPWR VGND sg13g2_decap_8
XFILLER_0_28 VPWR VGND sg13g2_decap_8
XFILLER_42_541 VPWR VGND sg13g2_decap_4
XFILLER_14_254 VPWR VGND sg13g2_decap_4
XFILLER_15_799 VPWR VGND sg13g2_fill_1
XFILLER_11_961 VPWR VGND sg13g2_fill_1
XFILLER_6_420 VPWR VGND sg13g2_fill_1
XFILLER_10_471 VPWR VGND sg13g2_decap_8
XFILLER_11_994 VPWR VGND sg13g2_decap_8
XFILLER_31_1027 VPWR VGND sg13g2_fill_2
XFILLER_6_453 VPWR VGND sg13g2_fill_2
XFILLER_2_670 VPWR VGND sg13g2_decap_8
X_4020_ _1056_ videogen.another_shader.time_cnt\[28\] _1054_ VPWR VGND sg13g2_nand2_1
X_5971_ net768 net810 _0032_ VPWR VGND sg13g2_nor2_1
XFILLER_25_519 VPWR VGND sg13g2_decap_8
X_4922_ VPWR VGND _1924_ _1912_ _1922_ _1742_ _1929_ _1913_ sg13g2_a221oi_1
XFILLER_18_582 VPWR VGND sg13g2_fill_2
X_4853_ _1857_ _1858_ _1854_ _1860_ VPWR VGND sg13g2_nand3_1
XFILLER_21_747 VPWR VGND sg13g2_fill_1
XFILLER_33_574 VPWR VGND sg13g2_fill_1
XFILLER_33_596 VPWR VGND sg13g2_fill_1
X_4784_ _1763_ _1790_ _1791_ VPWR VGND sg13g2_nor2_1
X_3804_ serialize.shift_reg_c\[1\] serialize.shift_reg_c\[0\] clknet_1_0__leaf_clk
+ net4 VPWR VGND sg13g2_mux2_1
X_3735_ videogen.test_lut_thingy.pixel_feeder_inst.row\[20\]\[3\] net857 _0878_ _0283_
+ VPWR VGND sg13g2_mux2_1
X_6523_ net205 VGND VPWR _0578_ videogen.test_lut_thingy.pixel_feeder_inst.row\[51\]\[0\]
+ _0165_ sg13g2_dfrbpq_1
X_6454_ net462 VGND VPWR _0509_ videogen.test_lut_thingy.pixel_feeder_inst.row\[60\]\[0\]
+ _0105_ sg13g2_dfrbpq_1
X_5405_ _2345_ _2397_ _2398_ VPWR VGND sg13g2_nor2b_1
X_3666_ videogen.test_lut_thingy.pixel_feeder_inst.row\[36\]\[2\] net866 _0864_ _0471_
+ VPWR VGND sg13g2_mux2_1
Xheichips25_bagel_28 VPWR VGND uio_oe[7] sg13g2_tielo
X_6385_ net126 VGND VPWR _0444_ videogen.test_lut_thingy.pixel_feeder_inst.row\[15\]\[0\]
+ _0049_ sg13g2_dfrbpq_1
X_3597_ net852 videogen.test_lut_thingy.pixel_feeder_inst.row\[58\]\[3\] _0848_ _0524_
+ VPWR VGND sg13g2_mux2_1
X_5336_ _2329_ _2328_ _2274_ VPWR VGND sg13g2_nand2b_1
X_5267_ _1313_ VPWR _2266_ VGND _2260_ _2265_ sg13g2_o21ai_1
X_4218_ VGND VPWR _1223_ _1224_ _1225_ _1221_ sg13g2_a21oi_1
X_5198_ _2195_ _1181_ _2197_ VPWR VGND sg13g2_xor2_1
XFILLER_18_57 VPWR VGND sg13g2_fill_1
XFILLER_18_68 VPWR VGND sg13g2_decap_4
X_4149_ _1154_ _1155_ _1156_ VPWR VGND sg13g2_nor2b_1
XFILLER_28_346 VPWR VGND sg13g2_decap_8
XFILLER_44_828 VPWR VGND sg13g2_decap_8
XFILLER_37_880 VPWR VGND sg13g2_fill_1
XFILLER_28_379 VPWR VGND sg13g2_decap_4
XFILLER_43_338 VPWR VGND sg13g2_decap_8
XFILLER_11_246 VPWR VGND sg13g2_fill_1
Xclkload0 VPWR clkload0/Y clknet_1_1__leaf_clk VGND sg13g2_inv_1
XFILLER_20_780 VPWR VGND sg13g2_fill_1
XFILLER_4_968 VPWR VGND sg13g2_decap_8
XFILLER_3_423 VPWR VGND sg13g2_fill_1
XFILLER_46_132 VPWR VGND sg13g2_fill_2
XFILLER_34_327 VPWR VGND sg13g2_fill_1
XFILLER_15_552 VPWR VGND sg13g2_decap_4
XFILLER_42_382 VPWR VGND sg13g2_fill_1
XFILLER_42_393 VPWR VGND sg13g2_fill_2
X_3520_ videogen.test_lut_thingy.pixel_feeder_inst.row\[47\]\[0\] net887 _0832_ _0594_
+ VPWR VGND sg13g2_mux2_1
XFILLER_7_795 VPWR VGND sg13g2_fill_2
X_3451_ VGND VPWR _0713_ _0811_ _0643_ _0812_ sg13g2_a21oi_1
X_3382_ _0774_ net701 net705 VPWR VGND sg13g2_nand2_2
X_6170_ net780 net823 _0230_ VPWR VGND sg13g2_nor2_1
X_5121_ _2127_ _1676_ _2128_ VPWR VGND sg13g2_nor2b_1
X_5052_ _2047_ _2041_ _2044_ _2059_ VPWR VGND sg13g2_mux2_1
X_4003_ net899 VPWR _1044_ VGND videogen.another_shader.time_cnt\[23\] _1042_ sg13g2_o21ai_1
X_5954_ net756 net799 _0015_ VPWR VGND sg13g2_nor2_1
X_4905_ _1912_ _1910_ _1911_ VPWR VGND sg13g2_nand2_2
X_5885_ _2834_ _2723_ _2756_ VPWR VGND sg13g2_nand2_1
X_4836_ _1839_ _1842_ _1843_ VPWR VGND sg13g2_nor2_1
XFILLER_14_1011 VPWR VGND sg13g2_decap_8
X_4767_ _1774_ _1770_ _1773_ VPWR VGND sg13g2_nand2_1
X_6506_ net277 VGND VPWR _0561_ videogen.test_lut_thingy.pixel_feeder_inst.row\[2\]\[3\]
+ _0148_ sg13g2_dfrbpq_1
X_3718_ videogen.test_lut_thingy.pixel_feeder_inst.row\[29\]\[0\] net889 _0874_ _0307_
+ VPWR VGND sg13g2_mux2_1
X_4698_ _1705_ videogen.another_shader.time_cnt\[6\] net712 VPWR VGND sg13g2_xnor2_1
X_6437_ net39 VGND VPWR _0492_ videogen.test_lut_thingy.pixel_feeder_inst.row\[30\]\[3\]
+ _0088_ sg13g2_dfrbpq_1
X_3649_ _0805_ _0854_ _0861_ VPWR VGND sg13g2_nor2_2
X_6368_ net151 VGND VPWR _0427_ red_tmds_par\[0\] net739 sg13g2_dfrbpq_1
XFILLER_1_949 VPWR VGND sg13g2_decap_8
X_5319_ _2303_ _2311_ _2312_ VPWR VGND sg13g2_nor2_1
X_6299_ net262 VGND VPWR _0358_ videogen.another_shader.time_cnt\[14\] net732 sg13g2_dfrbpq_2
XFILLER_0_448 VPWR VGND sg13g2_decap_8
Xhold23 serialize.shift_reg_r\[2\] VPWR VGND net511 sg13g2_dlygate4sd3_1
Xhold12 serialize.shift_reg_g\[5\] VPWR VGND net500 sg13g2_dlygate4sd3_1
XFILLER_29_622 VPWR VGND sg13g2_fill_1
Xhold34 serialize.shift_reg_b\[4\] VPWR VGND net522 sg13g2_dlygate4sd3_1
XFILLER_28_121 VPWR VGND sg13g2_fill_1
XFILLER_29_633 VPWR VGND sg13g2_fill_2
XFILLER_44_636 VPWR VGND sg13g2_decap_4
XFILLER_40_820 VPWR VGND sg13g2_decap_8
X_6261__338 VPWR VGND net338 sg13g2_tiehi
XFILLER_3_264 VPWR VGND sg13g2_fill_2
XFILLER_3_297 VPWR VGND sg13g2_fill_1
XFILLER_48_986 VPWR VGND sg13g2_decap_8
XFILLER_19_187 VPWR VGND sg13g2_fill_1
X_6307__246 VPWR VGND net246 sg13g2_tiehi
XFILLER_16_872 VPWR VGND sg13g2_fill_1
X_5670_ _2636_ _2625_ _2637_ VPWR VGND sg13g2_xor2_1
XFILLER_30_330 VPWR VGND sg13g2_fill_1
XFILLER_31_831 VPWR VGND sg13g2_decap_8
X_4621_ videogen.test_lut_thingy.pixel_feeder_inst.row\[52\]\[0\] net647 _1628_ VPWR
+ VGND sg13g2_nor2_1
X_4552_ net702 videogen.test_lut_thingy.pixel_feeder_inst.row\[48\]\[3\] videogen.test_lut_thingy.pixel_feeder_inst.row\[50\]\[3\]
+ videogen.test_lut_thingy.pixel_feeder_inst.row\[49\]\[3\] videogen.test_lut_thingy.pixel_feeder_inst.row\[51\]\[3\]
+ net706 _1559_ VPWR VGND sg13g2_mux4_1
X_4483_ videogen.test_lut_thingy.pixel_feeder_inst.row\[36\]\[1\] net648 _1490_ VPWR
+ VGND sg13g2_nor2_1
X_3503_ videogen.test_lut_thingy.pixel_feeder_inst.row\[44\]\[2\] net866 _0829_ _0608_
+ VPWR VGND sg13g2_mux2_1
X_6222_ net404 VGND VPWR _0281_ videogen.test_lut_thingy.pixel_feeder_inst.row\[20\]\[1\]
+ _0010_ sg13g2_dfrbpq_1
X_3434_ _0806_ _0785_ _0795_ VPWR VGND sg13g2_nand2_1
X_6314__228 VPWR VGND net228 sg13g2_tiehi
X_6153_ net761 net798 _0213_ VPWR VGND sg13g2_nor2_1
X_3365_ net670 net671 videogen.another_shader.video_y\[8\] _0757_ VPWR VGND videogen.another_shader.video_y\[5\]
+ sg13g2_nand4_1
X_5104_ _2108_ _2109_ _2111_ VPWR VGND _2106_ sg13g2_nand3b_1
X_6084_ VGND VPWR _2683_ _2684_ _0550_ net845 sg13g2_a21oi_1
XFILLER_39_942 VPWR VGND sg13g2_decap_8
X_5035_ _2039_ _2030_ _2042_ VPWR VGND sg13g2_xor2_1
XFILLER_26_603 VPWR VGND sg13g2_fill_1
XFILLER_25_157 VPWR VGND sg13g2_fill_2
X_5937_ VPWR _0706_ _2860_ VGND sg13g2_inv_1
XFILLER_40_149 VPWR VGND sg13g2_decap_4
XFILLER_22_842 VPWR VGND sg13g2_fill_1
XFILLER_22_853 VPWR VGND sg13g2_fill_1
XFILLER_34_691 VPWR VGND sg13g2_fill_2
X_5868_ _0745_ _2822_ _2823_ VPWR VGND sg13g2_nor2_1
X_4819_ _1826_ _1759_ _1824_ VPWR VGND sg13g2_nand2_1
XFILLER_21_374 VPWR VGND sg13g2_fill_2
X_5799_ _0924_ VPWR _2759_ VGND _2733_ _2758_ sg13g2_o21ai_1
Xoutput13 net13 uo_out[0] VPWR VGND sg13g2_buf_1
XFILLER_1_713 VPWR VGND sg13g2_decap_8
XFILLER_49_706 VPWR VGND sg13g2_decap_8
XFILLER_0_245 VPWR VGND sg13g2_decap_8
XFILLER_49_728 VPWR VGND sg13g2_decap_4
XFILLER_0_278 VPWR VGND sg13g2_decap_4
XFILLER_0_256 VPWR VGND sg13g2_fill_1
Xclkbuf_3_0__f_clk_regs clknet_0_clk_regs clknet_3_0__leaf_clk_regs VPWR VGND sg13g2_buf_8
XFILLER_45_967 VPWR VGND sg13g2_decap_8
XFILLER_44_455 VPWR VGND sg13g2_fill_2
XFILLER_44_499 VPWR VGND sg13g2_decap_4
XFILLER_13_842 VPWR VGND sg13g2_fill_2
XFILLER_40_694 VPWR VGND sg13g2_decap_8
XFILLER_8_389 VPWR VGND sg13g2_decap_4
XFILLER_21_90 VPWR VGND sg13g2_fill_1
XFILLER_39_205 VPWR VGND sg13g2_decap_4
XFILLER_11_4 VPWR VGND sg13g2_fill_2
XFILLER_48_783 VPWR VGND sg13g2_decap_8
XFILLER_36_945 VPWR VGND sg13g2_decap_8
XFILLER_23_617 VPWR VGND sg13g2_fill_1
XFILLER_35_488 VPWR VGND sg13g2_decap_4
X_3983_ net843 _1027_ _1028_ _0361_ VPWR VGND sg13g2_nor3_1
X_5722_ _2610_ _2574_ _2685_ VPWR VGND sg13g2_xor2_1
XFILLER_15_190 VPWR VGND sg13g2_fill_1
X_5653_ VGND VPWR net667 _2458_ _0463_ net844 sg13g2_a21oi_1
XFILLER_30_171 VPWR VGND sg13g2_decap_8
X_4604_ _1610_ VPWR _1611_ VGND videogen.test_lut_thingy.pixel_feeder_inst.row\[1\]\[0\]
+ net622 sg13g2_o21ai_1
X_5584_ net643 _2562_ _0430_ VPWR VGND sg13g2_nor2_1
X_4535_ net684 VPWR _1542_ VGND net665 _1541_ sg13g2_o21ai_1
X_4466_ videogen.test_lut_thingy.pixel_feeder_inst.row\[54\]\[1\] net635 _1473_ VPWR
+ VGND sg13g2_nor2_1
Xfanout825 net840 net825 VPWR VGND sg13g2_buf_8
Xfanout803 net841 net803 VPWR VGND sg13g2_buf_8
X_3417_ videogen.test_lut_thingy.pixel_feeder_inst.row\[35\]\[1\] net878 _0798_ _0674_
+ VPWR VGND sg13g2_mux2_1
X_6205_ net426 VGND VPWR _0264_ videogen.test_lut_thingy.pixel_feeder_inst.row\[34\]\[0\]
+ _0005_ sg13g2_dfrbpq_1
Xfanout814 net820 net814 VPWR VGND sg13g2_buf_8
X_4397_ videogen.test_lut_thingy.pixel_feeder_inst.row\[32\]\[2\] net649 _1404_ VPWR
+ VGND sg13g2_nor2_1
Xfanout836 net839 net836 VPWR VGND sg13g2_buf_8
X_3348_ VPWR _0741_ tmds_green.dc_balancing_reg\[1\] VGND sg13g2_inv_1
X_6136_ net781 net824 _0196_ VPWR VGND sg13g2_nor2_1
Xfanout858 net859 net858 VPWR VGND sg13g2_buf_8
Xfanout847 net848 net847 VPWR VGND sg13g2_buf_8
Xfanout869 ui_in[6] net869 VPWR VGND sg13g2_buf_8
X_6067_ net767 net809 _0128_ VPWR VGND sg13g2_nor2_1
X_5018_ _2015_ _2012_ _2024_ _2025_ VPWR VGND sg13g2_a21o_1
XFILLER_26_35 VPWR VGND sg13g2_fill_1
XFILLER_42_959 VPWR VGND sg13g2_decap_8
XFILLER_21_182 VPWR VGND sg13g2_decap_8
XFILLER_49_503 VPWR VGND sg13g2_decap_8
XFILLER_1_587 VPWR VGND sg13g2_decap_8
XFILLER_36_208 VPWR VGND sg13g2_fill_1
XFILLER_29_293 VPWR VGND sg13g2_fill_2
XFILLER_33_959 VPWR VGND sg13g2_fill_2
XFILLER_34_1014 VPWR VGND sg13g2_decap_8
XFILLER_40_480 VPWR VGND sg13g2_fill_2
X_6634__139 VPWR VGND net139 sg13g2_tiehi
X_4320_ net700 _1321_ _1326_ _1327_ VPWR VGND sg13g2_nor3_1
XFILLER_4_370 VPWR VGND sg13g2_fill_2
X_4251_ VGND VPWR _1258_ _1178_ _1160_ sg13g2_or2_1
X_4182_ _1189_ _1186_ _1188_ VPWR VGND sg13g2_xnor2_1
XFILLER_36_731 VPWR VGND sg13g2_decap_4
XFILLER_35_274 VPWR VGND sg13g2_fill_2
X_3966_ VGND VPWR _0730_ _1013_ _1017_ net842 sg13g2_a21oi_1
XFILLER_11_609 VPWR VGND sg13g2_fill_2
X_5705_ _2599_ _2650_ _2670_ VPWR VGND sg13g2_nor2_1
X_3897_ _0897_ _0971_ _0972_ _0324_ VPWR VGND sg13g2_nor3_1
X_5636_ VGND VPWR green\[0\] _2610_ _0436_ _2612_ sg13g2_a21oi_1
X_5567_ _2550_ _2546_ _2549_ VPWR VGND sg13g2_xnor2_1
X_5498_ VPWR _2484_ _2483_ VGND sg13g2_inv_1
X_4518_ videogen.test_lut_thingy.pixel_feeder_inst.row\[33\]\[3\] net628 _1525_ VPWR
+ VGND sg13g2_nor2_1
X_4449_ videogen.test_lut_thingy.pixel_feeder_inst.row\[11\]\[1\] net654 _1456_ VPWR
+ VGND sg13g2_nor2_1
Xfanout622 net625 net622 VPWR VGND sg13g2_buf_8
Xfanout611 _2606_ net611 VPWR VGND sg13g2_buf_1
Xfanout633 net636 net633 VPWR VGND sg13g2_buf_8
Xfanout666 videogen.mem_read net666 VPWR VGND sg13g2_buf_8
Xfanout644 net645 net644 VPWR VGND sg13g2_buf_8
Xfanout655 net657 net655 VPWR VGND sg13g2_buf_8
Xfanout688 net690 net688 VPWR VGND sg13g2_buf_8
Xfanout677 videogen.another_shader.video_y\[0\] net677 VPWR VGND sg13g2_buf_8
Xfanout699 net700 net699 VPWR VGND sg13g2_buf_8
X_6119_ net766 net808 _0179_ VPWR VGND sg13g2_nor2_1
XFILLER_46_517 VPWR VGND sg13g2_decap_4
XFILLER_42_723 VPWR VGND sg13g2_fill_1
XFILLER_14_403 VPWR VGND sg13g2_decap_4
XFILLER_22_480 VPWR VGND sg13g2_fill_2
XFILLER_22_491 VPWR VGND sg13g2_fill_1
X_6633__183 VPWR VGND net183 sg13g2_tiehi
XFILLER_2_874 VPWR VGND sg13g2_decap_8
XFILLER_1_351 VPWR VGND sg13g2_decap_8
XFILLER_49_333 VPWR VGND sg13g2_decap_8
XFILLER_17_252 VPWR VGND sg13g2_fill_2
XFILLER_45_583 VPWR VGND sg13g2_fill_1
X_3820_ net708 _0890_ net709 _0929_ VPWR VGND _0927_ sg13g2_nand4_1
XFILLER_21_907 VPWR VGND sg13g2_fill_1
X_6495__305 VPWR VGND net305 sg13g2_tiehi
XFILLER_33_789 VPWR VGND sg13g2_fill_1
X_3751_ videogen.another_shader.video_x\[1\] videogen.another_shader.video_x\[0\]
+ _0887_ VPWR VGND sg13g2_and2_1
XFILLER_9_440 VPWR VGND sg13g2_decap_8
XFILLER_9_462 VPWR VGND sg13g2_decap_8
X_3682_ videogen.test_lut_thingy.pixel_feeder_inst.row\[11\]\[1\] net870 _0867_ _0449_
+ VPWR VGND sg13g2_mux2_1
X_6470_ net430 VGND VPWR _0525_ videogen.test_lut_thingy.pixel_feeder_inst.row\[57\]\[0\]
+ _0121_ sg13g2_dfrbpq_1
X_5421_ _2414_ _2399_ _2410_ VPWR VGND sg13g2_xnor2_1
X_5352_ _2345_ _1137_ _2344_ VPWR VGND sg13g2_xnor2_1
X_4303_ _1310_ _1303_ _1308_ VPWR VGND sg13g2_nand2_1
X_5283_ _2275_ _2187_ _2276_ VPWR VGND sg13g2_xor2_1
XFILLER_4_82 VPWR VGND sg13g2_decap_4
X_4234_ _1236_ _1240_ _1241_ VPWR VGND sg13g2_nor2_1
X_4165_ _1158_ _1151_ _1150_ _1172_ VPWR VGND sg13g2_a21o_1
XFILLER_28_517 VPWR VGND sg13g2_decap_8
XFILLER_28_528 VPWR VGND sg13g2_fill_1
X_4096_ _1108_ VPWR _0395_ VGND _0717_ net615 sg13g2_o21ai_1
X_6623__341 VPWR VGND net341 sg13g2_tiehi
X_6443__484 VPWR VGND net484 sg13g2_tiehi
X_4998_ VPWR VGND _2002_ _1989_ _2000_ _1729_ _2005_ _1990_ sg13g2_a221oi_1
XFILLER_23_25 VPWR VGND sg13g2_decap_4
XFILLER_23_69 VPWR VGND sg13g2_decap_4
X_3949_ videogen.another_shader.time_cnt\[8\] _1004_ _1005_ VPWR VGND sg13g2_nor2_1
X_5619_ _2594_ _2595_ _2596_ VPWR VGND sg13g2_and2_1
X_6599_ net99 VGND VPWR _0654_ blue_tmds_par\[0\] net743 sg13g2_dfrbpq_1
XFILLER_3_605 VPWR VGND sg13g2_decap_8
XFILLER_2_115 VPWR VGND sg13g2_decap_8
XFILLER_2_126 VPWR VGND sg13g2_fill_1
XFILLER_24_1002 VPWR VGND sg13g2_decap_8
XFILLER_47_804 VPWR VGND sg13g2_decap_8
XFILLER_48_55 VPWR VGND sg13g2_decap_8
XFILLER_46_314 VPWR VGND sg13g2_fill_1
XFILLER_46_336 VPWR VGND sg13g2_fill_2
XFILLER_42_586 VPWR VGND sg13g2_fill_2
XFILLER_9_49 VPWR VGND sg13g2_decap_8
XFILLER_11_940 VPWR VGND sg13g2_decap_8
XFILLER_7_944 VPWR VGND sg13g2_decap_4
XFILLER_10_450 VPWR VGND sg13g2_decap_4
XFILLER_11_973 VPWR VGND sg13g2_decap_8
XFILLER_7_988 VPWR VGND sg13g2_decap_8
X_6271__318 VPWR VGND net318 sg13g2_tiehi
XFILLER_43_7 VPWR VGND sg13g2_fill_2
XFILLER_9_1018 VPWR VGND sg13g2_decap_8
XFILLER_49_185 VPWR VGND sg13g2_fill_2
X_5970_ net768 net810 _0031_ VPWR VGND sg13g2_nor2_1
X_4921_ _1928_ _1914_ _1925_ VPWR VGND sg13g2_nand2_1
X_4852_ _1859_ _1854_ _1857_ _1858_ VPWR VGND sg13g2_and3_1
X_3803_ _0910_ _0923_ net7 VPWR VGND sg13g2_nor2_1
X_4783_ _1790_ _1779_ _1785_ VPWR VGND sg13g2_xnor2_1
X_6522_ net209 VGND VPWR _0577_ videogen.test_lut_thingy.pixel_feeder_inst.row\[25\]\[3\]
+ _0164_ sg13g2_dfrbpq_1
X_3734_ _0790_ _0828_ _0878_ VPWR VGND sg13g2_nor2_2
XFILLER_9_292 VPWR VGND sg13g2_decap_4
X_3665_ videogen.test_lut_thingy.pixel_feeder_inst.row\[36\]\[3\] net855 _0864_ _0472_
+ VPWR VGND sg13g2_mux2_1
X_6453_ net464 VGND VPWR _0508_ videogen.test_lut_thingy.pixel_feeder_inst.row\[61\]\[3\]
+ _0104_ sg13g2_dfrbpq_1
X_5404_ _2396_ _2392_ _2389_ _2397_ VPWR VGND sg13g2_a21o_1
Xheichips25_bagel_29 VPWR VGND uio_out[1] sg13g2_tielo
X_6384_ net128 VGND VPWR _0443_ videogen.test_lut_thingy.pixel_feeder_inst.row\[16\]\[3\]
+ _0048_ sg13g2_dfrbpq_1
X_3596_ _0809_ _0824_ net618 _0848_ VPWR VGND sg13g2_nand3_1
X_5335_ _2328_ _1248_ _1237_ VPWR VGND sg13g2_nand2b_1
X_5266_ _2259_ _2256_ _2264_ _2265_ VPWR VGND sg13g2_a21o_1
X_4217_ _1138_ _1215_ _1224_ VPWR VGND sg13g2_nor2_1
X_5197_ _1181_ _2195_ _2196_ VPWR VGND sg13g2_nor2b_1
XFILLER_29_837 VPWR VGND sg13g2_fill_1
XFILLER_44_807 VPWR VGND sg13g2_decap_8
X_4148_ VGND VPWR _1132_ _1133_ _1155_ _1134_ sg13g2_a21oi_1
X_4079_ _0907_ _0929_ _1097_ VPWR VGND sg13g2_nor2_1
X_6416__81 VPWR VGND net81 sg13g2_tiehi
X_6324__208 VPWR VGND net208 sg13g2_tiehi
X_6431__51 VPWR VGND net51 sg13g2_tiehi
XFILLER_34_35 VPWR VGND sg13g2_fill_1
XFILLER_7_218 VPWR VGND sg13g2_fill_1
Xclkload1 VPWR clkload1/Y clknet_3_1__leaf_clk_regs VGND sg13g2_inv_1
XFILLER_20_792 VPWR VGND sg13g2_decap_8
XFILLER_4_947 VPWR VGND sg13g2_decap_8
XFILLER_19_336 VPWR VGND sg13g2_decap_8
X_6522__209 VPWR VGND net209 sg13g2_tiehi
X_6407__92 VPWR VGND net92 sg13g2_tiehi
XFILLER_43_884 VPWR VGND sg13g2_decap_8
XFILLER_7_741 VPWR VGND sg13g2_decap_8
XFILLER_6_240 VPWR VGND sg13g2_fill_2
X_3450_ net876 _0811_ _0812_ VPWR VGND sg13g2_nor2_1
X_3381_ net702 net706 _0773_ VPWR VGND sg13g2_and2_1
X_5120_ _2127_ _2125_ _2111_ _2124_ _2119_ VPWR VGND sg13g2_a22oi_1
XFILLER_3_980 VPWR VGND sg13g2_decap_8
X_5051_ _2058_ _2056_ _2057_ VPWR VGND sg13g2_xnor2_1
X_4002_ videogen.another_shader.time_cnt\[22\] _1039_ videogen.another_shader.time_cnt\[23\]
+ _1043_ VPWR VGND sg13g2_nand3_1
XFILLER_38_667 VPWR VGND sg13g2_fill_1
XFILLER_26_818 VPWR VGND sg13g2_decap_4
X_5953_ net757 net799 _0014_ VPWR VGND sg13g2_nor2_1
X_6247__364 VPWR VGND net364 sg13g2_tiehi
X_4904_ _1900_ _1908_ _1911_ VPWR VGND _1745_ sg13g2_nand3b_1
XFILLER_40_309 VPWR VGND sg13g2_decap_8
X_5884_ VGND VPWR _2712_ _2754_ _2833_ _0745_ sg13g2_a21oi_1
X_4835_ VGND VPWR _1834_ _1841_ _1842_ _1838_ sg13g2_a21oi_1
XFILLER_33_394 VPWR VGND sg13g2_decap_4
X_4766_ VGND VPWR _1768_ _1771_ _1773_ _1767_ sg13g2_a21oi_1
X_6505_ net281 VGND VPWR _0560_ videogen.test_lut_thingy.pixel_feeder_inst.row\[2\]\[2\]
+ _0147_ sg13g2_dfrbpq_1
X_3717_ videogen.test_lut_thingy.pixel_feeder_inst.row\[29\]\[1\] net880 _0874_ _0308_
+ VPWR VGND sg13g2_mux2_1
X_4697_ _1704_ videogen.another_shader.time_cnt\[6\] net712 VPWR VGND sg13g2_nand2_1
X_6436_ net41 VGND VPWR _0491_ videogen.test_lut_thingy.pixel_feeder_inst.row\[30\]\[2\]
+ _0087_ sg13g2_dfrbpq_1
X_3648_ _0860_ VPWR _0485_ VGND _0716_ _0858_ sg13g2_o21ai_1
X_6367_ net152 VGND VPWR _0426_ tmds_red.dc_balancing_reg\[4\] net737 sg13g2_dfrbpq_2
X_3579_ videogen.test_lut_thingy.pixel_feeder_inst.row\[52\]\[1\] net871 _0844_ _0538_
+ VPWR VGND sg13g2_mux2_1
XFILLER_0_427 VPWR VGND sg13g2_decap_8
XFILLER_1_928 VPWR VGND sg13g2_decap_8
X_5318_ _2304_ _2310_ _2311_ VPWR VGND sg13g2_nor2_1
X_6298_ net264 VGND VPWR _0357_ videogen.another_shader.time_cnt\[13\] net732 sg13g2_dfrbpq_1
Xhold13 serialize.shift_reg_r\[4\] VPWR VGND net501 sg13g2_dlygate4sd3_1
Xhold35 clockdiv.q0 VPWR VGND net523 sg13g2_dlygate4sd3_1
Xhold24 serialize.shift_reg_r\[3\] VPWR VGND net512 sg13g2_dlygate4sd3_1
X_5249_ _2245_ _2247_ _2248_ VPWR VGND sg13g2_nor2_1
XFILLER_21_1027 VPWR VGND sg13g2_fill_2
XFILLER_28_133 VPWR VGND sg13g2_decap_4
XFILLER_4_722 VPWR VGND sg13g2_decap_8
XFILLER_39_409 VPWR VGND sg13g2_fill_1
XFILLER_48_965 VPWR VGND sg13g2_decap_8
XFILLER_47_453 VPWR VGND sg13g2_decap_8
XFILLER_47_486 VPWR VGND sg13g2_decap_4
XFILLER_37_1023 VPWR VGND sg13g2_decap_4
XFILLER_43_692 VPWR VGND sg13g2_fill_2
X_4620_ net698 _1621_ _1626_ _1627_ VPWR VGND sg13g2_nor3_1
XFILLER_30_364 VPWR VGND sg13g2_fill_2
XFILLER_31_898 VPWR VGND sg13g2_decap_8
X_4551_ net698 VPWR _1558_ VGND _1516_ _1557_ sg13g2_o21ai_1
XFILLER_7_582 VPWR VGND sg13g2_fill_1
XFILLER_7_571 VPWR VGND sg13g2_fill_1
X_4482_ videogen.test_lut_thingy.pixel_feeder_inst.row\[39\]\[1\] net658 _1489_ VPWR
+ VGND sg13g2_nor2_1
X_3502_ videogen.test_lut_thingy.pixel_feeder_inst.row\[44\]\[3\] net854 _0829_ _0609_
+ VPWR VGND sg13g2_mux2_1
X_6221_ net406 VGND VPWR _0280_ videogen.test_lut_thingy.pixel_feeder_inst.row\[20\]\[0\]
+ _0009_ sg13g2_dfrbpq_1
X_3433_ _0805_ _0800_ VPWR VGND net704 sg13g2_nand2b_2
X_6152_ net786 net829 _0212_ VPWR VGND sg13g2_nor2_1
X_5103_ _2110_ _2108_ _2109_ VPWR VGND sg13g2_nand2_1
X_3364_ videogen.another_shader.video_y\[8\] net670 _0717_ _0756_ VPWR VGND net671
+ sg13g2_nand4_1
XFILLER_32_0 VPWR VGND sg13g2_decap_4
XFILLER_39_921 VPWR VGND sg13g2_decap_8
X_6083_ net771 net814 _0144_ VPWR VGND sg13g2_nor2_1
X_5034_ _2036_ _2040_ _2041_ VPWR VGND sg13g2_nor2b_1
XFILLER_39_998 VPWR VGND sg13g2_decap_8
XFILLER_26_615 VPWR VGND sg13g2_fill_1
X_5936_ _2860_ net746 net521 net753 red_tmds_par\[5\] VPWR VGND sg13g2_a22oi_1
XFILLER_34_670 VPWR VGND sg13g2_decap_8
X_5867_ _2758_ _2821_ _2822_ VPWR VGND sg13g2_nor2_1
X_4818_ _1758_ _1804_ _1825_ VPWR VGND sg13g2_nor2_1
X_5798_ _2753_ VPWR _2758_ VGND net614 _2757_ sg13g2_o21ai_1
X_4749_ _0727_ _1037_ _1755_ _1756_ VPWR VGND sg13g2_or3_1
Xoutput14 net14 uo_out[1] VPWR VGND sg13g2_buf_1
X_6419_ net75 VGND VPWR _0474_ videogen.test_lut_thingy.pixel_feeder_inst.row\[33\]\[1\]
+ _0070_ sg13g2_dfrbpq_1
XFILLER_0_224 VPWR VGND sg13g2_decap_8
XFILLER_17_604 VPWR VGND sg13g2_fill_2
XFILLER_29_453 VPWR VGND sg13g2_fill_2
XFILLER_45_946 VPWR VGND sg13g2_decap_8
XFILLER_44_423 VPWR VGND sg13g2_fill_1
XFILLER_16_103 VPWR VGND sg13g2_decap_4
XFILLER_16_114 VPWR VGND sg13g2_decap_4
XFILLER_17_637 VPWR VGND sg13g2_decap_4
XFILLER_13_887 VPWR VGND sg13g2_decap_4
XFILLER_8_368 VPWR VGND sg13g2_fill_1
XFILLER_36_924 VPWR VGND sg13g2_decap_8
X_3982_ net680 _1022_ videogen.another_shader.time_cnt\[17\] _1029_ VPWR VGND sg13g2_nand3_1
X_5721_ VGND VPWR _2683_ _2684_ _0549_ net844 sg13g2_a21oi_1
X_6244__367 VPWR VGND net367 sg13g2_tiehi
XFILLER_31_651 VPWR VGND sg13g2_decap_4
X_5652_ VGND VPWR net667 _2622_ _0462_ net844 sg13g2_a21oi_1
XFILLER_31_684 VPWR VGND sg13g2_decap_4
X_4603_ _1610_ net652 videogen.test_lut_thingy.pixel_feeder_inst.row\[0\]\[0\] VPWR
+ VGND sg13g2_nand2b_1
X_5583_ _2497_ _2444_ _2562_ VPWR VGND sg13g2_xor2_1
X_4534_ _1539_ VPWR _1541_ VGND net694 _1540_ sg13g2_o21ai_1
XFILLER_11_1015 VPWR VGND sg13g2_decap_8
X_4465_ net698 _1466_ _1471_ _1472_ VPWR VGND sg13g2_nor3_1
X_6204_ net427 VGND VPWR net811 clockdiv.q2temp net488 sg13g2_dfrbpq_1
Xfanout804 net805 net804 VPWR VGND sg13g2_buf_8
X_4396_ videogen.test_lut_thingy.pixel_feeder_inst.row\[33\]\[2\] net628 _1403_ VPWR
+ VGND sg13g2_nor2_1
Xfanout815 net820 net815 VPWR VGND sg13g2_buf_8
X_3416_ videogen.test_lut_thingy.pixel_feeder_inst.row\[35\]\[2\] net867 _0798_ _0675_
+ VPWR VGND sg13g2_mux2_1
Xfanout837 net839 net837 VPWR VGND sg13g2_buf_1
Xfanout826 net828 net826 VPWR VGND sg13g2_buf_8
X_6135_ net781 net824 _0195_ VPWR VGND sg13g2_nor2_1
X_3347_ VPWR _0740_ videogen.test_lut_thingy.gol_counter_reg\[0\] VGND sg13g2_inv_1
Xfanout848 _0720_ net848 VPWR VGND sg13g2_buf_8
Xfanout859 ui_in[7] net859 VPWR VGND sg13g2_buf_8
X_6066_ net769 net812 _0127_ VPWR VGND sg13g2_nor2_1
X_5017_ VGND VPWR _2015_ _2017_ _2024_ _2012_ sg13g2_a21oi_1
XFILLER_38_250 VPWR VGND sg13g2_decap_8
XFILLER_42_938 VPWR VGND sg13g2_decap_8
XFILLER_41_437 VPWR VGND sg13g2_fill_2
XFILLER_41_459 VPWR VGND sg13g2_decap_4
X_5919_ VPWR _0697_ _2851_ VGND sg13g2_inv_1
XFILLER_42_57 VPWR VGND sg13g2_decap_8
X_6557__477 VPWR VGND net477 sg13g2_tiehi
XFILLER_5_327 VPWR VGND sg13g2_decap_8
XFILLER_5_305 VPWR VGND sg13g2_decap_4
X_6453__464 VPWR VGND net464 sg13g2_tiehi
XFILLER_1_566 VPWR VGND sg13g2_decap_8
XFILLER_45_721 VPWR VGND sg13g2_decap_8
XFILLER_16_80 VPWR VGND sg13g2_fill_1
XFILLER_13_640 VPWR VGND sg13g2_decap_8
XFILLER_8_121 VPWR VGND sg13g2_fill_2
XFILLER_12_194 VPWR VGND sg13g2_decap_8
X_4250_ _1160_ _1178_ _1257_ VPWR VGND sg13g2_nor2_1
X_4181_ _1188_ _1172_ _1187_ VPWR VGND sg13g2_xnor2_1
XFILLER_41_1008 VPWR VGND sg13g2_decap_8
XFILLER_48_570 VPWR VGND sg13g2_fill_1
XFILLER_35_231 VPWR VGND sg13g2_decap_4
XFILLER_23_437 VPWR VGND sg13g2_fill_1
X_3965_ _1011_ _1015_ _1016_ VPWR VGND sg13g2_nor2_1
X_5704_ VGND VPWR _2649_ _2655_ _2669_ _2654_ sg13g2_a21oi_1
X_3896_ net697 _0970_ _0972_ VPWR VGND sg13g2_nor2_1
X_5635_ net632 VPWR _2612_ VGND green\[0\] _2610_ sg13g2_o21ai_1
X_5566_ _2548_ tmds_red.dc_balancing_reg\[4\] _2549_ VPWR VGND sg13g2_xor2_1
X_5497_ _2483_ _2479_ _2480_ VPWR VGND sg13g2_xnor2_1
X_4517_ videogen.test_lut_thingy.pixel_feeder_inst.row\[32\]\[3\] net649 _1524_ VPWR
+ VGND sg13g2_nor2_1
X_3363__1 VPWR net488 clknet_1_0__leaf_clk VGND sg13g2_inv_1
X_4448_ videogen.test_lut_thingy.pixel_feeder_inst.row\[8\]\[1\] net645 _1455_ VPWR
+ VGND sg13g2_nor2_1
Xfanout612 _2608_ net612 VPWR VGND sg13g2_buf_2
X_6540__97 VPWR VGND net97 sg13g2_tiehi
Xfanout623 net624 net623 VPWR VGND sg13g2_buf_8
Xfanout667 net669 net667 VPWR VGND sg13g2_buf_8
Xfanout645 net647 net645 VPWR VGND sg13g2_buf_8
Xfanout634 net636 net634 VPWR VGND sg13g2_buf_8
X_4379_ _1386_ net683 _1385_ VPWR VGND sg13g2_nand2b_1
Xfanout656 net657 net656 VPWR VGND sg13g2_buf_1
Xfanout689 net690 net689 VPWR VGND sg13g2_buf_8
Xfanout678 videogen.another_shader.video_y\[0\] net678 VPWR VGND sg13g2_buf_8
X_6118_ net766 net808 _0178_ VPWR VGND sg13g2_nor2_1
X_6049_ net762 net804 _0110_ VPWR VGND sg13g2_nor2_1
XFILLER_27_710 VPWR VGND sg13g2_fill_1
XFILLER_37_57 VPWR VGND sg13g2_fill_2
X_6610__46 VPWR VGND net46 sg13g2_tiehi
XFILLER_41_245 VPWR VGND sg13g2_decap_4
X_6518__225 VPWR VGND net225 sg13g2_tiehi
XFILLER_5_135 VPWR VGND sg13g2_fill_2
XFILLER_2_864 VPWR VGND sg13g2_decap_4
XFILLER_1_330 VPWR VGND sg13g2_decap_8
XFILLER_49_312 VPWR VGND sg13g2_decap_8
XFILLER_49_389 VPWR VGND sg13g2_decap_8
XFILLER_45_573 VPWR VGND sg13g2_decap_4
XFILLER_45_562 VPWR VGND sg13g2_decap_8
XFILLER_18_765 VPWR VGND sg13g2_decap_4
XFILLER_33_724 VPWR VGND sg13g2_decap_8
X_6206__424 VPWR VGND net424 sg13g2_tiehi
X_3750_ _0882_ _0884_ videogen.test_lut_thingy.pixel_feeder_inst.h_counter\[3\] _0886_
+ VPWR VGND _0885_ sg13g2_nand4_1
XFILLER_32_267 VPWR VGND sg13g2_fill_2
X_6378__137 VPWR VGND net137 sg13g2_tiehi
X_3681_ videogen.test_lut_thingy.pixel_feeder_inst.row\[11\]\[2\] net860 _0867_ _0450_
+ VPWR VGND sg13g2_mux2_1
X_5420_ _2413_ _2399_ _2410_ VPWR VGND sg13g2_nand2_1
X_5351_ _2344_ _2275_ _2343_ VPWR VGND sg13g2_xnor2_1
X_5282_ _1228_ _2274_ _2275_ VPWR VGND sg13g2_nor2b_2
X_4302_ _1302_ _1308_ _1309_ VPWR VGND sg13g2_nor2_1
X_4233_ _1231_ _1233_ _1240_ VPWR VGND sg13g2_nor2_1
X_4164_ _1171_ videogen.another_shader.video_y\[8\] videogen.fancy_shader.shader_counter_reg\[8\]
+ VPWR VGND sg13g2_xnor2_1
X_4095_ _0928_ _1092_ net894 _1108_ VPWR VGND _1107_ sg13g2_nand4_1
XFILLER_49_890 VPWR VGND sg13g2_decap_8
X_4997_ _1991_ VPWR _2004_ VGND _1999_ _2003_ sg13g2_o21ai_1
XFILLER_17_1021 VPWR VGND sg13g2_decap_8
X_3948_ net846 _1003_ _1004_ _0351_ VPWR VGND sg13g2_nor3_1
X_3879_ videogen.test_lut_thingy.pixel_feeder_inst.v_pix\[3\] _0958_ _0960_ VPWR VGND
+ sg13g2_and2_1
X_5618_ _2595_ green\[1\] green\[7\] VPWR VGND sg13g2_xnor2_1
X_6598_ net107 VGND VPWR _0653_ videogen.test_lut_thingy.pixel_feeder_inst.row\[49\]\[3\]
+ _0240_ sg13g2_dfrbpq_1
X_5549_ _2531_ _2524_ _2533_ VPWR VGND sg13g2_xor2_1
XFILLER_46_326 VPWR VGND sg13g2_decap_4
XFILLER_46_359 VPWR VGND sg13g2_fill_2
XFILLER_27_562 VPWR VGND sg13g2_decap_8
XFILLER_14_223 VPWR VGND sg13g2_fill_1
XFILLER_30_716 VPWR VGND sg13g2_fill_1
XFILLER_30_749 VPWR VGND sg13g2_fill_2
XFILLER_7_967 VPWR VGND sg13g2_decap_8
XFILLER_1_160 VPWR VGND sg13g2_fill_1
XFILLER_36_7 VPWR VGND sg13g2_decap_8
XFILLER_49_142 VPWR VGND sg13g2_decap_8
XFILLER_49_197 VPWR VGND sg13g2_decap_8
X_4920_ _1922_ _1926_ _1927_ VPWR VGND sg13g2_and2_1
X_4851_ _1830_ _1844_ _1858_ VPWR VGND _1856_ sg13g2_nand3b_1
XFILLER_33_532 VPWR VGND sg13g2_fill_2
X_3802_ VGND VPWR videogen.test_lut_thingy.pixel_feeder_inst.v_pix\[5\] _0919_ _0923_
+ _0922_ sg13g2_a21oi_1
XFILLER_21_738 VPWR VGND sg13g2_fill_1
X_4782_ _1785_ _1779_ _1789_ VPWR VGND sg13g2_xor2_1
X_6521_ net213 VGND VPWR _0576_ videogen.test_lut_thingy.pixel_feeder_inst.row\[25\]\[2\]
+ _0163_ sg13g2_dfrbpq_1
X_3733_ videogen.test_lut_thingy.pixel_feeder_inst.row\[1\]\[0\] net881 _0877_ _0288_
+ VPWR VGND sg13g2_mux2_1
XFILLER_9_271 VPWR VGND sg13g2_decap_8
X_3664_ _0797_ _0828_ _0864_ VPWR VGND sg13g2_nor2_2
X_6452_ net466 VGND VPWR _0507_ videogen.test_lut_thingy.pixel_feeder_inst.row\[61\]\[2\]
+ _0103_ sg13g2_dfrbpq_1
X_5403_ VPWR _2396_ _2395_ VGND sg13g2_inv_1
X_3595_ net885 videogen.test_lut_thingy.pixel_feeder_inst.row\[57\]\[0\] _0847_ _0525_
+ VPWR VGND sg13g2_mux2_1
X_6383_ net130 VGND VPWR _0442_ videogen.test_lut_thingy.pixel_feeder_inst.row\[16\]\[2\]
+ _0047_ sg13g2_dfrbpq_1
XFILLER_47_1014 VPWR VGND sg13g2_decap_8
XFILLER_0_609 VPWR VGND sg13g2_decap_8
X_5334_ _2326_ VPWR _2327_ VGND _2320_ _2325_ sg13g2_o21ai_1
X_5265_ _1256_ _2261_ _2263_ _2264_ VPWR VGND sg13g2_or3_1
X_5196_ _2195_ _1151_ _1187_ _2191_ VPWR VGND sg13g2_and3_2
X_4216_ _1219_ _1222_ _1223_ VPWR VGND sg13g2_nor2b_2
X_4147_ _1154_ net673 videogen.fancy_shader.shader_counter_reg\[4\] VPWR VGND sg13g2_xnor2_1
XFILLER_28_315 VPWR VGND sg13g2_decap_4
X_4078_ _0719_ _0906_ _0929_ _1096_ VPWR VGND sg13g2_nor3_1
XFILLER_11_215 VPWR VGND sg13g2_fill_2
Xclkload2 VPWR clkload2/Y clknet_3_3__leaf_clk_regs VGND sg13g2_inv_1
XFILLER_4_926 VPWR VGND sg13g2_decap_8
XFILLER_47_668 VPWR VGND sg13g2_fill_1
XFILLER_35_819 VPWR VGND sg13g2_fill_1
XFILLER_43_863 VPWR VGND sg13g2_decap_8
XFILLER_24_80 VPWR VGND sg13g2_fill_2
XFILLER_30_579 VPWR VGND sg13g2_decap_4
XFILLER_10_270 VPWR VGND sg13g2_fill_1
X_3380_ _0772_ net666 _0770_ VPWR VGND sg13g2_nand2_1
X_5050_ _1713_ _2043_ _2048_ _2057_ VPWR VGND sg13g2_nor3_1
X_4001_ net847 _1040_ _1042_ _0366_ VPWR VGND sg13g2_nor3_1
XFILLER_37_101 VPWR VGND sg13g2_fill_2
XFILLER_37_134 VPWR VGND sg13g2_fill_1
XFILLER_1_84 VPWR VGND sg13g2_decap_8
X_5952_ net757 net803 _0013_ VPWR VGND sg13g2_nor2_1
X_4903_ _1901_ _1907_ _1745_ _1910_ VPWR VGND sg13g2_nand3_1
XFILLER_34_852 VPWR VGND sg13g2_decap_8
X_5883_ VGND VPWR net668 _2832_ _0660_ _2824_ sg13g2_a21oi_1
XFILLER_34_885 VPWR VGND sg13g2_decap_8
X_4834_ VGND VPWR _1822_ _1827_ _1841_ _1840_ sg13g2_a21oi_1
XFILLER_21_535 VPWR VGND sg13g2_decap_8
X_4765_ _1772_ _1768_ _1771_ VPWR VGND sg13g2_nand2_1
XFILLER_21_557 VPWR VGND sg13g2_fill_2
X_6504_ net285 VGND VPWR _0559_ videogen.test_lut_thingy.pixel_feeder_inst.row\[2\]\[1\]
+ _0146_ sg13g2_dfrbpq_1
X_3716_ videogen.test_lut_thingy.pixel_feeder_inst.row\[29\]\[2\] net867 _0874_ _0309_
+ VPWR VGND sg13g2_mux2_1
X_4696_ _1701_ _1702_ _1703_ VPWR VGND sg13g2_and2_1
XFILLER_20_16 VPWR VGND sg13g2_fill_2
X_3647_ _0860_ net889 _0858_ VPWR VGND sg13g2_nand2_1
X_6435_ net43 VGND VPWR _0490_ videogen.test_lut_thingy.pixel_feeder_inst.row\[30\]\[1\]
+ _0086_ sg13g2_dfrbpq_1
XFILLER_20_27 VPWR VGND sg13g2_fill_1
XFILLER_20_38 VPWR VGND sg13g2_decap_4
X_6366_ net153 VGND VPWR _0425_ tmds_red.dc_balancing_reg\[3\] net727 sg13g2_dfrbpq_2
XFILLER_1_907 VPWR VGND sg13g2_decap_8
X_3578_ videogen.test_lut_thingy.pixel_feeder_inst.row\[52\]\[2\] net861 _0844_ _0539_
+ VPWR VGND sg13g2_mux2_1
XFILLER_0_406 VPWR VGND sg13g2_decap_8
X_5317_ _2310_ _2305_ _2309_ VPWR VGND sg13g2_nand2_1
X_6297_ net266 VGND VPWR _0356_ videogen.another_shader.time_cnt\[12\] net732 sg13g2_dfrbpq_2
Xhold14 serialize.shift_reg_g\[4\] VPWR VGND net502 sg13g2_dlygate4sd3_1
X_5248_ _2247_ _1237_ _2246_ VPWR VGND sg13g2_xnor2_1
Xhold36 serialize.shift_reg_c\[8\] VPWR VGND net524 sg13g2_dlygate4sd3_1
Xhold25 serialize.shift_reg_b\[7\] VPWR VGND net513 sg13g2_dlygate4sd3_1
XFILLER_29_47 VPWR VGND sg13g2_decap_8
XFILLER_29_69 VPWR VGND sg13g2_fill_2
X_5179_ _1413_ _2178_ _2179_ VPWR VGND sg13g2_nor2_1
XFILLER_25_830 VPWR VGND sg13g2_fill_2
X_6404__96 VPWR VGND net96 sg13g2_tiehi
XFILLER_40_866 VPWR VGND sg13g2_decap_8
XFILLER_12_579 VPWR VGND sg13g2_decap_4
XFILLER_0_984 VPWR VGND sg13g2_decap_8
XFILLER_48_944 VPWR VGND sg13g2_decap_8
XFILLER_47_432 VPWR VGND sg13g2_decap_8
XFILLER_47_421 VPWR VGND sg13g2_decap_8
X_6463__444 VPWR VGND net444 sg13g2_tiehi
XFILLER_37_1002 VPWR VGND sg13g2_decap_8
XFILLER_16_863 VPWR VGND sg13g2_fill_1
XFILLER_43_682 VPWR VGND sg13g2_fill_2
XFILLER_15_395 VPWR VGND sg13g2_fill_2
X_4550_ _1514_ VPWR _1557_ VGND videogen.test_lut_thingy.pixel_feeder_inst.row\[53\]\[3\]
+ net625 sg13g2_o21ai_1
X_6533__125 VPWR VGND net125 sg13g2_tiehi
X_4481_ _1484_ _1485_ _1486_ _1487_ _1488_ VPWR VGND sg13g2_nor4_1
X_3501_ _0821_ _0828_ _0829_ VPWR VGND sg13g2_nor2_2
X_3432_ videogen.test_lut_thingy.pixel_feeder_inst.row\[24\]\[0\] net884 _0804_ _0665_
+ VPWR VGND sg13g2_mux2_1
X_6220_ net407 VGND VPWR _0279_ serialize.shift_reg_r\[9\] clknet_3_4__leaf_clk_regs
+ sg13g2_dfrbpq_1
X_6151_ net786 net829 _0211_ VPWR VGND sg13g2_nor2_1
XFILLER_44_1028 VPWR VGND sg13g2_fill_1
XFILLER_44_1017 VPWR VGND sg13g2_decap_8
X_5102_ _2074_ VPWR _2109_ VGND _2085_ _2107_ sg13g2_o21ai_1
XFILLER_39_900 VPWR VGND sg13g2_decap_8
X_6082_ net773 net816 _0143_ VPWR VGND sg13g2_nor2_1
X_5033_ _2035_ VPWR _2040_ VGND _2031_ _2038_ sg13g2_o21ai_1
XFILLER_39_977 VPWR VGND sg13g2_decap_8
XFILLER_38_432 VPWR VGND sg13g2_decap_8
X_5935_ VPWR _0705_ _2859_ VGND sg13g2_inv_1
XFILLER_25_159 VPWR VGND sg13g2_fill_1
X_5866_ _2687_ _2754_ _2821_ VPWR VGND sg13g2_nor2_1
X_4817_ _1820_ _1823_ _1824_ VPWR VGND sg13g2_nor2b_2
X_6260__340 VPWR VGND net340 sg13g2_tiehi
XFILLER_21_354 VPWR VGND sg13g2_decap_4
X_5797_ _2757_ _2756_ VPWR VGND sg13g2_inv_2
X_4748_ videogen.another_shader.time_cnt\[22\] videogen.another_shader.time_cnt\[16\]
+ videogen.another_shader.time_cnt\[23\] _1755_ VPWR VGND sg13g2_nand3_1
X_4679_ _1678_ _1682_ _1686_ VPWR VGND sg13g2_nor2b_1
Xoutput15 net15 uo_out[2] VPWR VGND sg13g2_buf_1
X_6418_ net77 VGND VPWR _0473_ videogen.test_lut_thingy.pixel_feeder_inst.row\[33\]\[0\]
+ _0069_ sg13g2_dfrbpq_1
X_6349_ net170 VGND VPWR _0408_ blue\[6\] net741 sg13g2_dfrbpq_1
XFILLER_5_1022 VPWR VGND sg13g2_decap_8
XFILLER_45_925 VPWR VGND sg13g2_decap_8
XFILLER_13_800 VPWR VGND sg13g2_fill_1
XFILLER_31_107 VPWR VGND sg13g2_fill_2
XFILLER_32_619 VPWR VGND sg13g2_decap_4
XFILLER_24_170 VPWR VGND sg13g2_decap_4
XFILLER_13_899 VPWR VGND sg13g2_fill_1
XFILLER_8_347 VPWR VGND sg13g2_decap_8
XFILLER_4_564 VPWR VGND sg13g2_decap_4
X_6313__230 VPWR VGND net230 sg13g2_tiehi
XFILLER_0_781 VPWR VGND sg13g2_decap_8
XFILLER_11_6 VPWR VGND sg13g2_fill_1
XFILLER_35_435 VPWR VGND sg13g2_decap_4
X_3981_ _0727_ _0728_ _1024_ _1028_ VPWR VGND sg13g2_nor3_1
XFILLER_15_170 VPWR VGND sg13g2_fill_1
XFILLER_16_682 VPWR VGND sg13g2_decap_8
X_5720_ VGND VPWR _2591_ net613 _2684_ _0745_ sg13g2_a21oi_1
X_5651_ _2622_ _2445_ _2519_ VPWR VGND sg13g2_xnor2_1
X_5582_ VGND VPWR _2460_ _2559_ _0429_ _2561_ sg13g2_a21oi_1
X_4602_ videogen.test_lut_thingy.pixel_feeder_inst.row\[3\]\[0\] net654 _1609_ VPWR
+ VGND sg13g2_nor2_1
X_4533_ net702 videogen.test_lut_thingy.pixel_feeder_inst.row\[20\]\[3\] videogen.test_lut_thingy.pixel_feeder_inst.row\[22\]\[3\]
+ videogen.test_lut_thingy.pixel_feeder_inst.row\[21\]\[3\] videogen.test_lut_thingy.pixel_feeder_inst.row\[23\]\[3\]
+ net706 _1540_ VPWR VGND sg13g2_mux4_1
X_6552__40 VPWR VGND net40 sg13g2_tiehi
XFILLER_7_94 VPWR VGND sg13g2_decap_4
X_6203_ net428 VGND VPWR _0263_ clockdiv.q2 clknet_3_2__leaf_clk_regs sg13g2_dfrbpq_1
X_4464_ _1467_ _1468_ _1469_ _1470_ _1471_ VPWR VGND sg13g2_nor4_1
Xfanout805 net807 net805 VPWR VGND sg13g2_buf_8
X_3415_ videogen.test_lut_thingy.pixel_feeder_inst.row\[35\]\[3\] net856 _0798_ _0676_
+ VPWR VGND sg13g2_mux2_1
Xfanout816 net820 net816 VPWR VGND sg13g2_buf_1
X_4395_ _1398_ _1399_ _1400_ _1401_ _1402_ VPWR VGND sg13g2_nor4_1
Xfanout838 net839 net838 VPWR VGND sg13g2_buf_8
X_3346_ VPWR _0739_ net701 VGND sg13g2_inv_1
X_6134_ net781 net824 _0194_ VPWR VGND sg13g2_nor2_1
Xfanout849 net859 net849 VPWR VGND sg13g2_buf_8
Xfanout827 net828 net827 VPWR VGND sg13g2_buf_8
X_6065_ net766 net808 _0126_ VPWR VGND sg13g2_nor2_1
XFILLER_39_752 VPWR VGND sg13g2_fill_2
XFILLER_27_903 VPWR VGND sg13g2_fill_1
X_5016_ _2021_ _2022_ _2023_ VPWR VGND sg13g2_and2_1
X_6288__284 VPWR VGND net284 sg13g2_tiehi
XFILLER_26_424 VPWR VGND sg13g2_fill_1
XFILLER_38_284 VPWR VGND sg13g2_fill_2
XFILLER_42_917 VPWR VGND sg13g2_decap_8
XFILLER_26_479 VPWR VGND sg13g2_fill_1
XFILLER_13_118 VPWR VGND sg13g2_fill_1
X_5918_ _2851_ net746 net510 net753 green_tmds_par\[4\] VPWR VGND sg13g2_a22oi_1
XFILLER_22_641 VPWR VGND sg13g2_decap_8
X_5849_ _2806_ tmds_blue.dc_balancing_reg\[4\] _2805_ VPWR VGND sg13g2_xnor2_1
XFILLER_10_847 VPWR VGND sg13g2_decap_4
XFILLER_5_339 VPWR VGND sg13g2_decap_4
XFILLER_27_1012 VPWR VGND sg13g2_decap_8
XFILLER_1_545 VPWR VGND sg13g2_decap_8
X_6564__449 VPWR VGND net449 sg13g2_tiehi
XFILLER_45_700 VPWR VGND sg13g2_decap_8
XFILLER_18_947 VPWR VGND sg13g2_fill_2
XFILLER_45_799 VPWR VGND sg13g2_decap_8
XFILLER_44_276 VPWR VGND sg13g2_decap_8
XFILLER_26_991 VPWR VGND sg13g2_fill_1
XFILLER_32_416 VPWR VGND sg13g2_decap_4
XFILLER_9_601 VPWR VGND sg13g2_decap_4
XFILLER_41_994 VPWR VGND sg13g2_decap_8
XFILLER_40_482 VPWR VGND sg13g2_fill_1
XFILLER_8_144 VPWR VGND sg13g2_decap_8
X_4180_ videogen.fancy_shader.shader_counter_reg\[7\] videogen.another_shader.video_y\[7\]
+ _1187_ VPWR VGND sg13g2_xor2_1
XFILLER_36_711 VPWR VGND sg13g2_decap_8
XFILLER_35_276 VPWR VGND sg13g2_fill_1
X_3964_ _1015_ videogen.another_shader.time_cnt\[13\] videogen.another_shader.time_cnt\[12\]
+ VPWR VGND sg13g2_nand2_1
X_3895_ net664 net658 _0966_ _0971_ VPWR VGND sg13g2_nor3_2
X_5703_ net642 _2668_ _0467_ VPWR VGND sg13g2_nor2_1
X_5634_ VPWR _2611_ _2610_ VGND sg13g2_inv_1
X_5565_ VGND VPWR _0752_ _2526_ _2548_ _2547_ sg13g2_a21oi_1
X_5496_ _2482_ _2474_ _2478_ _2481_ VPWR VGND sg13g2_and3_2
X_4516_ videogen.test_lut_thingy.pixel_feeder_inst.row\[34\]\[3\] net639 _1523_ VPWR
+ VGND sg13g2_nor2_1
X_4447_ videogen.test_lut_thingy.pixel_feeder_inst.row\[10\]\[1\] net633 _1454_ VPWR
+ VGND sg13g2_nor2_1
Xfanout613 _2608_ net613 VPWR VGND sg13g2_buf_2
Xfanout624 net625 net624 VPWR VGND sg13g2_buf_8
Xfanout657 _0774_ net657 VPWR VGND sg13g2_buf_8
Xfanout635 net636 net635 VPWR VGND sg13g2_buf_8
X_4378_ net665 _1379_ _1384_ _1385_ VPWR VGND sg13g2_nor3_1
X_6117_ net766 net808 _0177_ VPWR VGND sg13g2_nor2_1
Xfanout646 net647 net646 VPWR VGND sg13g2_buf_8
X_3329_ _0722_ videogen.another_shader.time_cnt\[30\] VPWR VGND sg13g2_inv_2
Xfanout679 videogen.fancy_shader.shader_counter_reg\[5\] net679 VPWR VGND sg13g2_buf_8
Xfanout668 net669 net668 VPWR VGND sg13g2_buf_8
X_6048_ net762 net807 _0109_ VPWR VGND sg13g2_nor2_1
XFILLER_2_1014 VPWR VGND sg13g2_decap_8
XFILLER_42_758 VPWR VGND sg13g2_decap_8
X_6227__396 VPWR VGND net396 sg13g2_tiehi
XFILLER_22_482 VPWR VGND sg13g2_fill_1
XFILLER_2_843 VPWR VGND sg13g2_decap_8
XFILLER_1_386 VPWR VGND sg13g2_decap_8
XFILLER_49_368 VPWR VGND sg13g2_decap_8
XFILLER_37_519 VPWR VGND sg13g2_decap_8
XFILLER_18_733 VPWR VGND sg13g2_fill_1
XFILLER_27_80 VPWR VGND sg13g2_decap_4
XFILLER_9_486 VPWR VGND sg13g2_fill_2
X_3680_ videogen.test_lut_thingy.pixel_feeder_inst.row\[11\]\[3\] net849 _0867_ _0451_
+ VPWR VGND sg13g2_mux2_1
X_5350_ _1230_ _1238_ _2343_ VPWR VGND sg13g2_nor2b_1
X_5281_ _1118_ _1248_ _2274_ VPWR VGND sg13g2_nor2_2
X_4301_ _1308_ _1231_ _1295_ VPWR VGND sg13g2_xnor2_1
X_4232_ _1239_ _1237_ _1238_ VPWR VGND sg13g2_xnor2_1
X_4163_ _1170_ videogen.another_shader.video_y\[8\] videogen.fancy_shader.shader_counter_reg\[8\]
+ VPWR VGND sg13g2_nand2_1
X_4094_ _1107_ videogen.another_shader.video_y\[9\] _1105_ VPWR VGND sg13g2_xnor2_1
XFILLER_36_530 VPWR VGND sg13g2_fill_1
XFILLER_23_213 VPWR VGND sg13g2_decap_8
XFILLER_24_725 VPWR VGND sg13g2_decap_8
X_4996_ VPWR _2003_ _2002_ VGND sg13g2_inv_1
X_3947_ _1004_ videogen.another_shader.time_cnt\[7\] videogen.another_shader.time_cnt\[6\]
+ _1001_ VPWR VGND sg13g2_and3_2
X_3878_ _0958_ _0959_ _0318_ VPWR VGND sg13g2_nor2_1
X_5617_ _2592_ _2590_ _2594_ VPWR VGND sg13g2_xor2_1
X_6597_ net115 VGND VPWR _0652_ videogen.test_lut_thingy.pixel_feeder_inst.row\[49\]\[2\]
+ _0239_ sg13g2_dfrbpq_1
X_5548_ VPWR _2532_ _2531_ VGND sg13g2_inv_1
XFILLER_3_8 VPWR VGND sg13g2_fill_1
X_5479_ _2465_ _2462_ _2463_ VPWR VGND sg13g2_nand2_1
XFILLER_48_35 VPWR VGND sg13g2_decap_8
XFILLER_47_839 VPWR VGND sg13g2_decap_8
X_6628__243 VPWR VGND net243 sg13g2_tiehi
XFILLER_42_522 VPWR VGND sg13g2_fill_1
XFILLER_15_725 VPWR VGND sg13g2_fill_1
XFILLER_42_555 VPWR VGND sg13g2_fill_2
XFILLER_42_566 VPWR VGND sg13g2_fill_2
XFILLER_23_780 VPWR VGND sg13g2_decap_4
XFILLER_10_485 VPWR VGND sg13g2_decap_8
XFILLER_13_71 VPWR VGND sg13g2_fill_1
XFILLER_2_684 VPWR VGND sg13g2_decap_8
XFILLER_49_121 VPWR VGND sg13g2_decap_8
XFILLER_37_338 VPWR VGND sg13g2_decap_4
XFILLER_18_541 VPWR VGND sg13g2_decap_4
XFILLER_46_883 VPWR VGND sg13g2_decap_8
X_4850_ _1845_ _1855_ _1831_ _1857_ VPWR VGND sg13g2_nand3_1
X_3801_ _0909_ VPWR _0922_ VGND videogen.test_lut_thingy.pixel_feeder_inst.v_pix\[5\]
+ _0919_ sg13g2_o21ai_1
X_4781_ _1786_ _1787_ _1788_ VPWR VGND sg13g2_and2_1
X_6520_ net217 VGND VPWR _0575_ videogen.test_lut_thingy.pixel_feeder_inst.row\[25\]\[1\]
+ _0162_ sg13g2_dfrbpq_1
XFILLER_20_216 VPWR VGND sg13g2_fill_1
X_3732_ videogen.test_lut_thingy.pixel_feeder_inst.row\[1\]\[1\] net870 _0877_ _0289_
+ VPWR VGND sg13g2_mux2_1
X_6451_ net468 VGND VPWR _0506_ videogen.test_lut_thingy.pixel_feeder_inst.row\[61\]\[1\]
+ _0102_ sg13g2_dfrbpq_1
X_3663_ videogen.test_lut_thingy.pixel_feeder_inst.row\[33\]\[0\] net889 _0863_ _0473_
+ VPWR VGND sg13g2_mux2_1
X_6382_ net132 VGND VPWR _0441_ videogen.test_lut_thingy.pixel_feeder_inst.row\[16\]\[1\]
+ _0046_ sg13g2_dfrbpq_1
X_5402_ _2395_ _2393_ _2394_ VPWR VGND sg13g2_xnor2_1
X_5333_ _2320_ VPWR _2326_ VGND _2322_ _2325_ sg13g2_o21ai_1
X_3594_ net872 videogen.test_lut_thingy.pixel_feeder_inst.row\[57\]\[1\] _0847_ _0526_
+ VPWR VGND sg13g2_mux2_1
X_5264_ VGND VPWR _2251_ _2262_ _2263_ _2252_ sg13g2_a21oi_1
X_5195_ VPWR _2194_ _2193_ VGND sg13g2_inv_1
X_4215_ _1222_ _1211_ _1214_ VPWR VGND sg13g2_nand2_1
X_4146_ net672 videogen.fancy_shader.shader_counter_reg\[5\] _1153_ VPWR VGND sg13g2_nor2_1
XFILLER_18_49 VPWR VGND sg13g2_fill_2
XFILLER_28_327 VPWR VGND sg13g2_fill_2
X_6508__269 VPWR VGND net269 sg13g2_tiehi
X_4077_ VGND VPWR net674 _1093_ _0389_ _1095_ sg13g2_a21oi_1
X_4979_ _1981_ _1983_ _1984_ _1986_ VPWR VGND sg13g2_or3_1
Xclkload3 VPWR clkload3/Y clknet_3_5__leaf_clk_regs VGND sg13g2_inv_1
X_6478__379 VPWR VGND net379 sg13g2_tiehi
X_6649_ net389 VGND VPWR _0704_ serialize.shift_reg_r\[3\] clknet_3_7__leaf_clk_regs
+ sg13g2_dfrbpq_1
X_6270__320 VPWR VGND net320 sg13g2_tiehi
XFILLER_8_1020 VPWR VGND sg13g2_decap_8
XFILLER_47_625 VPWR VGND sg13g2_fill_1
XFILLER_19_316 VPWR VGND sg13g2_decap_4
XFILLER_43_842 VPWR VGND sg13g2_decap_8
XFILLER_30_503 VPWR VGND sg13g2_fill_1
X_6203__428 VPWR VGND net428 sg13g2_tiehi
XFILLER_11_794 VPWR VGND sg13g2_decap_8
XFILLER_6_242 VPWR VGND sg13g2_fill_1
XFILLER_6_220 VPWR VGND sg13g2_fill_2
X_4000_ VPWR _1042_ _1041_ VGND sg13g2_inv_1
XFILLER_27_4 VPWR VGND sg13g2_fill_1
XFILLER_38_647 VPWR VGND sg13g2_fill_1
XFILLER_1_63 VPWR VGND sg13g2_decap_8
X_5951_ net789 net832 _0012_ VPWR VGND sg13g2_nor2_1
XFILLER_19_872 VPWR VGND sg13g2_decap_8
X_4902_ _1909_ _1745_ _1901_ _1907_ VPWR VGND sg13g2_and3_1
X_6413__86 VPWR VGND net86 sg13g2_tiehi
X_6323__210 VPWR VGND net210 sg13g2_tiehi
X_5882_ _2818_ _2695_ _2832_ VPWR VGND sg13g2_xor2_1
X_4833_ VGND VPWR _1819_ _1827_ _1840_ _1822_ sg13g2_a21oi_1
X_4764_ _0723_ VPWR _1771_ VGND _0724_ _1764_ sg13g2_o21ai_1
X_6503_ net289 VGND VPWR _0558_ videogen.test_lut_thingy.pixel_feeder_inst.row\[2\]\[0\]
+ _0145_ sg13g2_dfrbpq_1
XFILLER_14_1025 VPWR VGND sg13g2_decap_4
X_3715_ videogen.test_lut_thingy.pixel_feeder_inst.row\[29\]\[3\] net858 _0874_ _0310_
+ VPWR VGND sg13g2_mux2_1
X_6434_ net45 VGND VPWR _0489_ videogen.test_lut_thingy.pixel_feeder_inst.row\[30\]\[0\]
+ _0085_ sg13g2_dfrbpq_1
X_4695_ _1692_ _1689_ _1700_ _1702_ VPWR VGND sg13g2_a21o_1
X_3646_ videogen.test_lut_thingy.pixel_feeder_inst.row\[31\]\[1\] net878 _0858_ _0486_
+ VPWR VGND sg13g2_mux2_1
X_6365_ net154 VGND VPWR _0424_ tmds_red.dc_balancing_reg\[2\] net727 sg13g2_dfrbpq_2
X_3577_ videogen.test_lut_thingy.pixel_feeder_inst.row\[52\]\[3\] net850 _0844_ _0540_
+ VPWR VGND sg13g2_mux2_1
X_6296_ net268 VGND VPWR _0355_ videogen.another_shader.time_cnt\[11\] net732 sg13g2_dfrbpq_1
X_5316_ _2307_ VPWR _2309_ VGND _2304_ _2308_ sg13g2_o21ai_1
X_5247_ _2184_ VPWR _2246_ VGND _1238_ _1249_ sg13g2_o21ai_1
Xhold15 serialize.shift_reg_r\[8\] VPWR VGND net503 sg13g2_dlygate4sd3_1
Xhold26 serialize.shift_reg_g\[8\] VPWR VGND net514 sg13g2_dlygate4sd3_1
Xhold37 serialize.bit_cnt\[2\] VPWR VGND net525 sg13g2_dlygate4sd3_1
X_5178_ VGND VPWR _2178_ _1665_ _1510_ sg13g2_or2_1
X_6230__392 VPWR VGND net392 sg13g2_tiehi
X_4129_ _1135_ _1132_ _1136_ VPWR VGND sg13g2_xor2_1
XFILLER_45_47 VPWR VGND sg13g2_decap_4
XFILLER_16_308 VPWR VGND sg13g2_decap_4
XFILLER_24_341 VPWR VGND sg13g2_decap_8
XFILLER_24_363 VPWR VGND sg13g2_fill_2
XFILLER_40_845 VPWR VGND sg13g2_decap_4
XFILLER_12_547 VPWR VGND sg13g2_fill_2
X_6298__264 VPWR VGND net264 sg13g2_tiehi
XFILLER_0_963 VPWR VGND sg13g2_decap_8
XFILLER_48_923 VPWR VGND sg13g2_decap_8
XFILLER_19_146 VPWR VGND sg13g2_fill_2
X_6381__134 VPWR VGND net134 sg13g2_tiehi
XFILLER_16_831 VPWR VGND sg13g2_fill_2
XFILLER_28_691 VPWR VGND sg13g2_fill_1
XFILLER_43_694 VPWR VGND sg13g2_fill_1
XFILLER_31_845 VPWR VGND sg13g2_decap_8
X_6410__89 VPWR VGND net89 sg13g2_tiehi
XFILLER_31_889 VPWR VGND sg13g2_fill_1
X_3500_ _0739_ net705 net696 _0828_ VPWR VGND net617 sg13g2_nand4_1
X_4480_ videogen.test_lut_thingy.pixel_feeder_inst.row\[46\]\[1\] net637 _1487_ VPWR
+ VGND sg13g2_nor2_1
X_3431_ videogen.test_lut_thingy.pixel_feeder_inst.row\[24\]\[1\] net874 _0804_ _0666_
+ VPWR VGND sg13g2_mux2_1
X_3362_ VPWR _0755_ tmds_blue.dc_balancing_reg\[3\] VGND sg13g2_inv_1
X_6150_ net786 net829 _0210_ VPWR VGND sg13g2_nor2_1
X_5101_ _2074_ _2085_ _2107_ _2108_ VPWR VGND sg13g2_or3_1
X_6081_ net764 net806 _0142_ VPWR VGND sg13g2_nor2_1
X_5032_ _2038_ VPWR _2039_ VGND _2031_ _2035_ sg13g2_o21ai_1
XFILLER_39_956 VPWR VGND sg13g2_decap_8
X_6583__271 VPWR VGND net271 sg13g2_tiehi
XFILLER_25_105 VPWR VGND sg13g2_fill_2
XFILLER_26_639 VPWR VGND sg13g2_fill_1
X_5934_ _2859_ net746 net499 net751 red_tmds_par\[4\] VPWR VGND sg13g2_a22oi_1
X_5865_ _2820_ _2758_ _2687_ VPWR VGND sg13g2_nand2b_1
X_4816_ _1814_ _1817_ _1806_ _1823_ VPWR VGND sg13g2_nand3_1
X_5796_ _2756_ _2751_ _2755_ VPWR VGND sg13g2_nand2_1
X_4747_ _1748_ videogen.another_shader.time_cnt\[22\] _1754_ VPWR VGND sg13g2_xor2_1
XFILLER_21_399 VPWR VGND sg13g2_decap_8
X_4678_ _1685_ _1684_ VPWR VGND sg13g2_inv_2
X_6417_ net79 VGND VPWR _0472_ videogen.test_lut_thingy.pixel_feeder_inst.row\[36\]\[3\]
+ _0068_ sg13g2_dfrbpq_1
X_3629_ videogen.test_lut_thingy.pixel_feeder_inst.row\[8\]\[2\] net860 _0855_ _0499_
+ VPWR VGND sg13g2_mux2_1
Xoutput16 net16 uo_out[3] VPWR VGND sg13g2_buf_1
XFILLER_1_727 VPWR VGND sg13g2_decap_8
X_6348_ net171 VGND VPWR _0407_ blue\[5\] net741 sg13g2_dfrbpq_2
X_6279_ net302 VGND VPWR _0338_ videogen.test_lut_thingy.pixel_feeder_inst.row\[37\]\[2\]
+ _0035_ sg13g2_dfrbpq_1
XFILLER_5_1001 VPWR VGND sg13g2_decap_8
XFILLER_45_904 VPWR VGND sg13g2_decap_8
XFILLER_29_455 VPWR VGND sg13g2_fill_1
XFILLER_17_606 VPWR VGND sg13g2_fill_1
X_6640__34 VPWR VGND net34 sg13g2_tiehi
XFILLER_40_620 VPWR VGND sg13g2_decap_8
XFILLER_9_827 VPWR VGND sg13g2_decap_8
X_6595__131 VPWR VGND net131 sg13g2_tiehi
XFILLER_4_543 VPWR VGND sg13g2_decap_8
XFILLER_48_797 VPWR VGND sg13g2_decap_8
XFILLER_47_274 VPWR VGND sg13g2_fill_2
XFILLER_47_252 VPWR VGND sg13g2_decap_4
XFILLER_36_959 VPWR VGND sg13g2_decap_8
X_3980_ VGND VPWR net680 _1022_ _1027_ videogen.another_shader.time_cnt\[17\] sg13g2_a21oi_1
X_5650_ VGND VPWR net667 _2621_ _0461_ net844 sg13g2_a21oi_1
XFILLER_31_631 VPWR VGND sg13g2_fill_1
Xclkbuf_0_clk clk clknet_0_clk VPWR VGND sg13g2_buf_8
X_4601_ videogen.test_lut_thingy.pixel_feeder_inst.row\[2\]\[0\] net633 _1608_ VPWR
+ VGND sg13g2_nor2_1
X_5581_ net632 VPWR _2561_ VGND _2559_ _2560_ sg13g2_o21ai_1
X_4532_ net695 VPWR _1539_ VGND _1537_ _1538_ sg13g2_o21ai_1
X_6654__283 VPWR VGND net283 sg13g2_tiehi
X_4463_ videogen.test_lut_thingy.pixel_feeder_inst.row\[58\]\[1\] net634 _1470_ VPWR
+ VGND sg13g2_nor2_1
X_3414_ _0794_ _0797_ _0798_ VPWR VGND sg13g2_nor2_2
X_6202_ net429 VGND VPWR _0262_ clockdiv.q1 clknet_3_2__leaf_clk_regs sg13g2_dfrbpq_1
Xfanout806 net807 net806 VPWR VGND sg13g2_buf_8
X_4394_ videogen.test_lut_thingy.pixel_feeder_inst.row\[41\]\[2\] net628 _1401_ VPWR
+ VGND sg13g2_nor2_1
X_6133_ net781 net824 _0193_ VPWR VGND sg13g2_nor2_1
Xfanout828 net840 net828 VPWR VGND sg13g2_buf_8
X_3345_ _0738_ net699 VPWR VGND sg13g2_inv_2
Xfanout839 net840 net839 VPWR VGND sg13g2_buf_2
Xfanout817 net819 net817 VPWR VGND sg13g2_buf_8
X_6064_ net769 net812 _0125_ VPWR VGND sg13g2_nor2_1
X_5015_ _1725_ _2008_ _2022_ VPWR VGND sg13g2_nor2b_1
XFILLER_26_414 VPWR VGND sg13g2_decap_4
X_5917_ VPWR _0696_ _2850_ VGND sg13g2_inv_1
X_5848_ _2745_ VPWR _2805_ VGND tmds_blue.dc_balancing_reg\[3\] _2785_ sg13g2_o21ai_1
XFILLER_22_686 VPWR VGND sg13g2_decap_8
XFILLER_22_697 VPWR VGND sg13g2_fill_2
X_5779_ _2735_ _2738_ _2739_ VPWR VGND sg13g2_nor2_1
XFILLER_1_524 VPWR VGND sg13g2_decap_8
XFILLER_49_517 VPWR VGND sg13g2_decap_8
XFILLER_45_745 VPWR VGND sg13g2_fill_2
XFILLER_17_436 VPWR VGND sg13g2_fill_2
XFILLER_29_285 VPWR VGND sg13g2_decap_4
XFILLER_17_469 VPWR VGND sg13g2_fill_2
XFILLER_16_71 VPWR VGND sg13g2_fill_1
XFILLER_13_653 VPWR VGND sg13g2_fill_2
XFILLER_41_973 VPWR VGND sg13g2_decap_8
XFILLER_12_152 VPWR VGND sg13g2_fill_1
XFILLER_12_163 VPWR VGND sg13g2_decap_8
XFILLER_34_1028 VPWR VGND sg13g2_fill_1
XFILLER_9_668 VPWR VGND sg13g2_decap_8
XFILLER_32_81 VPWR VGND sg13g2_decap_8
XFILLER_8_189 VPWR VGND sg13g2_fill_2
XFILLER_5_841 VPWR VGND sg13g2_decap_4
XFILLER_5_896 VPWR VGND sg13g2_fill_2
XFILLER_5_885 VPWR VGND sg13g2_decap_8
X_3963_ VGND VPWR _0731_ _1011_ _0356_ _1014_ sg13g2_a21oi_1
X_3894_ _0897_ _0969_ _0970_ _0323_ VPWR VGND sg13g2_nor3_1
X_5702_ VPWR VGND _2609_ _2667_ _2663_ _2639_ _2668_ _2656_ sg13g2_a221oi_1
X_5633_ VGND VPWR _2610_ _2609_ net611 sg13g2_or2_1
X_5564_ _2482_ _2485_ _2547_ VPWR VGND sg13g2_and2_1
XFILLER_8_690 VPWR VGND sg13g2_fill_1
X_4515_ net665 VPWR _1522_ VGND videogen.test_lut_thingy.pixel_feeder_inst.row\[35\]\[3\]
+ net660 sg13g2_o21ai_1
X_5495_ _2481_ _2479_ _2480_ VPWR VGND sg13g2_nand2_1
X_4446_ net686 VPWR _1453_ VGND videogen.test_lut_thingy.pixel_feeder_inst.row\[9\]\[1\]
+ net622 sg13g2_o21ai_1
X_4377_ net689 _1380_ _1381_ _1383_ _1384_ VPWR VGND sg13g2_nor4_1
Xfanout614 _2716_ net614 VPWR VGND sg13g2_buf_8
X_3328_ VPWR _0721_ videogen.another_shader.time_cnt\[31\] VGND sg13g2_inv_1
Xfanout658 net659 net658 VPWR VGND sg13g2_buf_8
X_6116_ net763 net805 _0176_ VPWR VGND sg13g2_nor2_1
Xfanout636 net641 net636 VPWR VGND sg13g2_buf_8
X_6438__37 VPWR VGND net37 sg13g2_tiehi
Xfanout647 net651 net647 VPWR VGND sg13g2_buf_8
Xfanout625 net631 net625 VPWR VGND sg13g2_buf_8
Xfanout669 display_enable net669 VPWR VGND sg13g2_buf_8
X_6047_ net764 net806 _0108_ VPWR VGND sg13g2_nor2_1
X_6331__194 VPWR VGND net194 sg13g2_tiehi
XFILLER_39_583 VPWR VGND sg13g2_decap_8
XFILLER_26_211 VPWR VGND sg13g2_fill_1
XFILLER_26_222 VPWR VGND sg13g2_decap_4
XFILLER_15_918 VPWR VGND sg13g2_fill_2
XFILLER_26_266 VPWR VGND sg13g2_fill_1
XFILLER_26_277 VPWR VGND sg13g2_decap_4
XFILLER_27_789 VPWR VGND sg13g2_fill_2
XFILLER_42_748 VPWR VGND sg13g2_fill_2
XFILLER_14_439 VPWR VGND sg13g2_fill_2
XFILLER_10_645 VPWR VGND sg13g2_fill_1
XFILLER_2_822 VPWR VGND sg13g2_decap_8
XFILLER_49_303 VPWR VGND sg13g2_decap_4
XFILLER_2_888 VPWR VGND sg13g2_decap_8
XFILLER_1_365 VPWR VGND sg13g2_decap_8
XFILLER_49_347 VPWR VGND sg13g2_decap_8
XFILLER_40_1021 VPWR VGND sg13g2_decap_8
XFILLER_45_520 VPWR VGND sg13g2_fill_1
XFILLER_45_597 VPWR VGND sg13g2_decap_8
X_6280__300 VPWR VGND net300 sg13g2_tiehi
XFILLER_32_236 VPWR VGND sg13g2_decap_8
XFILLER_33_759 VPWR VGND sg13g2_fill_1
X_6575__354 VPWR VGND net354 sg13g2_tiehi
XFILLER_9_454 VPWR VGND sg13g2_decap_4
XFILLER_5_693 VPWR VGND sg13g2_decap_4
X_5280_ _1665_ _2272_ net897 _2273_ VPWR VGND sg13g2_nand3_1
X_4300_ _1306_ _1290_ _1293_ _1307_ VPWR VGND sg13g2_mux2_1
XFILLER_4_170 VPWR VGND sg13g2_fill_2
X_4231_ _1238_ _1127_ _1128_ VPWR VGND sg13g2_xnor2_1
X_4162_ _1169_ _1167_ _1168_ VPWR VGND sg13g2_xnor2_1
X_4093_ _0394_ _1106_ net615 _1104_ _0718_ VPWR VGND sg13g2_a22oi_1
XFILLER_36_575 VPWR VGND sg13g2_decap_8
X_4995_ _2001_ VPWR _2002_ VGND _1977_ _1981_ sg13g2_o21ai_1
X_3946_ VGND VPWR videogen.another_shader.time_cnt\[6\] _1001_ _1003_ videogen.another_shader.time_cnt\[7\]
+ sg13g2_a21oi_1
XFILLER_32_781 VPWR VGND sg13g2_fill_2
X_3877_ _0954_ VPWR _0959_ VGND videogen.test_lut_thingy.pixel_feeder_inst.v_pix\[2\]
+ _0956_ sg13g2_o21ai_1
X_5616_ _2593_ _2590_ _2592_ VPWR VGND sg13g2_nand2b_1
X_6596_ net123 VGND VPWR _0651_ videogen.test_lut_thingy.pixel_feeder_inst.row\[49\]\[1\]
+ _0238_ sg13g2_dfrbpq_1
X_6257__346 VPWR VGND net346 sg13g2_tiehi
XFILLER_3_619 VPWR VGND sg13g2_decap_8
X_5547_ _2531_ _2527_ _2529_ VPWR VGND sg13g2_xnor2_1
X_5478_ _2462_ _2463_ _2464_ VPWR VGND sg13g2_nor2_1
X_4429_ _1436_ net683 _1435_ VPWR VGND sg13g2_nand2b_1
XFILLER_48_14 VPWR VGND sg13g2_decap_8
XFILLER_24_1016 VPWR VGND sg13g2_decap_8
XFILLER_24_1027 VPWR VGND sg13g2_fill_2
XFILLER_47_818 VPWR VGND sg13g2_decap_8
XFILLER_48_69 VPWR VGND sg13g2_decap_8
XFILLER_42_545 VPWR VGND sg13g2_fill_1
XFILLER_14_258 VPWR VGND sg13g2_fill_1
XFILLER_11_954 VPWR VGND sg13g2_decap_8
XFILLER_10_464 VPWR VGND sg13g2_decap_8
XFILLER_11_987 VPWR VGND sg13g2_decap_8
X_6240__372 VPWR VGND net372 sg13g2_tiehi
XFILLER_6_479 VPWR VGND sg13g2_fill_1
XFILLER_2_663 VPWR VGND sg13g2_decap_8
XFILLER_46_862 VPWR VGND sg13g2_decap_8
XFILLER_18_575 VPWR VGND sg13g2_decap_8
XFILLER_33_501 VPWR VGND sg13g2_decap_8
X_4780_ _1778_ VPWR _1787_ VGND _1779_ _1785_ sg13g2_o21ai_1
X_3800_ VGND VPWR _0909_ _0921_ net20 _0910_ sg13g2_a21oi_1
X_3731_ videogen.test_lut_thingy.pixel_feeder_inst.row\[1\]\[2\] net860 _0877_ _0290_
+ VPWR VGND sg13g2_mux2_1
X_6450_ net470 VGND VPWR _0505_ videogen.test_lut_thingy.pixel_feeder_inst.row\[61\]\[0\]
+ _0101_ sg13g2_dfrbpq_1
X_3662_ videogen.test_lut_thingy.pixel_feeder_inst.row\[33\]\[1\] net878 _0863_ _0474_
+ VPWR VGND sg13g2_mux2_1
X_6536__113 VPWR VGND net113 sg13g2_tiehi
X_6473__403 VPWR VGND net403 sg13g2_tiehi
X_6381_ net134 VGND VPWR _0440_ videogen.test_lut_thingy.pixel_feeder_inst.row\[16\]\[0\]
+ _0045_ sg13g2_dfrbpq_1
X_5401_ _2394_ _2379_ _2390_ VPWR VGND sg13g2_nand2_1
X_3593_ net863 videogen.test_lut_thingy.pixel_feeder_inst.row\[57\]\[2\] _0847_ _0527_
+ VPWR VGND sg13g2_mux2_1
X_6391__114 VPWR VGND net114 sg13g2_tiehi
X_5332_ _2316_ _2324_ _2325_ VPWR VGND sg13g2_nor2b_1
XFILLER_48_0 VPWR VGND sg13g2_decap_8
X_5263_ _2262_ _2254_ _2249_ VPWR VGND sg13g2_nand2b_1
X_5194_ _2193_ _1189_ _2192_ VPWR VGND sg13g2_xnor2_1
X_4214_ _1221_ _1218_ _1220_ _1216_ _1210_ VPWR VGND sg13g2_a22oi_1
X_4145_ _1152_ videogen.another_shader.video_y\[5\] net679 VPWR VGND sg13g2_nand2_1
XFILLER_28_339 VPWR VGND sg13g2_decap_8
X_4076_ net894 VPWR _1095_ VGND net674 _1094_ sg13g2_o21ai_1
XFILLER_24_523 VPWR VGND sg13g2_fill_1
XFILLER_24_567 VPWR VGND sg13g2_fill_1
X_4978_ VGND VPWR _1985_ _1984_ _1983_ sg13g2_or2_1
XFILLER_11_217 VPWR VGND sg13g2_fill_1
XFILLER_11_239 VPWR VGND sg13g2_decap_8
X_3929_ net897 VPWR _0993_ VGND videogen.another_shader.time_cnt\[0\] _0952_ sg13g2_o21ai_1
Xclkload4 VPWR clkload4/Y clknet_3_7__leaf_clk_regs VGND sg13g2_inv_1
X_6648_ net421 VGND VPWR _0703_ serialize.shift_reg_r\[2\] clknet_3_5__leaf_clk_regs
+ sg13g2_dfrbpq_1
X_6579_ net321 VGND VPWR _0634_ videogen.test_lut_thingy.pixel_feeder_inst.row\[6\]\[0\]
+ _0221_ sg13g2_dfrbpq_1
XFILLER_19_306 VPWR VGND sg13g2_fill_2
XFILLER_46_125 VPWR VGND sg13g2_decap_8
XFILLER_28_851 VPWR VGND sg13g2_fill_1
XFILLER_43_821 VPWR VGND sg13g2_decap_8
XFILLER_28_884 VPWR VGND sg13g2_fill_2
XFILLER_15_567 VPWR VGND sg13g2_decap_4
XFILLER_43_898 VPWR VGND sg13g2_decap_8
XFILLER_42_375 VPWR VGND sg13g2_decap_8
XFILLER_7_788 VPWR VGND sg13g2_decap_8
XFILLER_6_287 VPWR VGND sg13g2_fill_2
XFILLER_3_994 VPWR VGND sg13g2_decap_8
XFILLER_49_90 VPWR VGND sg13g2_fill_2
XFILLER_37_114 VPWR VGND sg13g2_decap_4
XFILLER_1_42 VPWR VGND sg13g2_decap_8
XFILLER_37_147 VPWR VGND sg13g2_decap_8
X_5950_ net788 net831 _0011_ VPWR VGND sg13g2_nor2_1
X_4901_ _1899_ _1898_ _1906_ _1908_ VPWR VGND sg13g2_a21o_1
X_5881_ VGND VPWR net668 _2831_ _0659_ _2817_ sg13g2_a21oi_1
X_4832_ _1839_ _1836_ _1837_ _1833_ _1830_ VPWR VGND sg13g2_a22oi_1
XFILLER_33_386 VPWR VGND sg13g2_fill_2
X_4763_ _1770_ _0722_ _1768_ VPWR VGND sg13g2_xnor2_1
XFILLER_14_1004 VPWR VGND sg13g2_decap_8
XFILLER_21_559 VPWR VGND sg13g2_fill_1
X_4694_ _1692_ _1700_ _1689_ _1701_ VPWR VGND sg13g2_nand3_1
X_3714_ _0778_ _0803_ _0874_ VPWR VGND sg13g2_nor2_2
X_6502_ net291 VGND VPWR _0557_ tmds_blue.dc_balancing_reg\[4\] net744 sg13g2_dfrbpq_2
X_6433_ net47 VGND VPWR _0488_ videogen.test_lut_thingy.pixel_feeder_inst.row\[31\]\[3\]
+ _0084_ sg13g2_dfrbpq_1
X_3645_ _0859_ VPWR _0487_ VGND _0715_ _0858_ sg13g2_o21ai_1
XFILLER_20_18 VPWR VGND sg13g2_fill_1
X_6364_ net155 VGND VPWR _0423_ tmds_red.dc_balancing_reg\[1\] net737 sg13g2_dfrbpq_2
X_3576_ _0807_ _0828_ _0844_ VPWR VGND sg13g2_nor2_2
X_6295_ net270 VGND VPWR _0354_ videogen.another_shader.time_cnt\[10\] net732 sg13g2_dfrbpq_2
X_5315_ _2308_ _2298_ _2305_ VPWR VGND sg13g2_nand2_1
X_5246_ _2243_ _2185_ _2245_ VPWR VGND sg13g2_xor2_1
Xhold27 serialize.shift_reg_r\[9\] VPWR VGND net515 sg13g2_dlygate4sd3_1
Xhold38 _0664_ VPWR VGND net526 sg13g2_dlygate4sd3_1
Xhold16 serialize.shift_reg_b\[5\] VPWR VGND net504 sg13g2_dlygate4sd3_1
X_5177_ _2177_ VPWR _0408_ VGND _1569_ _1668_ sg13g2_o21ai_1
X_4128_ _1135_ net674 videogen.fancy_shader.shader_counter_reg\[3\] VPWR VGND sg13g2_xnor2_1
XFILLER_44_618 VPWR VGND sg13g2_fill_2
X_4059_ VGND VPWR net892 _1082_ _1083_ _1063_ sg13g2_a21oi_1
XFILLER_37_692 VPWR VGND sg13g2_decap_4
XFILLER_25_821 VPWR VGND sg13g2_fill_1
XFILLER_25_832 VPWR VGND sg13g2_fill_1
XFILLER_25_865 VPWR VGND sg13g2_fill_2
XFILLER_24_386 VPWR VGND sg13g2_fill_1
Xclkbuf_regs_0_clk clk clk_regs VPWR VGND sg13g2_buf_8
XFILLER_48_902 VPWR VGND sg13g2_decap_8
XFILLER_0_942 VPWR VGND sg13g2_decap_8
X_6567__437 VPWR VGND net437 sg13g2_tiehi
XFILLER_19_103 VPWR VGND sg13g2_fill_1
XFILLER_19_114 VPWR VGND sg13g2_fill_1
XFILLER_48_979 VPWR VGND sg13g2_decap_8
XFILLER_28_670 VPWR VGND sg13g2_fill_1
XFILLER_35_618 VPWR VGND sg13g2_decap_4
XFILLER_34_117 VPWR VGND sg13g2_fill_1
XFILLER_34_128 VPWR VGND sg13g2_decap_4
XFILLER_15_342 VPWR VGND sg13g2_decap_4
XFILLER_31_857 VPWR VGND sg13g2_fill_1
XFILLER_11_592 VPWR VGND sg13g2_fill_2
X_3430_ videogen.test_lut_thingy.pixel_feeder_inst.row\[24\]\[2\] net863 _0804_ _0667_
+ VPWR VGND sg13g2_mux2_1
X_3361_ VPWR _0754_ red\[7\] VGND sg13g2_inv_1
X_5100_ _1685_ _2086_ _2094_ _2107_ VPWR VGND sg13g2_nor3_1
XFILLER_3_780 VPWR VGND sg13g2_decap_8
X_6080_ net772 net815 _0141_ VPWR VGND sg13g2_nor2_1
X_5031_ _2037_ VPWR _2038_ VGND _2020_ _2023_ sg13g2_o21ai_1
XFILLER_39_935 VPWR VGND sg13g2_decap_8
XFILLER_38_412 VPWR VGND sg13g2_decap_8
X_5933_ VPWR _0704_ _2858_ VGND sg13g2_inv_1
XFILLER_18_180 VPWR VGND sg13g2_fill_2
X_5864_ VGND VPWR net668 _2819_ _0654_ _2817_ sg13g2_a21oi_1
XFILLER_34_684 VPWR VGND sg13g2_fill_2
X_4815_ _1809_ _1789_ _1821_ _1822_ VPWR VGND sg13g2_mux2_1
XFILLER_21_323 VPWR VGND sg13g2_fill_1
XFILLER_33_194 VPWR VGND sg13g2_fill_1
X_5795_ VPWR _2755_ _2754_ VGND sg13g2_inv_1
X_4746_ _1753_ videogen.another_shader.time_cnt\[22\] _1748_ VPWR VGND sg13g2_nand2_1
XFILLER_31_28 VPWR VGND sg13g2_fill_2
X_4677_ _1684_ _1680_ _1683_ VPWR VGND sg13g2_xnor2_1
X_6416_ net81 VGND VPWR _0471_ videogen.test_lut_thingy.pixel_feeder_inst.row\[36\]\[2\]
+ _0067_ sg13g2_dfrbpq_1
X_3628_ videogen.test_lut_thingy.pixel_feeder_inst.row\[8\]\[3\] net849 _0855_ _0500_
+ VPWR VGND sg13g2_mux2_1
Xoutput17 net17 uo_out[4] VPWR VGND sg13g2_buf_1
XFILLER_1_706 VPWR VGND sg13g2_decap_8
X_6347_ net172 VGND VPWR _0406_ blue\[4\] net741 sg13g2_dfrbpq_1
X_3559_ videogen.test_lut_thingy.pixel_feeder_inst.row\[28\]\[1\] net878 _0840_ _0563_
+ VPWR VGND sg13g2_mux2_1
XFILLER_0_238 VPWR VGND sg13g2_decap_8
X_6278_ net304 VGND VPWR _0337_ videogen.test_lut_thingy.pixel_feeder_inst.row\[37\]\[1\]
+ _0034_ sg13g2_dfrbpq_1
X_5229_ _2188_ _2216_ _2227_ _2228_ VPWR VGND sg13g2_nor3_1
XFILLER_12_301 VPWR VGND sg13g2_decap_4
XFILLER_25_673 VPWR VGND sg13g2_fill_1
XFILLER_31_109 VPWR VGND sg13g2_fill_1
XFILLER_40_643 VPWR VGND sg13g2_fill_1
XFILLER_40_687 VPWR VGND sg13g2_decap_8
XFILLER_40_665 VPWR VGND sg13g2_decap_8
XFILLER_4_511 VPWR VGND sg13g2_fill_1
XFILLER_21_72 VPWR VGND sg13g2_fill_2
X_6614__471 VPWR VGND net471 sg13g2_tiehi
XFILLER_4_588 VPWR VGND sg13g2_fill_2
XFILLER_39_209 VPWR VGND sg13g2_fill_1
XFILLER_0_772 VPWR VGND sg13g2_fill_1
XFILLER_48_776 VPWR VGND sg13g2_decap_8
XFILLER_36_938 VPWR VGND sg13g2_decap_8
XFILLER_44_982 VPWR VGND sg13g2_decap_8
X_4600_ _1603_ _1604_ _1605_ _1606_ _1607_ VPWR VGND sg13g2_nor4_1
X_5580_ _2460_ _2440_ _2494_ _2560_ VPWR VGND sg13g2_mux2_1
X_4531_ _1512_ VPWR _1538_ VGND videogen.test_lut_thingy.pixel_feeder_inst.row\[28\]\[3\]
+ net649 sg13g2_o21ai_1
X_4462_ videogen.test_lut_thingy.pixel_feeder_inst.row\[56\]\[1\] net646 _1469_ VPWR
+ VGND sg13g2_nor2_1
X_6201_ net231 VGND VPWR _0261_ tmds_green.dc_balancing_reg\[0\] net740 sg13g2_dfrbpq_1
X_3413_ _0797_ _0796_ VPWR VGND _0789_ sg13g2_nand2b_2
Xfanout807 net841 net807 VPWR VGND sg13g2_buf_8
X_4393_ videogen.test_lut_thingy.pixel_feeder_inst.row\[43\]\[2\] net660 _1400_ VPWR
+ VGND sg13g2_nor2_1
Xfanout818 net819 net818 VPWR VGND sg13g2_buf_8
X_3344_ VPWR _0737_ videogen.test_lut_thingy.pixel_feeder_inst.v_counter\[0\] VGND
+ sg13g2_inv_1
X_6132_ net787 net830 _0192_ VPWR VGND sg13g2_nor2_1
Xfanout829 net833 net829 VPWR VGND sg13g2_buf_8
X_6063_ net772 net815 _0124_ VPWR VGND sg13g2_nor2_1
XFILLER_39_754 VPWR VGND sg13g2_fill_1
X_5014_ _2018_ _2009_ _2021_ VPWR VGND sg13g2_xor2_1
XFILLER_39_798 VPWR VGND sg13g2_decap_4
XFILLER_26_28 VPWR VGND sg13g2_decap_8
X_5916_ _2850_ net748 net500 net754 green_tmds_par\[3\] VPWR VGND sg13g2_a22oi_1
XFILLER_35_993 VPWR VGND sg13g2_decap_8
XFILLER_34_481 VPWR VGND sg13g2_decap_8
XFILLER_34_492 VPWR VGND sg13g2_decap_8
X_5847_ _2797_ VPWR _2804_ VGND _2795_ _2798_ sg13g2_o21ai_1
XFILLER_21_153 VPWR VGND sg13g2_decap_4
X_5778_ VGND VPWR _2738_ _2737_ _2736_ sg13g2_or2_1
X_4729_ VPWR _1736_ _1735_ VGND sg13g2_inv_1
X_6267__326 VPWR VGND net326 sg13g2_tiehi
XFILLER_45_735 VPWR VGND sg13g2_fill_2
XFILLER_44_289 VPWR VGND sg13g2_fill_2
XFILLER_41_952 VPWR VGND sg13g2_decap_8
XFILLER_34_1007 VPWR VGND sg13g2_decap_8
XFILLER_40_473 VPWR VGND sg13g2_fill_2
XFILLER_4_396 VPWR VGND sg13g2_decap_4
XFILLER_36_702 VPWR VGND sg13g2_decap_4
XFILLER_36_735 VPWR VGND sg13g2_fill_1
X_3962_ _1014_ net895 _1013_ VPWR VGND sg13g2_nand2_1
X_5701_ VPWR VGND _2657_ net612 _2666_ net610 _2667_ _2665_ sg13g2_a221oi_1
XFILLER_16_481 VPWR VGND sg13g2_decap_8
X_3893_ net658 _0966_ _0970_ VPWR VGND sg13g2_nor2_1
X_5632_ _2580_ net612 _2609_ VPWR VGND sg13g2_and2_1
X_5563_ VGND VPWR _2527_ _2538_ _2546_ _2543_ sg13g2_a21oi_1
X_4514_ _1520_ VPWR _1521_ VGND videogen.test_lut_thingy.pixel_feeder_inst.row\[39\]\[3\]
+ net658 sg13g2_o21ai_1
X_5494_ _2468_ VPWR _2480_ VGND _2461_ _2470_ sg13g2_o21ai_1
X_4445_ net686 _1448_ _1449_ _1451_ _1452_ VPWR VGND sg13g2_nor4_1
Xfanout615 _0930_ net615 VPWR VGND sg13g2_buf_8
X_4376_ _1382_ VPWR _1383_ VGND videogen.test_lut_thingy.pixel_feeder_inst.row\[55\]\[2\]
+ net656 sg13g2_o21ai_1
X_6115_ net765 net804 _0175_ VPWR VGND sg13g2_nor2_1
Xfanout648 net651 net648 VPWR VGND sg13g2_buf_8
Xfanout637 net641 net637 VPWR VGND sg13g2_buf_8
Xfanout626 net631 net626 VPWR VGND sg13g2_buf_8
X_3327_ VPWR _0720_ net900 VGND sg13g2_inv_1
Xfanout659 net660 net659 VPWR VGND sg13g2_buf_8
X_6046_ net764 net806 _0107_ VPWR VGND sg13g2_nor2_1
XFILLER_27_735 VPWR VGND sg13g2_fill_2
XFILLER_14_407 VPWR VGND sg13g2_fill_1
XFILLER_35_790 VPWR VGND sg13g2_decap_8
XFILLER_22_473 VPWR VGND sg13g2_decap_8
XFILLER_10_679 VPWR VGND sg13g2_decap_8
XFILLER_1_344 VPWR VGND sg13g2_decap_8
XFILLER_49_326 VPWR VGND sg13g2_decap_8
XFILLER_40_1000 VPWR VGND sg13g2_decap_8
XFILLER_17_245 VPWR VGND sg13g2_decap_8
XFILLER_43_81 VPWR VGND sg13g2_fill_1
XFILLER_40_270 VPWR VGND sg13g2_fill_2
XFILLER_9_477 VPWR VGND sg13g2_fill_1
X_4230_ _1237_ _1116_ _1117_ VPWR VGND sg13g2_xnor2_1
X_4161_ _1168_ net708 videogen.fancy_shader.shader_counter_reg\[9\] VPWR VGND sg13g2_xnor2_1
X_4092_ _1106_ net893 _1105_ VPWR VGND sg13g2_nand2_1
X_4994_ _2001_ _1981_ _1985_ VPWR VGND sg13g2_nand2_1
XFILLER_17_790 VPWR VGND sg13g2_decap_8
X_3945_ net846 _1002_ _0350_ VPWR VGND sg13g2_nor2_1
XFILLER_23_18 VPWR VGND sg13g2_decap_8
XFILLER_23_259 VPWR VGND sg13g2_decap_4
XFILLER_23_29 VPWR VGND sg13g2_fill_2
X_3876_ videogen.test_lut_thingy.pixel_feeder_inst.v_pix\[2\] _0956_ _0958_ VPWR VGND
+ sg13g2_and2_1
X_5615_ _2592_ green\[3\] _2591_ VPWR VGND sg13g2_xnor2_1
X_6595_ net131 VGND VPWR _0650_ videogen.test_lut_thingy.pixel_feeder_inst.row\[49\]\[0\]
+ _0237_ sg13g2_dfrbpq_1
X_5546_ _2530_ _2527_ _2529_ VPWR VGND sg13g2_nand2b_1
X_5477_ _2463_ _2446_ _2457_ VPWR VGND sg13g2_xnor2_1
X_4428_ net665 _1429_ _1434_ _1435_ VPWR VGND sg13g2_nor3_1
X_4359_ videogen.test_lut_thingy.pixel_feeder_inst.row\[59\]\[2\] net655 _1366_ VPWR
+ VGND sg13g2_nor2_1
X_6029_ net758 net800 _0090_ VPWR VGND sg13g2_nor2_1
XFILLER_30_708 VPWR VGND sg13g2_fill_2
XFILLER_10_410 VPWR VGND sg13g2_fill_1
XFILLER_11_933 VPWR VGND sg13g2_decap_8
XFILLER_23_793 VPWR VGND sg13g2_fill_2
XFILLER_11_966 VPWR VGND sg13g2_decap_8
XFILLER_7_948 VPWR VGND sg13g2_fill_1
XFILLER_7_937 VPWR VGND sg13g2_decap_8
XFILLER_10_454 VPWR VGND sg13g2_fill_2
XFILLER_2_642 VPWR VGND sg13g2_decap_8
XFILLER_49_156 VPWR VGND sg13g2_fill_1
XFILLER_46_841 VPWR VGND sg13g2_decap_8
X_6425__63 VPWR VGND net63 sg13g2_tiehi
X_6440__33 VPWR VGND net33 sg13g2_tiehi
XFILLER_33_557 VPWR VGND sg13g2_fill_1
X_6499__297 VPWR VGND net297 sg13g2_tiehi
X_3730_ videogen.test_lut_thingy.pixel_feeder_inst.row\[1\]\[3\] net849 _0877_ _0291_
+ VPWR VGND sg13g2_mux2_1
XFILLER_41_590 VPWR VGND sg13g2_fill_2
XFILLER_9_230 VPWR VGND sg13g2_fill_1
XFILLER_9_252 VPWR VGND sg13g2_fill_2
X_3661_ videogen.test_lut_thingy.pixel_feeder_inst.row\[33\]\[2\] net867 _0863_ _0475_
+ VPWR VGND sg13g2_mux2_1
X_5400_ _2393_ _2366_ _2376_ VPWR VGND sg13g2_xnor2_1
XFILLER_9_296 VPWR VGND sg13g2_fill_1
X_6380_ net135 VGND VPWR _0439_ green_tmds_par\[7\] net738 sg13g2_dfrbpq_1
X_3592_ net852 videogen.test_lut_thingy.pixel_feeder_inst.row\[57\]\[3\] _0847_ _0528_
+ VPWR VGND sg13g2_mux2_1
X_5331_ _2323_ VPWR _2324_ VGND _2315_ _2318_ sg13g2_o21ai_1
XFILLER_47_1028 VPWR VGND sg13g2_fill_1
XFILLER_6_992 VPWR VGND sg13g2_decap_8
X_5262_ _2245_ _2257_ _2261_ VPWR VGND sg13g2_and2_1
X_5193_ _2192_ _1151_ _2191_ VPWR VGND sg13g2_nand2_1
X_4213_ _1220_ _1219_ _1215_ VPWR VGND sg13g2_nand2b_1
X_4144_ videogen.fancy_shader.shader_counter_reg\[6\] videogen.another_shader.video_y\[6\]
+ _1151_ VPWR VGND sg13g2_xor2_1
XFILLER_29_819 VPWR VGND sg13g2_fill_2
XFILLER_28_329 VPWR VGND sg13g2_fill_1
X_4075_ _1094_ net675 _0904_ _0928_ VPWR VGND sg13g2_and3_1
X_6560__465 VPWR VGND net465 sg13g2_tiehi
XFILLER_36_395 VPWR VGND sg13g2_fill_2
X_4977_ VGND VPWR _1963_ _1982_ _1984_ _1952_ sg13g2_a21oi_1
X_3928_ _0735_ _0762_ net620 _0992_ VPWR VGND sg13g2_nor3_2
XFILLER_20_752 VPWR VGND sg13g2_decap_4
X_6647_ net435 VGND VPWR _0702_ serialize.shift_reg_r\[1\] clknet_3_7__leaf_clk_regs
+ sg13g2_dfrbpq_1
XFILLER_20_785 VPWR VGND sg13g2_decap_8
X_3859_ net495 net750 _0305_ VPWR VGND sg13g2_and2_1
X_6578_ net329 VGND VPWR _0633_ videogen.test_lut_thingy.pixel_feeder_inst.row\[38\]\[3\]
+ _0220_ sg13g2_dfrbpq_1
X_5529_ _2514_ _2513_ _2502_ VPWR VGND sg13g2_nand2b_1
XFILLER_1_7 VPWR VGND sg13g2_decap_8
XFILLER_43_800 VPWR VGND sg13g2_decap_8
XFILLER_27_362 VPWR VGND sg13g2_fill_2
XFILLER_43_877 VPWR VGND sg13g2_decap_8
XFILLER_42_354 VPWR VGND sg13g2_decap_8
XFILLER_42_387 VPWR VGND sg13g2_fill_2
XFILLER_23_590 VPWR VGND sg13g2_fill_2
XFILLER_7_734 VPWR VGND sg13g2_decap_8
XFILLER_7_701 VPWR VGND sg13g2_fill_1
XFILLER_11_785 VPWR VGND sg13g2_fill_1
XFILLER_6_233 VPWR VGND sg13g2_decap_8
XFILLER_3_973 VPWR VGND sg13g2_decap_8
XFILLER_2_472 VPWR VGND sg13g2_fill_2
XFILLER_38_627 VPWR VGND sg13g2_fill_2
XFILLER_1_21 VPWR VGND sg13g2_decap_8
XFILLER_19_852 VPWR VGND sg13g2_decap_4
XFILLER_1_98 VPWR VGND sg13g2_decap_8
X_4900_ _1907_ _1900_ _1906_ VPWR VGND sg13g2_nand2_1
X_5880_ _2758_ _2694_ _2830_ _2831_ VPWR VGND sg13g2_a21o_1
X_4831_ _1838_ _1836_ _1837_ VPWR VGND sg13g2_nand2_1
XFILLER_33_365 VPWR VGND sg13g2_decap_8
XFILLER_34_899 VPWR VGND sg13g2_fill_2
X_4762_ _0722_ _0723_ _0724_ _1764_ _1769_ VPWR VGND sg13g2_nor4_1
XFILLER_33_398 VPWR VGND sg13g2_fill_2
X_3713_ net883 videogen.test_lut_thingy.pixel_feeder_inst.row\[18\]\[0\] _0873_ _0311_
+ VPWR VGND sg13g2_mux2_1
X_6501_ net293 VGND VPWR _0556_ tmds_blue.dc_balancing_reg\[3\] net742 sg13g2_dfrbpq_1
X_4693_ _1699_ videogen.another_shader.video_y\[5\] _1700_ VPWR VGND sg13g2_xor2_1
X_6432_ net49 VGND VPWR _0487_ videogen.test_lut_thingy.pixel_feeder_inst.row\[31\]\[2\]
+ _0083_ sg13g2_dfrbpq_1
X_3644_ _0859_ net869 _0858_ VPWR VGND sg13g2_nand2_1
X_6363_ net156 VGND VPWR _0422_ tmds_red.dc_balancing_reg\[0\] net737 sg13g2_dfrbpq_1
X_3575_ videogen.test_lut_thingy.pixel_feeder_inst.row\[53\]\[0\] net884 _0843_ _0541_
+ VPWR VGND sg13g2_mux2_1
X_5314_ _2306_ _2291_ _2307_ VPWR VGND sg13g2_xor2_1
X_6294_ net272 VGND VPWR _0353_ videogen.another_shader.time_cnt\[9\] net732 sg13g2_dfrbpq_2
X_5245_ _2243_ _2185_ _2244_ VPWR VGND sg13g2_nor2b_1
Xhold17 serialize.shift_reg_g\[9\] VPWR VGND net505 sg13g2_dlygate4sd3_1
Xhold28 serialize.shift_reg_b\[2\] VPWR VGND net516 sg13g2_dlygate4sd3_1
X_5176_ _2177_ videogen.another_shader.time_cnt\[6\] _2145_ VPWR VGND sg13g2_nand2_1
Xhold39 serialize.bit_cnt\[1\] VPWR VGND net527 sg13g2_dlygate4sd3_1
XFILLER_29_605 VPWR VGND sg13g2_fill_1
X_6449__472 VPWR VGND net472 sg13g2_tiehi
X_4127_ net674 videogen.fancy_shader.shader_counter_reg\[3\] _1134_ VPWR VGND sg13g2_nor2_1
XFILLER_28_137 VPWR VGND sg13g2_fill_2
XFILLER_45_38 VPWR VGND sg13g2_fill_1
X_4058_ videogen.fancy_shader.shader_counter_reg\[8\] _1072_ videogen.fancy_shader.shader_counter_reg\[0\]
+ _1082_ VPWR VGND _1080_ sg13g2_nand4_1
XFILLER_43_129 VPWR VGND sg13g2_fill_2
XFILLER_37_682 VPWR VGND sg13g2_decap_4
X_6521__213 VPWR VGND net213 sg13g2_tiehi
XFILLER_8_509 VPWR VGND sg13g2_fill_2
XFILLER_12_549 VPWR VGND sg13g2_fill_1
XFILLER_20_560 VPWR VGND sg13g2_fill_1
XFILLER_4_748 VPWR VGND sg13g2_decap_4
XFILLER_0_921 VPWR VGND sg13g2_decap_8
XFILLER_47_402 VPWR VGND sg13g2_fill_1
XFILLER_0_998 VPWR VGND sg13g2_decap_8
XFILLER_48_958 VPWR VGND sg13g2_decap_8
XFILLER_47_446 VPWR VGND sg13g2_decap_8
XFILLER_16_833 VPWR VGND sg13g2_fill_1
XFILLER_37_1016 VPWR VGND sg13g2_decap_8
XFILLER_15_354 VPWR VGND sg13g2_fill_2
XFILLER_42_151 VPWR VGND sg13g2_decap_4
XFILLER_37_1027 VPWR VGND sg13g2_fill_2
X_6277__306 VPWR VGND net306 sg13g2_tiehi
X_3360_ VPWR _0753_ red\[0\] VGND sg13g2_inv_1
X_5030_ _2020_ VPWR _2037_ VGND _2023_ _2025_ sg13g2_o21ai_1
XFILLER_39_914 VPWR VGND sg13g2_decap_8
XFILLER_38_446 VPWR VGND sg13g2_fill_1
X_5932_ _2858_ net748 net507 net753 red_tmds_par\[3\] VPWR VGND sg13g2_a22oi_1
XFILLER_25_107 VPWR VGND sg13g2_fill_1
X_5863_ _2818_ blue\[0\] _2819_ VPWR VGND sg13g2_xor2_1
XFILLER_34_663 VPWR VGND sg13g2_decap_8
X_4814_ VPWR VGND _1817_ _1804_ _1815_ _1760_ _1821_ _1805_ sg13g2_a221oi_1
X_5794_ _2747_ VPWR _2754_ VGND tmds_blue.dc_balancing_reg\[4\] _2748_ sg13g2_o21ai_1
XFILLER_21_313 VPWR VGND sg13g2_decap_4
X_4745_ _1752_ _1747_ _1749_ VPWR VGND sg13g2_nand2_1
X_6590__211 VPWR VGND net211 sg13g2_tiehi
X_4676_ _1683_ videogen.another_shader.video_y\[3\] _1682_ VPWR VGND sg13g2_xnor2_1
X_6415_ net83 VGND VPWR _0470_ videogen.test_lut_thingy.pixel_feeder_inst.row\[36\]\[1\]
+ _0066_ sg13g2_dfrbpq_1
X_3627_ _0801_ _0854_ _0855_ VPWR VGND sg13g2_nor2_2
X_3558_ videogen.test_lut_thingy.pixel_feeder_inst.row\[28\]\[2\] net867 _0840_ _0564_
+ VPWR VGND sg13g2_mux2_1
Xoutput18 net18 uo_out[5] VPWR VGND sg13g2_buf_1
X_6346_ net173 VGND VPWR _0405_ blue\[3\] net734 sg13g2_dfrbpq_1
XFILLER_0_217 VPWR VGND sg13g2_decap_8
X_6277_ net306 VGND VPWR _0336_ videogen.test_lut_thingy.pixel_feeder_inst.row\[37\]\[0\]
+ _0033_ sg13g2_dfrbpq_1
X_3489_ _0825_ net617 _0824_ VPWR VGND sg13g2_nand2_2
X_5228_ _2227_ _2217_ _2224_ VPWR VGND sg13g2_xnor2_1
X_5159_ _2165_ _2148_ _2164_ VPWR VGND sg13g2_xnor2_1
XFILLER_29_413 VPWR VGND sg13g2_decap_4
XFILLER_44_405 VPWR VGND sg13g2_fill_2
XFILLER_45_939 VPWR VGND sg13g2_decap_8
XFILLER_16_107 VPWR VGND sg13g2_fill_1
XFILLER_16_118 VPWR VGND sg13g2_fill_1
XFILLER_13_814 VPWR VGND sg13g2_fill_2
XFILLER_24_151 VPWR VGND sg13g2_fill_1
XFILLER_25_663 VPWR VGND sg13g2_fill_1
XFILLER_24_195 VPWR VGND sg13g2_fill_1
XFILLER_8_317 VPWR VGND sg13g2_fill_2
X_6237__378 VPWR VGND net378 sg13g2_tiehi
XFILLER_0_795 VPWR VGND sg13g2_decap_8
XFILLER_47_243 VPWR VGND sg13g2_decap_4
XFILLER_47_276 VPWR VGND sg13g2_fill_1
XFILLER_44_961 VPWR VGND sg13g2_decap_8
XFILLER_16_663 VPWR VGND sg13g2_fill_1
X_6504__285 VPWR VGND net285 sg13g2_tiehi
XFILLER_15_195 VPWR VGND sg13g2_decap_8
XFILLER_30_110 VPWR VGND sg13g2_fill_2
XFILLER_31_688 VPWR VGND sg13g2_fill_1
XFILLER_31_699 VPWR VGND sg13g2_fill_1
X_4530_ _1513_ VPWR _1537_ VGND videogen.test_lut_thingy.pixel_feeder_inst.row\[29\]\[3\]
+ net629 sg13g2_o21ai_1
XFILLER_7_350 VPWR VGND sg13g2_decap_4
XFILLER_11_1008 VPWR VGND sg13g2_decap_8
X_4461_ videogen.test_lut_thingy.pixel_feeder_inst.row\[59\]\[1\] net655 _1468_ VPWR
+ VGND sg13g2_nor2_1
X_6200_ net789 net832 _0260_ VPWR VGND sg13g2_nor2_1
X_3412_ _0784_ _0795_ _0796_ VPWR VGND sg13g2_nor2_1
X_6131_ net785 net828 _0191_ VPWR VGND sg13g2_nor2_1
X_4392_ videogen.test_lut_thingy.pixel_feeder_inst.row\[42\]\[2\] net640 _1399_ VPWR
+ VGND sg13g2_nor2_1
X_3343_ VPWR _0736_ videogen.test_lut_thingy.pixel_feeder_inst.v_counter\[3\] VGND
+ sg13g2_inv_1
Xfanout808 net809 net808 VPWR VGND sg13g2_buf_8
Xfanout819 net820 net819 VPWR VGND sg13g2_buf_8
X_6062_ net769 net812 _0123_ VPWR VGND sg13g2_nor2_1
X_5013_ _2020_ _2019_ _2006_ _2018_ _2014_ VPWR VGND sg13g2_a22oi_1
XFILLER_38_210 VPWR VGND sg13g2_fill_1
XFILLER_38_232 VPWR VGND sg13g2_decap_4
X_5915_ VPWR _0695_ _2849_ VGND sg13g2_inv_1
XFILLER_22_600 VPWR VGND sg13g2_decap_4
XFILLER_35_972 VPWR VGND sg13g2_decap_8
X_5846_ VGND VPWR _2794_ _2803_ _0556_ net643 sg13g2_a21oi_1
X_5777_ VPWR VGND _2693_ _2720_ _2721_ blue\[0\] _2737_ _2718_ sg13g2_a221oi_1
X_4728_ _1735_ _1733_ _1734_ VPWR VGND sg13g2_nand2_1
XFILLER_5_309 VPWR VGND sg13g2_fill_1
X_4659_ VPWR _1666_ _1665_ VGND sg13g2_inv_1
X_6543__76 VPWR VGND net76 sg13g2_tiehi
X_6329_ net198 VGND VPWR _0388_ videogen.another_shader.video_y\[2\] net725 sg13g2_dfrbpq_2
XFILLER_1_559 VPWR VGND sg13g2_decap_8
XFILLER_27_1026 VPWR VGND sg13g2_fill_2
XFILLER_45_714 VPWR VGND sg13g2_decap_8
XFILLER_44_246 VPWR VGND sg13g2_decap_4
XFILLER_25_460 VPWR VGND sg13g2_decap_4
XFILLER_41_931 VPWR VGND sg13g2_decap_8
XFILLER_13_633 VPWR VGND sg13g2_decap_8
XFILLER_25_493 VPWR VGND sg13g2_fill_2
XFILLER_12_132 VPWR VGND sg13g2_decap_8
XFILLER_12_187 VPWR VGND sg13g2_decap_8
XFILLER_13_699 VPWR VGND sg13g2_decap_8
XFILLER_8_158 VPWR VGND sg13g2_decap_4
XFILLER_5_898 VPWR VGND sg13g2_fill_1
XFILLER_4_364 VPWR VGND sg13g2_fill_2
XFILLER_0_581 VPWR VGND sg13g2_decap_8
XFILLER_35_224 VPWR VGND sg13g2_decap_8
XFILLER_35_235 VPWR VGND sg13g2_fill_2
X_3961_ VGND VPWR _1013_ _1011_ _0731_ sg13g2_or2_1
X_5700_ net610 _2658_ _2666_ VPWR VGND sg13g2_nor2b_1
X_3892_ VGND VPWR net705 _0967_ _0969_ net701 sg13g2_a21oi_1
X_6539__101 VPWR VGND net101 sg13g2_tiehi
XFILLER_31_441 VPWR VGND sg13g2_fill_2
X_5631_ _2601_ VPWR _2608_ VGND tmds_green.dc_balancing_reg\[4\] _2604_ sg13g2_o21ai_1
XFILLER_31_463 VPWR VGND sg13g2_fill_2
XFILLER_31_496 VPWR VGND sg13g2_decap_8
XFILLER_32_997 VPWR VGND sg13g2_decap_4
X_5562_ net632 _2545_ _0425_ VPWR VGND sg13g2_and2_1
X_4513_ _1517_ _1518_ _1519_ _1520_ VPWR VGND sg13g2_nor3_1
X_6556__481 VPWR VGND net481 sg13g2_tiehi
X_5493_ _2477_ _2473_ _2479_ VPWR VGND sg13g2_xor2_1
XFILLER_7_191 VPWR VGND sg13g2_fill_2
X_4444_ _1450_ VPWR _1451_ VGND videogen.test_lut_thingy.pixel_feeder_inst.row\[3\]\[1\]
+ net654 sg13g2_o21ai_1
X_4375_ _1382_ net652 videogen.test_lut_thingy.pixel_feeder_inst.row\[52\]\[2\] VPWR
+ VGND sg13g2_nand2b_1
X_6114_ net762 net804 _0174_ VPWR VGND sg13g2_nor2_1
Xfanout616 _0793_ net616 VPWR VGND sg13g2_buf_8
Xfanout638 net641 net638 VPWR VGND sg13g2_buf_1
X_3326_ VPWR _0719_ net674 VGND sg13g2_inv_1
Xfanout627 net631 net627 VPWR VGND sg13g2_buf_1
Xfanout649 net650 net649 VPWR VGND sg13g2_buf_8
X_6045_ net764 net806 _0106_ VPWR VGND sg13g2_nor2_1
XFILLER_37_39 VPWR VGND sg13g2_decap_4
XFILLER_2_1028 VPWR VGND sg13g2_fill_1
XFILLER_23_942 VPWR VGND sg13g2_fill_1
XFILLER_41_249 VPWR VGND sg13g2_fill_1
X_6303__254 VPWR VGND net254 sg13g2_tiehi
X_5829_ _2787_ tmds_blue.dc_balancing_reg\[2\] _2743_ VPWR VGND sg13g2_nand2_1
XFILLER_5_128 VPWR VGND sg13g2_decap_8
XFILLER_2_857 VPWR VGND sg13g2_decap_8
XFILLER_1_323 VPWR VGND sg13g2_decap_8
XFILLER_2_868 VPWR VGND sg13g2_fill_2
XFILLER_45_511 VPWR VGND sg13g2_decap_8
XFILLER_18_758 VPWR VGND sg13g2_decap_8
XFILLER_18_769 VPWR VGND sg13g2_fill_2
XFILLER_27_94 VPWR VGND sg13g2_fill_2
XFILLER_33_739 VPWR VGND sg13g2_fill_1
XFILLER_41_761 VPWR VGND sg13g2_decap_4
XFILLER_32_249 VPWR VGND sg13g2_decap_4
XFILLER_13_463 VPWR VGND sg13g2_decap_8
XFILLER_14_997 VPWR VGND sg13g2_decap_8
X_4160_ _1161_ VPWR _1167_ VGND _1162_ _1166_ sg13g2_o21ai_1
X_4091_ VGND VPWR _1105_ _0907_ _0757_ sg13g2_or2_1
XFILLER_49_883 VPWR VGND sg13g2_decap_8
XFILLER_48_393 VPWR VGND sg13g2_decap_8
X_4993_ _1996_ _1997_ _1994_ _2000_ VPWR VGND sg13g2_nand3_1
XFILLER_24_739 VPWR VGND sg13g2_decap_4
X_3944_ _1002_ videogen.another_shader.time_cnt\[6\] _1001_ VPWR VGND sg13g2_xnor2_1
X_3875_ _0956_ _0957_ _0317_ VPWR VGND sg13g2_nor2_1
XFILLER_32_783 VPWR VGND sg13g2_fill_1
X_5614_ _2591_ green\[2\] _2581_ VPWR VGND sg13g2_xnor2_1
XFILLER_9_990 VPWR VGND sg13g2_decap_8
X_6594_ net143 VGND VPWR _0649_ videogen.test_lut_thingy.pixel_feeder_inst.row\[59\]\[3\]
+ _0236_ sg13g2_dfrbpq_1
X_5545_ _2529_ _2501_ _2528_ VPWR VGND sg13g2_nand2_1
X_5476_ _2462_ red\[4\] _2458_ VPWR VGND sg13g2_xnor2_1
X_4427_ net694 _1430_ _1432_ _1433_ _1434_ VPWR VGND sg13g2_nor4_1
X_4358_ videogen.test_lut_thingy.pixel_feeder_inst.row\[56\]\[2\] net646 _1365_ VPWR
+ VGND sg13g2_nor2_1
X_4289_ _1296_ _1295_ _1231_ VPWR VGND sg13g2_nand2b_1
XFILLER_46_319 VPWR VGND sg13g2_decap_8
X_6028_ net758 net800 _0089_ VPWR VGND sg13g2_nor2_1
XFILLER_27_511 VPWR VGND sg13g2_decap_8
XFILLER_39_393 VPWR VGND sg13g2_decap_8
XFILLER_27_522 VPWR VGND sg13g2_fill_2
X_6459__452 VPWR VGND net452 sg13g2_tiehi
XFILLER_22_271 VPWR VGND sg13g2_fill_2
XFILLER_6_426 VPWR VGND sg13g2_decap_4
XFILLER_10_499 VPWR VGND sg13g2_decap_8
XFILLER_2_621 VPWR VGND sg13g2_decap_8
XFILLER_2_698 VPWR VGND sg13g2_decap_8
XFILLER_49_135 VPWR VGND sg13g2_decap_8
XFILLER_46_820 VPWR VGND sg13g2_decap_8
XFILLER_45_363 VPWR VGND sg13g2_fill_2
XFILLER_46_897 VPWR VGND sg13g2_decap_8
XFILLER_33_514 VPWR VGND sg13g2_fill_2
XFILLER_14_772 VPWR VGND sg13g2_fill_1
XFILLER_9_220 VPWR VGND sg13g2_decap_4
XFILLER_13_271 VPWR VGND sg13g2_fill_1
X_6653__317 VPWR VGND net317 sg13g2_tiehi
XFILLER_9_264 VPWR VGND sg13g2_decap_8
X_3660_ videogen.test_lut_thingy.pixel_feeder_inst.row\[33\]\[3\] net856 _0863_ _0476_
+ VPWR VGND sg13g2_mux2_1
X_3591_ _0847_ _0809_ VPWR VGND _0805_ sg13g2_nand2b_2
XFILLER_6_971 VPWR VGND sg13g2_decap_8
X_5330_ _2323_ _2304_ _2310_ VPWR VGND sg13g2_xnor2_1
XFILLER_47_1007 VPWR VGND sg13g2_decap_8
X_5261_ VGND VPWR _2257_ _2259_ _2260_ _2256_ sg13g2_a21oi_1
X_4212_ VGND VPWR _1214_ _1217_ _1219_ _1211_ sg13g2_a21oi_1
X_5192_ _2191_ _1196_ _1209_ _2189_ VPWR VGND sg13g2_and3_2
X_4143_ net671 videogen.fancy_shader.shader_counter_reg\[6\] _1150_ VPWR VGND sg13g2_and2_1
X_4074_ net842 _1089_ _1093_ _0388_ VPWR VGND sg13g2_nor3_1
XFILLER_37_820 VPWR VGND sg13g2_fill_2
XFILLER_36_374 VPWR VGND sg13g2_decap_4
X_4976_ _1983_ _1952_ _1963_ _1982_ VPWR VGND sg13g2_and3_1
X_3927_ _0986_ _0991_ _0335_ VPWR VGND sg13g2_nor2_1
X_6646_ net443 VGND VPWR _0701_ serialize.shift_reg_r\[0\] clknet_3_7__leaf_clk_regs
+ sg13g2_dfrbpq_1
XFILLER_20_775 VPWR VGND sg13g2_fill_1
X_3858_ net492 net750 _0304_ VPWR VGND sg13g2_and2_1
X_3789_ _0914_ videogen.test_lut_thingy.pixel_feeder_inst.v_pix\[1\] _0911_ VPWR VGND
+ sg13g2_xnor2_1
X_6577_ net337 VGND VPWR _0632_ videogen.test_lut_thingy.pixel_feeder_inst.row\[38\]\[2\]
+ _0219_ sg13g2_dfrbpq_1
XFILLER_4_919 VPWR VGND sg13g2_decap_8
X_5528_ _2503_ VPWR _2513_ VGND _0751_ _2471_ sg13g2_o21ai_1
X_5459_ _2444_ red\[6\] _2445_ VPWR VGND sg13g2_xor2_1
XFILLER_46_138 VPWR VGND sg13g2_fill_2
XFILLER_28_886 VPWR VGND sg13g2_fill_1
XFILLER_43_856 VPWR VGND sg13g2_decap_8
XFILLER_24_73 VPWR VGND sg13g2_decap_8
XFILLER_10_252 VPWR VGND sg13g2_fill_2
XFILLER_6_289 VPWR VGND sg13g2_fill_1
XFILLER_3_952 VPWR VGND sg13g2_decap_8
XFILLER_49_81 VPWR VGND sg13g2_fill_1
XFILLER_49_70 VPWR VGND sg13g2_decap_8
XFILLER_19_842 VPWR VGND sg13g2_fill_2
XFILLER_1_77 VPWR VGND sg13g2_decap_8
XFILLER_18_363 VPWR VGND sg13g2_fill_1
XFILLER_18_374 VPWR VGND sg13g2_fill_1
X_4830_ _1824_ _1825_ _1819_ _1837_ VPWR VGND sg13g2_nand3_1
XFILLER_34_878 VPWR VGND sg13g2_decap_8
XFILLER_21_528 VPWR VGND sg13g2_decap_8
XFILLER_33_388 VPWR VGND sg13g2_fill_1
X_4761_ videogen.another_shader.time_cnt\[28\] _1052_ videogen.another_shader.time_cnt\[29\]
+ _1768_ VPWR VGND _1757_ sg13g2_nand4_1
X_3712_ net873 videogen.test_lut_thingy.pixel_feeder_inst.row\[18\]\[1\] _0873_ _0312_
+ VPWR VGND sg13g2_mux2_1
X_6500_ net295 VGND VPWR _0555_ tmds_blue.dc_balancing_reg\[2\] net742 sg13g2_dfrbpq_2
X_4692_ _1699_ videogen.another_shader.time_cnt\[5\] net713 VPWR VGND sg13g2_xnor2_1
X_3643_ videogen.test_lut_thingy.pixel_feeder_inst.row\[31\]\[3\] net856 _0858_ _0488_
+ VPWR VGND sg13g2_mux2_1
X_6431_ net51 VGND VPWR _0486_ videogen.test_lut_thingy.pixel_feeder_inst.row\[31\]\[1\]
+ _0082_ sg13g2_dfrbpq_1
X_6362_ net157 VGND VPWR _0421_ red\[7\] net727 sg13g2_dfrbpq_2
X_5313_ VGND VPWR _2298_ _2303_ _2306_ _2297_ sg13g2_a21oi_1
X_3574_ videogen.test_lut_thingy.pixel_feeder_inst.row\[53\]\[1\] net874 _0843_ _0542_
+ VPWR VGND sg13g2_mux2_1
X_6293_ net274 VGND VPWR _0352_ videogen.another_shader.time_cnt\[8\] net732 sg13g2_dfrbpq_2
X_5244_ _2241_ _2242_ _2243_ VPWR VGND sg13g2_nor2_1
X_5175_ _2145_ videogen.another_shader.time_cnt\[5\] _1669_ _0407_ VPWR VGND sg13g2_a21o_1
Xhold18 serialize.shift_reg_g\[7\] VPWR VGND net506 sg13g2_dlygate4sd3_1
Xhold29 serialize.shift_reg_b\[3\] VPWR VGND net517 sg13g2_dlygate4sd3_1
X_4126_ _1133_ net674 videogen.fancy_shader.shader_counter_reg\[3\] VPWR VGND sg13g2_nand2_1
XFILLER_37_661 VPWR VGND sg13g2_decap_8
X_4057_ VGND VPWR _1073_ _1080_ _0383_ _1081_ sg13g2_a21oi_1
XFILLER_43_119 VPWR VGND sg13g2_decap_4
XFILLER_12_528 VPWR VGND sg13g2_decap_4
X_4959_ _1966_ _0730_ _1730_ VPWR VGND sg13g2_xnor2_1
XFILLER_40_859 VPWR VGND sg13g2_decap_8
X_6629_ net223 VGND VPWR _0684_ videogen.test_lut_thingy.pixel_feeder_inst.row\[21\]\[3\]
+ _0260_ sg13g2_dfrbpq_1
X_6374__144 VPWR VGND net144 sg13g2_tiehi
XFILLER_10_97 VPWR VGND sg13g2_decap_8
XFILLER_0_900 VPWR VGND sg13g2_decap_8
XFILLER_48_937 VPWR VGND sg13g2_decap_8
XFILLER_47_414 VPWR VGND sg13g2_decap_8
XFILLER_0_977 VPWR VGND sg13g2_decap_8
XFILLER_35_609 VPWR VGND sg13g2_fill_1
XFILLER_34_108 VPWR VGND sg13g2_decap_4
XFILLER_35_50 VPWR VGND sg13g2_fill_1
XFILLER_16_878 VPWR VGND sg13g2_fill_2
XFILLER_35_72 VPWR VGND sg13g2_fill_2
XFILLER_7_554 VPWR VGND sg13g2_fill_2
XFILLER_7_598 VPWR VGND sg13g2_fill_1
XFILLER_25_4 VPWR VGND sg13g2_fill_2
X_5931_ VPWR _0703_ _2857_ VGND sg13g2_inv_1
XFILLER_18_171 VPWR VGND sg13g2_fill_1
XFILLER_18_182 VPWR VGND sg13g2_fill_1
XFILLER_33_130 VPWR VGND sg13g2_fill_2
XFILLER_33_141 VPWR VGND sg13g2_decap_4
X_5862_ _2752_ _2781_ _2818_ VPWR VGND sg13g2_nor2_2
X_4813_ VGND VPWR _1806_ _1820_ _1817_ _1815_ sg13g2_a21oi_2
XFILLER_21_336 VPWR VGND sg13g2_fill_2
X_5793_ _2753_ net614 _2751_ VPWR VGND sg13g2_nand2_1
X_4744_ videogen.another_shader.time_cnt\[19\] _1744_ videogen.another_shader.time_cnt\[20\]
+ _1751_ VPWR VGND sg13g2_nand3_1
XFILLER_21_347 VPWR VGND sg13g2_fill_2
XFILLER_21_369 VPWR VGND sg13g2_fill_1
X_4675_ net716 videogen.another_shader.time_cnt\[3\] _1682_ VPWR VGND sg13g2_xor2_1
X_6414_ net85 VGND VPWR _0469_ videogen.test_lut_thingy.pixel_feeder_inst.row\[36\]\[0\]
+ _0065_ sg13g2_dfrbpq_1
X_3626_ VGND VPWR _0854_ _0814_ _0802_ sg13g2_or2_1
X_3557_ videogen.test_lut_thingy.pixel_feeder_inst.row\[28\]\[3\] net856 _0840_ _0565_
+ VPWR VGND sg13g2_mux2_1
Xoutput19 net19 uo_out[6] VPWR VGND sg13g2_buf_1
X_6345_ net174 VGND VPWR _0404_ blue\[2\] net734 sg13g2_dfrbpq_2
X_6276_ net308 VGND VPWR _0335_ videogen.test_lut_thingy.pixel_feeder_inst.h_counter\[3\]
+ net718 sg13g2_dfrbpq_1
X_3488_ net698 net655 _0824_ VPWR VGND sg13g2_nor2_2
X_5227_ _2226_ _2217_ _2224_ VPWR VGND sg13g2_nand2_1
XFILLER_5_1015 VPWR VGND sg13g2_decap_8
X_5158_ _2164_ net676 net681 VPWR VGND sg13g2_xnor2_1
XFILLER_45_918 VPWR VGND sg13g2_decap_8
X_5089_ _2096_ _1685_ _2094_ VPWR VGND sg13g2_xnor2_1
X_4109_ _1116_ videogen.fancy_shader.shader_counter_reg\[0\] videogen.another_shader.video_x\[0\]
+ VPWR VGND sg13g2_nand2_1
XFILLER_20_391 VPWR VGND sg13g2_fill_2
XFILLER_4_568 VPWR VGND sg13g2_fill_1
XFILLER_4_557 VPWR VGND sg13g2_decap_8
XFILLER_21_74 VPWR VGND sg13g2_fill_1
XFILLER_4_579 VPWR VGND sg13g2_decap_4
XFILLER_43_1010 VPWR VGND sg13g2_decap_8
XFILLER_48_734 VPWR VGND sg13g2_fill_2
XFILLER_44_940 VPWR VGND sg13g2_decap_8
XFILLER_15_185 VPWR VGND sg13g2_fill_1
X_6320__216 VPWR VGND net216 sg13g2_tiehi
XFILLER_31_667 VPWR VGND sg13g2_fill_2
XFILLER_12_881 VPWR VGND sg13g2_fill_1
XFILLER_11_380 VPWR VGND sg13g2_fill_1
X_4460_ net688 VPWR _1467_ VGND videogen.test_lut_thingy.pixel_feeder_inst.row\[57\]\[1\]
+ net623 sg13g2_o21ai_1
XFILLER_7_98 VPWR VGND sg13g2_fill_1
X_3411_ _0795_ net617 _0782_ VPWR VGND sg13g2_nand2_1
X_4391_ net694 VPWR _1398_ VGND videogen.test_lut_thingy.pixel_feeder_inst.row\[40\]\[2\]
+ net650 sg13g2_o21ai_1
X_3342_ VPWR _0735_ videogen.another_shader.time_cnt\[0\] VGND sg13g2_inv_1
X_6130_ net785 net827 _0190_ VPWR VGND sg13g2_nor2_1
X_6511__257 VPWR VGND net257 sg13g2_tiehi
Xfanout809 net814 net809 VPWR VGND sg13g2_buf_8
XFILLER_39_701 VPWR VGND sg13g2_fill_1
X_6061_ net767 net809 _0122_ VPWR VGND sg13g2_nor2_1
X_5012_ _2009_ _2018_ _2008_ _2019_ VPWR VGND sg13g2_nand3_1
XFILLER_16_0 VPWR VGND sg13g2_fill_1
XFILLER_35_951 VPWR VGND sg13g2_decap_8
X_5914_ _2849_ net748 net502 net754 green_tmds_par\[2\] VPWR VGND sg13g2_a22oi_1
X_5845_ VPWR VGND _2752_ _2800_ _2802_ _2781_ _2803_ _2799_ sg13g2_a221oi_1
X_5776_ blue\[0\] _2689_ _2693_ _2718_ _2736_ VPWR VGND sg13g2_and4_1
X_4727_ _0729_ VPWR _1734_ VGND _1015_ _1729_ sg13g2_o21ai_1
X_4658_ _1664_ VPWR _1665_ VGND _0740_ net891 sg13g2_o21ai_1
X_3609_ videogen.test_lut_thingy.pixel_feeder_inst.row\[5\]\[1\] net871 _0850_ _0514_
+ VPWR VGND sg13g2_mux2_1
X_4589_ net687 _1592_ _1593_ _1595_ _1596_ VPWR VGND sg13g2_nor4_1
XFILLER_1_538 VPWR VGND sg13g2_decap_8
X_6328_ net200 VGND VPWR _0387_ videogen.another_shader.video_y\[1\] net725 sg13g2_dfrbpq_2
X_6259_ net342 VGND VPWR _0318_ videogen.test_lut_thingy.pixel_feeder_inst.v_pix\[2\]
+ net724 sg13g2_dfrbpq_1
XFILLER_29_222 VPWR VGND sg13g2_fill_1
XFILLER_41_910 VPWR VGND sg13g2_decap_8
XFILLER_16_96 VPWR VGND sg13g2_decap_8
XFILLER_9_605 VPWR VGND sg13g2_fill_2
XFILLER_41_987 VPWR VGND sg13g2_decap_8
XFILLER_32_62 VPWR VGND sg13g2_fill_2
XFILLER_32_95 VPWR VGND sg13g2_fill_2
XFILLER_4_376 VPWR VGND sg13g2_decap_8
X_6469__432 VPWR VGND net432 sg13g2_tiehi
XFILLER_0_560 VPWR VGND sg13g2_decap_8
XFILLER_48_542 VPWR VGND sg13g2_fill_2
X_3960_ _1010_ _1012_ _0355_ VPWR VGND sg13g2_nor2_1
X_3891_ _0897_ _0968_ _0322_ VPWR VGND sg13g2_nor2_1
XFILLER_31_453 VPWR VGND sg13g2_fill_2
X_5630_ VPWR _2607_ net610 VGND sg13g2_inv_1
X_5561_ _2540_ _2544_ _2537_ _2545_ VPWR VGND sg13g2_nand3_1
X_5492_ VGND VPWR _2478_ _2477_ _2473_ sg13g2_or2_1
X_4512_ net697 VPWR _1519_ VGND videogen.test_lut_thingy.pixel_feeder_inst.row\[38\]\[3\]
+ net638 sg13g2_o21ai_1
X_4443_ _1450_ net652 videogen.test_lut_thingy.pixel_feeder_inst.row\[0\]\[1\] VPWR
+ VGND sg13g2_nand2b_1
X_4374_ videogen.test_lut_thingy.pixel_feeder_inst.row\[53\]\[2\] net624 _1381_ VPWR
+ VGND sg13g2_nor2_1
Xfanout639 net640 net639 VPWR VGND sg13g2_buf_8
X_6113_ net762 net804 _0173_ VPWR VGND sg13g2_nor2_1
X_3325_ VPWR _0718_ videogen.another_shader.video_y\[8\] VGND sg13g2_inv_1
Xfanout617 net618 net617 VPWR VGND sg13g2_buf_8
Xfanout628 net630 net628 VPWR VGND sg13g2_buf_8
XFILLER_39_520 VPWR VGND sg13g2_decap_8
X_6044_ net764 net806 _0105_ VPWR VGND sg13g2_nor2_1
XFILLER_39_553 VPWR VGND sg13g2_fill_2
XFILLER_37_29 VPWR VGND sg13g2_fill_1
XFILLER_2_1007 VPWR VGND sg13g2_decap_8
X_6563__453 VPWR VGND net453 sg13g2_tiehi
XFILLER_22_431 VPWR VGND sg13g2_fill_2
XFILLER_34_291 VPWR VGND sg13g2_fill_2
X_5828_ _2786_ _0755_ _2784_ VPWR VGND sg13g2_xnor2_1
X_5759_ _2719_ blue\[1\] net614 VPWR VGND sg13g2_xnor2_1
XFILLER_6_619 VPWR VGND sg13g2_fill_1
XFILLER_2_836 VPWR VGND sg13g2_decap_8
XFILLER_1_379 VPWR VGND sg13g2_decap_8
XFILLER_45_545 VPWR VGND sg13g2_decap_4
XFILLER_33_707 VPWR VGND sg13g2_fill_2
XFILLER_14_921 VPWR VGND sg13g2_decap_4
X_4090_ _0393_ net893 _1103_ _1104_ VPWR VGND sg13g2_and3_1
XFILLER_49_862 VPWR VGND sg13g2_decap_8
XFILLER_48_372 VPWR VGND sg13g2_decap_8
XFILLER_24_718 VPWR VGND sg13g2_decap_8
X_4992_ _1999_ _1994_ _1996_ _1997_ VPWR VGND sg13g2_and3_1
XFILLER_17_770 VPWR VGND sg13g2_fill_2
X_3943_ net846 _1000_ _1001_ _0349_ VPWR VGND sg13g2_nor3_1
X_3874_ _0954_ VPWR _0957_ VGND videogen.test_lut_thingy.pixel_feeder_inst.v_pix\[1\]
+ _0951_ sg13g2_o21ai_1
X_5613_ _2589_ _2588_ _2590_ VPWR VGND sg13g2_xor2_1
X_6600__95 VPWR VGND net95 sg13g2_tiehi
X_6593_ net187 VGND VPWR _0648_ videogen.test_lut_thingy.pixel_feeder_inst.row\[59\]\[2\]
+ _0235_ sg13g2_dfrbpq_1
X_5544_ _2528_ _2487_ _2485_ VPWR VGND sg13g2_nand2b_1
X_5475_ _2461_ red\[2\] _2460_ VPWR VGND sg13g2_xnor2_1
X_4426_ videogen.test_lut_thingy.pixel_feeder_inst.row\[21\]\[1\] net629 _1433_ VPWR
+ VGND sg13g2_nor2_1
X_6587__239 VPWR VGND net239 sg13g2_tiehi
XFILLER_48_28 VPWR VGND sg13g2_decap_8
X_4357_ net688 VPWR _1364_ VGND videogen.test_lut_thingy.pixel_feeder_inst.row\[58\]\[2\]
+ net635 sg13g2_o21ai_1
X_4288_ _1295_ _1294_ _1289_ VPWR VGND sg13g2_nand2b_1
X_6027_ net795 net838 _0088_ VPWR VGND sg13g2_nor2_1
X_6524__201 VPWR VGND net201 sg13g2_tiehi
XFILLER_11_913 VPWR VGND sg13g2_decap_4
XFILLER_22_250 VPWR VGND sg13g2_fill_1
XFILLER_23_773 VPWR VGND sg13g2_decap_8
XFILLER_10_478 VPWR VGND sg13g2_decap_8
XFILLER_13_64 VPWR VGND sg13g2_decap_8
XFILLER_6_449 VPWR VGND sg13g2_decap_4
XFILLER_2_600 VPWR VGND sg13g2_decap_8
XFILLER_49_114 VPWR VGND sg13g2_decap_8
XFILLER_2_677 VPWR VGND sg13g2_decap_8
X_6529__145 VPWR VGND net145 sg13g2_tiehi
XFILLER_18_534 VPWR VGND sg13g2_decap_8
XFILLER_46_876 VPWR VGND sg13g2_decap_8
XFILLER_9_254 VPWR VGND sg13g2_fill_1
X_3590_ net883 videogen.test_lut_thingy.pixel_feeder_inst.row\[56\]\[0\] _0846_ _0529_
+ VPWR VGND sg13g2_mux2_1
XFILLER_6_950 VPWR VGND sg13g2_decap_8
X_5260_ _2259_ _2258_ _1250_ VPWR VGND sg13g2_nand2b_1
X_4211_ _1218_ _1195_ _1207_ VPWR VGND sg13g2_xnor2_1
X_5191_ _2190_ _1209_ _2189_ VPWR VGND sg13g2_nand2_1
X_4142_ _1149_ _1140_ _1148_ VPWR VGND sg13g2_xnor2_1
X_4073_ VGND VPWR _0906_ _1092_ _1093_ _0929_ sg13g2_a21oi_1
XFILLER_36_320 VPWR VGND sg13g2_decap_8
X_4975_ _1966_ _1975_ _1982_ VPWR VGND _1964_ sg13g2_nand3b_1
XFILLER_36_397 VPWR VGND sg13g2_fill_1
X_3926_ VGND VPWR videogen.test_lut_thingy.pixel_feeder_inst.h_counter\[2\] _0989_
+ _0991_ videogen.test_lut_thingy.pixel_feeder_inst.h_counter\[3\] sg13g2_a21oi_1
XFILLER_20_721 VPWR VGND sg13g2_decap_8
XFILLER_20_732 VPWR VGND sg13g2_fill_1
X_6645_ net451 VGND VPWR _0700_ serialize.shift_reg_g\[7\] clknet_3_5__leaf_clk_regs
+ sg13g2_dfrbpq_1
X_3857_ net494 net749 _0303_ VPWR VGND sg13g2_and2_1
X_3788_ _0910_ _0913_ net16 VPWR VGND sg13g2_nor2b_1
X_6576_ net345 VGND VPWR _0631_ videogen.test_lut_thingy.pixel_feeder_inst.row\[38\]\[1\]
+ _0218_ sg13g2_dfrbpq_1
XFILLER_30_1023 VPWR VGND sg13g2_decap_4
X_5527_ VPWR _2512_ _2511_ VGND sg13g2_inv_1
X_5458_ _2444_ red\[5\] _2442_ VPWR VGND sg13g2_xnor2_1
X_4409_ videogen.test_lut_thingy.pixel_feeder_inst.row\[27\]\[1\] net656 _1416_ VPWR
+ VGND sg13g2_nor2_1
X_5389_ _2382_ _2366_ _2379_ VPWR VGND sg13g2_nand2_1
XFILLER_8_1013 VPWR VGND sg13g2_decap_8
XFILLER_28_832 VPWR VGND sg13g2_fill_1
XFILLER_43_835 VPWR VGND sg13g2_decap_8
XFILLER_24_41 VPWR VGND sg13g2_decap_4
XFILLER_11_732 VPWR VGND sg13g2_fill_1
XFILLER_6_213 VPWR VGND sg13g2_fill_2
XFILLER_3_931 VPWR VGND sg13g2_decap_8
XFILLER_1_56 VPWR VGND sg13g2_decap_8
XFILLER_37_139 VPWR VGND sg13g2_decap_4
XFILLER_46_662 VPWR VGND sg13g2_decap_4
XFILLER_46_684 VPWR VGND sg13g2_fill_1
XFILLER_45_161 VPWR VGND sg13g2_fill_2
X_6507__273 VPWR VGND net273 sg13g2_tiehi
XFILLER_34_824 VPWR VGND sg13g2_fill_1
X_4760_ _1767_ videogen.another_shader.time_cnt\[28\] _1764_ VPWR VGND sg13g2_xnor2_1
XFILLER_14_1018 VPWR VGND sg13g2_decap_8
X_4691_ videogen.another_shader.time_cnt\[5\] net713 _1698_ VPWR VGND sg13g2_nor2_1
X_3711_ net862 videogen.test_lut_thingy.pixel_feeder_inst.row\[18\]\[2\] _0873_ _0313_
+ VPWR VGND sg13g2_mux2_1
X_6430_ net53 VGND VPWR _0485_ videogen.test_lut_thingy.pixel_feeder_inst.row\[31\]\[0\]
+ _0081_ sg13g2_dfrbpq_1
X_3642_ net616 _0803_ _0858_ VPWR VGND sg13g2_nor2_2
X_6477__383 VPWR VGND net383 sg13g2_tiehi
X_6361_ net158 VGND VPWR _0420_ red\[6\] net734 sg13g2_dfrbpq_1
X_5312_ _2305_ _2217_ _2277_ VPWR VGND sg13g2_xnor2_1
X_3573_ videogen.test_lut_thingy.pixel_feeder_inst.row\[53\]\[2\] net864 _0843_ _0543_
+ VPWR VGND sg13g2_mux2_1
XFILLER_46_0 VPWR VGND sg13g2_decap_4
X_6292_ net276 VGND VPWR _0351_ videogen.another_shader.time_cnt\[7\] net731 sg13g2_dfrbpq_2
X_5243_ _2225_ _2232_ _2228_ _2242_ VPWR VGND sg13g2_mux2_1
Xhold19 serialize.shift_reg_r\[5\] VPWR VGND net507 sg13g2_dlygate4sd3_1
X_5174_ _0406_ _2168_ _2176_ VPWR VGND sg13g2_nand2_1
X_4125_ VGND VPWR net675 videogen.fancy_shader.shader_counter_reg\[2\] _1132_ _1131_
+ sg13g2_a21oi_1
X_6367__152 VPWR VGND net152 sg13g2_tiehi
X_4056_ VGND VPWR _1081_ _1079_ _1067_ sg13g2_or2_1
XFILLER_40_827 VPWR VGND sg13g2_decap_8
X_4958_ VGND VPWR _1965_ _1964_ _1962_ sg13g2_or2_1
XFILLER_40_838 VPWR VGND sg13g2_decap_8
X_4889_ _1894_ _1886_ _1884_ _1896_ VPWR VGND sg13g2_a21o_1
X_3909_ _0980_ videogen.test_lut_thingy.pixel_feeder_inst.v_counter\[1\] videogen.test_lut_thingy.pixel_feeder_inst.v_counter\[0\]
+ VPWR VGND sg13g2_xnor2_1
X_6628_ net243 VGND VPWR _0683_ videogen.test_lut_thingy.pixel_feeder_inst.row\[21\]\[2\]
+ _0259_ sg13g2_dfrbpq_1
XFILLER_20_573 VPWR VGND sg13g2_fill_1
X_6559_ net469 VGND VPWR _0614_ videogen.test_lut_thingy.pixel_feeder_inst.row\[42\]\[0\]
+ _0201_ sg13g2_dfrbpq_1
X_6571__393 VPWR VGND net393 sg13g2_tiehi
XFILLER_0_956 VPWR VGND sg13g2_decap_8
XFILLER_48_916 VPWR VGND sg13g2_decap_8
XFILLER_28_640 VPWR VGND sg13g2_fill_1
XFILLER_28_651 VPWR VGND sg13g2_fill_2
XFILLER_31_838 VPWR VGND sg13g2_decap_8
XFILLER_2_282 VPWR VGND sg13g2_decap_8
XFILLER_39_949 VPWR VGND sg13g2_decap_8
XFILLER_47_993 VPWR VGND sg13g2_decap_8
X_5930_ _2857_ net748 net501 net753 red_tmds_par\[2\] VPWR VGND sg13g2_a22oi_1
XFILLER_19_695 VPWR VGND sg13g2_decap_8
X_5861_ net900 VPWR _2817_ VGND net669 hsync sg13g2_o21ai_1
X_4812_ _1815_ _1818_ _1819_ VPWR VGND sg13g2_and2_1
XFILLER_15_890 VPWR VGND sg13g2_fill_1
X_5792_ _2744_ tmds_blue.dc_balancing_reg\[4\] _2750_ _2752_ VPWR VGND sg13g2_a21o_2
X_4743_ _1750_ videogen.another_shader.time_cnt\[19\] _1744_ VPWR VGND sg13g2_nand2_1
XFILLER_30_871 VPWR VGND sg13g2_fill_1
X_6413_ net86 VGND VPWR _0468_ tmds_green.dc_balancing_reg\[4\] net740 sg13g2_dfrbpq_2
X_4674_ VGND VPWR _1681_ net716 videogen.another_shader.time_cnt\[3\] sg13g2_or2_1
X_3625_ net886 videogen.test_lut_thingy.pixel_feeder_inst.row\[62\]\[0\] _0853_ _0501_
+ VPWR VGND sg13g2_mux2_1
X_3556_ _0803_ _0828_ _0840_ VPWR VGND sg13g2_nor2_2
X_6344_ net175 VGND VPWR _0403_ blue\[1\] net741 sg13g2_dfrbpq_2
X_6275_ net310 VGND VPWR _0334_ videogen.test_lut_thingy.pixel_feeder_inst.h_counter\[2\]
+ net718 sg13g2_dfrbpq_1
X_5226_ _2219_ _2223_ _2215_ _2225_ VPWR VGND sg13g2_mux2_1
X_3487_ videogen.test_lut_thingy.pixel_feeder_inst.row\[41\]\[0\] net888 _0823_ _0618_
+ VPWR VGND sg13g2_mux2_1
X_5157_ _2163_ net676 net681 VPWR VGND sg13g2_nand2_1
X_5088_ _1685_ _2094_ _2095_ VPWR VGND sg13g2_nor2_1
X_4108_ _1115_ videogen.another_shader.video_x\[1\] videogen.fancy_shader.shader_counter_reg\[1\]
+ VPWR VGND sg13g2_nand2_1
XFILLER_38_993 VPWR VGND sg13g2_decap_8
X_4039_ videogen.fancy_shader.shader_counter_reg\[2\] _1066_ _1069_ VPWR VGND sg13g2_and2_1
XFILLER_40_613 VPWR VGND sg13g2_decap_8
XFILLER_25_687 VPWR VGND sg13g2_fill_2
X_6546__64 VPWR VGND net64 sg13g2_tiehi
XFILLER_43_462 VPWR VGND sg13g2_fill_1
XFILLER_43_451 VPWR VGND sg13g2_decap_8
XFILLER_43_440 VPWR VGND sg13g2_fill_1
XFILLER_44_996 VPWR VGND sg13g2_decap_8
XFILLER_15_164 VPWR VGND sg13g2_fill_2
XFILLER_31_646 VPWR VGND sg13g2_fill_1
XFILLER_30_178 VPWR VGND sg13g2_fill_2
XFILLER_8_875 VPWR VGND sg13g2_decap_8
XFILLER_7_363 VPWR VGND sg13g2_fill_2
X_6357__162 VPWR VGND net162 sg13g2_tiehi
X_3410_ _0794_ net653 _0793_ VPWR VGND sg13g2_nand2_2
X_4390_ net664 _1391_ _1396_ _1397_ VPWR VGND sg13g2_nor3_1
X_3341_ VPWR _0734_ net681 VGND sg13g2_inv_1
XFILLER_3_591 VPWR VGND sg13g2_decap_8
X_6060_ net769 net812 _0121_ VPWR VGND sg13g2_nor2_1
X_5011_ _2015_ _2012_ _2017_ _2018_ VPWR VGND sg13g2_a21o_2
XFILLER_26_418 VPWR VGND sg13g2_fill_2
XFILLER_47_790 VPWR VGND sg13g2_decap_8
X_6364__155 VPWR VGND net155 sg13g2_tiehi
XFILLER_35_930 VPWR VGND sg13g2_fill_1
X_5913_ VPWR _0694_ _2848_ VGND sg13g2_inv_1
X_5844_ _2799_ _2777_ _2802_ VPWR VGND sg13g2_xor2_1
X_5775_ VGND VPWR _2695_ _2725_ _2735_ _2724_ sg13g2_a21oi_1
X_4726_ videogen.another_shader.time_cnt\[13\] videogen.another_shader.time_cnt\[12\]
+ videogen.another_shader.time_cnt\[14\] _1733_ VPWR VGND _1728_ sg13g2_nand4_1
XFILLER_21_189 VPWR VGND sg13g2_decap_4
X_4657_ _1616_ _1663_ net891 _1664_ VPWR VGND sg13g2_nand3_1
X_3608_ videogen.test_lut_thingy.pixel_feeder_inst.row\[5\]\[2\] net861 _0850_ _0515_
+ VPWR VGND sg13g2_mux2_1
X_4588_ _1594_ VPWR _1595_ VGND videogen.test_lut_thingy.pixel_feeder_inst.row\[7\]\[0\]
+ net657 sg13g2_o21ai_1
XFILLER_1_517 VPWR VGND sg13g2_decap_8
X_6327_ net202 VGND VPWR _0386_ videogen.another_shader.video_y\[0\] net726 sg13g2_dfrbpq_2
X_6371__148 VPWR VGND net148 sg13g2_tiehi
X_3539_ videogen.test_lut_thingy.pixel_feeder_inst.row\[51\]\[1\] net872 _0836_ _0579_
+ VPWR VGND sg13g2_mux2_1
XFILLER_27_1028 VPWR VGND sg13g2_fill_1
X_6258_ net344 VGND VPWR _0317_ videogen.test_lut_thingy.pixel_feeder_inst.v_pix\[1\]
+ net724 sg13g2_dfrbpq_2
X_6236__380 VPWR VGND net380 sg13g2_tiehi
X_5209_ _2198_ _2204_ _2208_ VPWR VGND sg13g2_nor2_1
X_6189_ net792 net835 _0249_ VPWR VGND sg13g2_nor2_1
XFILLER_44_215 VPWR VGND sg13g2_decap_4
XFILLER_25_495 VPWR VGND sg13g2_fill_1
XFILLER_41_966 VPWR VGND sg13g2_decap_8
XFILLER_9_628 VPWR VGND sg13g2_fill_1
XFILLER_5_845 VPWR VGND sg13g2_fill_2
XFILLER_5_834 VPWR VGND sg13g2_decap_8
XFILLER_5_878 VPWR VGND sg13g2_decap_8
X_6387__122 VPWR VGND net122 sg13g2_tiehi
X_6649__389 VPWR VGND net389 sg13g2_tiehi
XFILLER_44_793 VPWR VGND sg13g2_decap_8
XFILLER_16_473 VPWR VGND sg13g2_decap_4
XFILLER_32_933 VPWR VGND sg13g2_fill_1
X_3890_ _0966_ net705 _0968_ VPWR VGND sg13g2_xor2_1
XFILLER_16_495 VPWR VGND sg13g2_fill_1
XFILLER_32_955 VPWR VGND sg13g2_fill_2
X_5560_ _2519_ _2522_ _2542_ _2543_ _2544_ VPWR VGND sg13g2_or4_1
XFILLER_8_672 VPWR VGND sg13g2_fill_1
XFILLER_8_650 VPWR VGND sg13g2_decap_8
X_5491_ _2477_ _2474_ _2476_ VPWR VGND sg13g2_nand2_1
X_4511_ videogen.test_lut_thingy.pixel_feeder_inst.row\[36\]\[3\] net651 _1518_ VPWR
+ VGND sg13g2_nor2_1
X_4442_ videogen.test_lut_thingy.pixel_feeder_inst.row\[1\]\[1\] net622 _1449_ VPWR
+ VGND sg13g2_nor2_1
XFILLER_7_193 VPWR VGND sg13g2_fill_1
X_4373_ videogen.test_lut_thingy.pixel_feeder_inst.row\[54\]\[2\] net635 _1380_ VPWR
+ VGND sg13g2_nor2_1
Xfanout629 net630 net629 VPWR VGND sg13g2_buf_1
Xfanout618 _0772_ net618 VPWR VGND sg13g2_buf_8
X_3324_ _0717_ videogen.another_shader.video_y\[9\] VPWR VGND sg13g2_inv_2
X_6112_ net766 net808 _0172_ VPWR VGND sg13g2_nor2_1
X_6043_ net765 net807 _0104_ VPWR VGND sg13g2_nor2_1
XFILLER_39_543 VPWR VGND sg13g2_fill_1
XFILLER_26_226 VPWR VGND sg13g2_fill_2
XFILLER_23_911 VPWR VGND sg13g2_fill_1
XFILLER_35_771 VPWR VGND sg13g2_fill_1
XFILLER_22_443 VPWR VGND sg13g2_fill_2
X_5827_ VPWR _2785_ _2784_ VGND sg13g2_inv_1
XFILLER_33_1010 VPWR VGND sg13g2_decap_8
XFILLER_22_487 VPWR VGND sg13g2_decap_4
X_5758_ net614 _2687_ _2718_ VPWR VGND sg13g2_xor2_1
X_4709_ _1709_ VPWR _1716_ VGND _1704_ _1710_ sg13g2_o21ai_1
X_5689_ _2653_ _2651_ _2655_ VPWR VGND sg13g2_xor2_1
XFILLER_2_815 VPWR VGND sg13g2_decap_8
XFILLER_1_358 VPWR VGND sg13g2_decap_8
XFILLER_49_307 VPWR VGND sg13g2_fill_1
XFILLER_40_1014 VPWR VGND sg13g2_decap_8
X_6347__172 VPWR VGND net172 sg13g2_tiehi
XFILLER_25_281 VPWR VGND sg13g2_fill_1
XFILLER_9_447 VPWR VGND sg13g2_decap_8
XFILLER_13_498 VPWR VGND sg13g2_fill_1
XFILLER_9_469 VPWR VGND sg13g2_decap_4
XFILLER_4_130 VPWR VGND sg13g2_decap_4
XFILLER_5_697 VPWR VGND sg13g2_fill_2
XFILLER_5_686 VPWR VGND sg13g2_decap_8
X_6354__165 VPWR VGND net165 sg13g2_tiehi
XFILLER_49_841 VPWR VGND sg13g2_decap_8
XFILLER_36_535 VPWR VGND sg13g2_decap_8
X_4991_ _1998_ _1996_ _1997_ VPWR VGND sg13g2_nand2_1
X_6361__158 VPWR VGND net158 sg13g2_tiehi
X_3942_ _1001_ videogen.another_shader.time_cnt\[5\] videogen.another_shader.time_cnt\[4\]
+ _0997_ VPWR VGND sg13g2_and3_2
X_3873_ videogen.test_lut_thingy.pixel_feeder_inst.v_pix\[1\] _0951_ _0956_ VPWR VGND
+ sg13g2_and2_1
XFILLER_32_774 VPWR VGND sg13g2_decap_8
X_6592_ net195 VGND VPWR _0647_ videogen.test_lut_thingy.pixel_feeder_inst.row\[59\]\[1\]
+ _0234_ sg13g2_dfrbpq_1
X_5612_ _2589_ _2567_ _2583_ VPWR VGND sg13g2_xnor2_1
XFILLER_31_295 VPWR VGND sg13g2_fill_2
X_5543_ _2527_ tmds_red.dc_balancing_reg\[3\] _2525_ VPWR VGND sg13g2_xnor2_1
XFILLER_8_480 VPWR VGND sg13g2_fill_1
X_5474_ VGND VPWR _2459_ _2460_ _2454_ _0753_ sg13g2_a21oi_2
X_4425_ _1431_ VPWR _1432_ VGND videogen.test_lut_thingy.pixel_feeder_inst.row\[22\]\[1\]
+ net640 sg13g2_o21ai_1
X_4356_ _1362_ VPWR _1363_ VGND _1327_ _1338_ sg13g2_o21ai_1
XFILLER_24_1009 VPWR VGND sg13g2_decap_8
X_4287_ _1294_ _1293_ _1290_ VPWR VGND sg13g2_nand2b_1
X_6026_ net794 net837 _0087_ VPWR VGND sg13g2_nor2_1
XFILLER_27_502 VPWR VGND sg13g2_fill_1
XFILLER_39_373 VPWR VGND sg13g2_fill_1
XFILLER_11_947 VPWR VGND sg13g2_decap_8
XFILLER_22_273 VPWR VGND sg13g2_fill_1
XFILLER_2_656 VPWR VGND sg13g2_decap_8
XFILLER_1_188 VPWR VGND sg13g2_fill_1
XFILLER_46_855 VPWR VGND sg13g2_decap_8
XFILLER_45_365 VPWR VGND sg13g2_fill_1
XFILLER_33_516 VPWR VGND sg13g2_fill_1
X_6284__292 VPWR VGND net292 sg13g2_tiehi
XFILLER_14_752 VPWR VGND sg13g2_decap_4
X_6618__439 VPWR VGND net439 sg13g2_tiehi
X_4210_ _1217_ _1210_ _1216_ VPWR VGND sg13g2_nand2_1
X_5190_ _1130_ _1135_ _2184_ _2189_ VPWR VGND sg13g2_nor3_1
X_4141_ VGND VPWR _1141_ _1147_ _1148_ _1142_ sg13g2_a21oi_1
X_4072_ _1090_ _1091_ _0946_ _1092_ VPWR VGND sg13g2_nand3_1
XFILLER_49_693 VPWR VGND sg13g2_decap_8
XFILLER_37_833 VPWR VGND sg13g2_fill_2
XFILLER_36_332 VPWR VGND sg13g2_fill_1
X_4974_ _1732_ _1965_ _1980_ _1981_ VPWR VGND sg13g2_nor3_1
XFILLER_24_549 VPWR VGND sg13g2_fill_2
X_3925_ _0986_ _0990_ _0334_ VPWR VGND sg13g2_nor2_1
X_6644_ net459 VGND VPWR _0699_ serialize.shift_reg_g\[6\] clknet_3_6__leaf_clk_regs
+ sg13g2_dfrbpq_1
XFILLER_32_571 VPWR VGND sg13g2_decap_8
X_3856_ net497 net749 _0302_ VPWR VGND sg13g2_and2_1
X_3787_ _0909_ VPWR _0913_ VGND _0911_ _0912_ sg13g2_o21ai_1
X_6575_ net354 VGND VPWR _0630_ videogen.test_lut_thingy.pixel_feeder_inst.row\[38\]\[0\]
+ _0217_ sg13g2_dfrbpq_1
XFILLER_20_799 VPWR VGND sg13g2_decap_4
X_5526_ _2511_ _2458_ _2494_ VPWR VGND sg13g2_nand2_1
X_5457_ _2443_ red\[5\] _2440_ VPWR VGND sg13g2_xnor2_1
X_4408_ videogen.test_lut_thingy.pixel_feeder_inst.row\[24\]\[1\] net646 _1415_ VPWR
+ VGND sg13g2_nor2_1
X_6337__182 VPWR VGND net182 sg13g2_tiehi
X_5388_ _2381_ _1210_ _2380_ VPWR VGND sg13g2_xnor2_1
X_4339_ videogen.test_lut_thingy.pixel_feeder_inst.row\[13\]\[2\] net626 _1346_ VPWR
+ VGND sg13g2_nor2_1
X_6009_ net791 net834 _0070_ VPWR VGND sg13g2_nor2_1
XFILLER_28_811 VPWR VGND sg13g2_fill_1
XFILLER_39_181 VPWR VGND sg13g2_fill_1
XFILLER_27_343 VPWR VGND sg13g2_fill_2
XFILLER_43_814 VPWR VGND sg13g2_decap_8
X_6344__175 VPWR VGND net175 sg13g2_tiehi
X_6422__69 VPWR VGND net69 sg13g2_tiehi
XFILLER_7_715 VPWR VGND sg13g2_fill_2
XFILLER_11_766 VPWR VGND sg13g2_decap_8
XFILLER_7_748 VPWR VGND sg13g2_fill_1
XFILLER_10_254 VPWR VGND sg13g2_fill_1
XFILLER_40_41 VPWR VGND sg13g2_fill_1
XFILLER_3_987 VPWR VGND sg13g2_decap_8
X_6351__168 VPWR VGND net168 sg13g2_tiehi
Xfanout790 net796 net790 VPWR VGND sg13g2_buf_8
XFILLER_1_35 VPWR VGND sg13g2_decap_8
XFILLER_37_107 VPWR VGND sg13g2_decap_8
XFILLER_19_844 VPWR VGND sg13g2_fill_1
XFILLER_33_302 VPWR VGND sg13g2_decap_4
XFILLER_33_335 VPWR VGND sg13g2_fill_2
XFILLER_21_519 VPWR VGND sg13g2_fill_1
X_3710_ net851 videogen.test_lut_thingy.pixel_feeder_inst.row\[18\]\[3\] _0873_ _0314_
+ VPWR VGND sg13g2_mux2_1
XFILLER_14_582 VPWR VGND sg13g2_decap_8
X_4690_ VPWR _1697_ _1696_ VGND sg13g2_inv_1
X_3641_ videogen.test_lut_thingy.pixel_feeder_inst.row\[30\]\[0\] net889 _0857_ _0489_
+ VPWR VGND sg13g2_mux2_1
X_6360_ net159 VGND VPWR _0419_ red\[5\] net727 sg13g2_dfrbpq_2
X_3572_ videogen.test_lut_thingy.pixel_feeder_inst.row\[53\]\[3\] net852 _0843_ _0544_
+ VPWR VGND sg13g2_mux2_1
XFILLER_6_781 VPWR VGND sg13g2_decap_4
X_5311_ _2301_ _2299_ _2303_ _2304_ VPWR VGND sg13g2_a21o_2
X_6514__245 VPWR VGND net245 sg13g2_tiehi
XFILLER_5_280 VPWR VGND sg13g2_decap_4
X_6291_ net278 VGND VPWR _0350_ videogen.another_shader.time_cnt\[6\] net741 sg13g2_dfrbpq_2
X_5242_ _2237_ _2240_ _2241_ VPWR VGND sg13g2_nor2_1
XFILLER_39_0 VPWR VGND sg13g2_decap_4
X_5173_ VGND VPWR videogen.another_shader.time_cnt\[4\] _2145_ _2176_ _1669_ sg13g2_a21oi_1
X_4124_ VGND VPWR _1126_ _1129_ _1131_ _1130_ sg13g2_a21oi_1
Xinput1 ui_in[0] net1 VPWR VGND sg13g2_buf_2
X_4055_ videogen.fancy_shader.shader_counter_reg\[7\] videogen.fancy_shader.shader_counter_reg\[6\]
+ net679 videogen.fancy_shader.shader_counter_reg\[4\] _1080_ VPWR VGND sg13g2_and4_1
XFILLER_37_696 VPWR VGND sg13g2_fill_1
XFILLER_36_195 VPWR VGND sg13g2_fill_2
XFILLER_24_379 VPWR VGND sg13g2_decap_8
X_4957_ _1735_ _1957_ _1960_ _1964_ VPWR VGND sg13g2_nor3_1
X_4888_ VGND VPWR _1886_ _1894_ _1895_ _1884_ sg13g2_a21oi_1
X_3908_ _0978_ _0979_ _0328_ VPWR VGND sg13g2_nor2_1
X_6627_ net259 VGND VPWR _0682_ videogen.test_lut_thingy.pixel_feeder_inst.row\[21\]\[1\]
+ _0258_ sg13g2_dfrbpq_1
X_3839_ _0940_ net710 _0938_ VPWR VGND sg13g2_nand2_1
X_6558_ net473 VGND VPWR _0613_ videogen.test_lut_thingy.pixel_feeder_inst.row\[43\]\[3\]
+ _0200_ sg13g2_dfrbpq_1
XFILLER_4_729 VPWR VGND sg13g2_decap_8
X_5509_ _2492_ _2494_ _2495_ VPWR VGND sg13g2_nor2_2
X_6489_ net327 VGND VPWR _0544_ videogen.test_lut_thingy.pixel_feeder_inst.row\[53\]\[3\]
+ _0140_ sg13g2_dfrbpq_1
XFILLER_0_935 VPWR VGND sg13g2_decap_8
XFILLER_35_74 VPWR VGND sg13g2_fill_1
XFILLER_24_891 VPWR VGND sg13g2_decap_4
XFILLER_35_96 VPWR VGND sg13g2_fill_1
XFILLER_7_556 VPWR VGND sg13g2_fill_1
X_6253__353 VPWR VGND net353 sg13g2_tiehi
XFILLER_39_928 VPWR VGND sg13g2_decap_8
XFILLER_47_972 VPWR VGND sg13g2_decap_8
XFILLER_19_663 VPWR VGND sg13g2_decap_8
XFILLER_46_493 VPWR VGND sg13g2_fill_1
X_5860_ VGND VPWR _2809_ _2816_ _0557_ net643 sg13g2_a21oi_1
X_4811_ _1814_ VPWR _1818_ VGND _1810_ _1817_ sg13g2_o21ai_1
XFILLER_33_132 VPWR VGND sg13g2_fill_1
XFILLER_34_677 VPWR VGND sg13g2_decap_8
X_6397__102 VPWR VGND net102 sg13g2_tiehi
XFILLER_33_187 VPWR VGND sg13g2_decap_8
X_5791_ VGND VPWR _2750_ _2751_ _2744_ tmds_blue.dc_balancing_reg\[4\] sg13g2_a21oi_2
X_4742_ VPWR _1749_ _1748_ VGND sg13g2_inv_1
XFILLER_14_390 VPWR VGND sg13g2_fill_1
XFILLER_21_338 VPWR VGND sg13g2_fill_1
XFILLER_21_349 VPWR VGND sg13g2_fill_1
X_4673_ VGND VPWR videogen.another_shader.time_cnt\[2\] net717 _1680_ _1679_ sg13g2_a21oi_1
X_6412_ net87 VGND VPWR _0467_ tmds_green.dc_balancing_reg\[3\] net740 sg13g2_dfrbpq_1
X_3624_ net876 videogen.test_lut_thingy.pixel_feeder_inst.row\[62\]\[1\] _0853_ _0502_
+ VPWR VGND sg13g2_mux2_1
X_3555_ videogen.test_lut_thingy.pixel_feeder_inst.row\[27\]\[0\] net884 _0839_ _0566_
+ VPWR VGND sg13g2_mux2_1
X_6343_ net176 VGND VPWR _0402_ blue\[0\] net735 sg13g2_dfrbpq_2
X_6274_ net312 VGND VPWR _0333_ videogen.test_lut_thingy.pixel_feeder_inst.h_counter\[1\]
+ net718 sg13g2_dfrbpq_1
X_3486_ videogen.test_lut_thingy.pixel_feeder_inst.row\[41\]\[1\] net879 _0823_ _0619_
+ VPWR VGND sg13g2_mux2_1
X_5225_ _2222_ VPWR _2224_ VGND _2215_ _2219_ sg13g2_o21ai_1
X_5156_ _2162_ _2161_ _1669_ _0402_ VPWR VGND sg13g2_a21o_1
X_6566__441 VPWR VGND net441 sg13g2_tiehi
X_5087_ VGND VPWR _2089_ _2092_ _2094_ _2093_ sg13g2_a21oi_1
X_4107_ net842 _1114_ _0400_ VPWR VGND sg13g2_nor2_1
XFILLER_38_972 VPWR VGND sg13g2_decap_8
X_4038_ _1066_ _1067_ _1068_ _0377_ VPWR VGND sg13g2_nor3_1
X_5989_ net782 net825 _0050_ VPWR VGND sg13g2_nor2_1
XFILLER_24_187 VPWR VGND sg13g2_fill_2
X_6341__178 VPWR VGND net178 sg13g2_tiehi
XFILLER_20_393 VPWR VGND sg13g2_fill_1
XFILLER_0_721 VPWR VGND sg13g2_decap_8
XFILLER_0_743 VPWR VGND sg13g2_decap_8
XFILLER_0_765 VPWR VGND sg13g2_fill_2
XFILLER_48_736 VPWR VGND sg13g2_fill_1
XFILLER_48_769 VPWR VGND sg13g2_decap_8
XFILLER_44_975 VPWR VGND sg13g2_decap_8
XFILLER_31_669 VPWR VGND sg13g2_fill_1
X_3340_ VPWR _0733_ videogen.another_shader.time_cnt\[10\] VGND sg13g2_inv_1
XFILLER_3_570 VPWR VGND sg13g2_decap_8
X_5010_ _2000_ _2016_ _2017_ VPWR VGND sg13g2_and2_1
X_6607__58 VPWR VGND net58 sg13g2_tiehi
X_6446__478 VPWR VGND net478 sg13g2_tiehi
X_5912_ _2848_ net748 net509 net753 green_tmds_par\[1\] VPWR VGND sg13g2_a22oi_1
X_5843_ _2777_ _2799_ _2801_ VPWR VGND sg13g2_and2_1
XFILLER_35_986 VPWR VGND sg13g2_decap_8
XFILLER_21_135 VPWR VGND sg13g2_decap_4
X_5774_ VGND VPWR _2730_ _2731_ _2734_ _2728_ sg13g2_a21oi_1
X_4725_ _1730_ _1731_ _1732_ VPWR VGND sg13g2_and2_1
X_4656_ _1662_ VPWR _1663_ VGND _1627_ _1638_ sg13g2_o21ai_1
X_4587_ VGND VPWR _1594_ net636 videogen.test_lut_thingy.pixel_feeder_inst.row\[6\]\[0\]
+ sg13g2_or2_1
X_3607_ videogen.test_lut_thingy.pixel_feeder_inst.row\[5\]\[3\] net850 _0850_ _0516_
+ VPWR VGND sg13g2_mux2_1
X_6326_ net204 VGND VPWR _0385_ videogen.fancy_shader.shader_counter_reg\[9\] net720
+ sg13g2_dfrbpq_2
X_3538_ videogen.test_lut_thingy.pixel_feeder_inst.row\[51\]\[2\] net862 _0836_ _0580_
+ VPWR VGND sg13g2_mux2_1
X_6257_ net346 VGND VPWR _0316_ videogen.test_lut_thingy.pixel_feeder_inst.v_pix\[0\]
+ net724 sg13g2_dfrbpq_1
X_3469_ videogen.test_lut_thingy.pixel_feeder_inst.row\[38\]\[2\] net865 _0819_ _0632_
+ VPWR VGND sg13g2_mux2_1
X_6188_ net789 net832 _0248_ VPWR VGND sg13g2_nor2_1
X_5208_ _2207_ _1200_ _2190_ VPWR VGND sg13g2_xnor2_1
X_5139_ _1670_ _2141_ _0401_ _2146_ VPWR VGND _2143_ sg13g2_nand4_1
XFILLER_45_728 VPWR VGND sg13g2_decap_8
XFILLER_17_408 VPWR VGND sg13g2_fill_1
XFILLER_25_441 VPWR VGND sg13g2_fill_1
XFILLER_37_290 VPWR VGND sg13g2_decap_4
XFILLER_13_614 VPWR VGND sg13g2_fill_1
XFILLER_41_945 VPWR VGND sg13g2_decap_8
XFILLER_13_647 VPWR VGND sg13g2_fill_2
XFILLER_0_595 VPWR VGND sg13g2_decap_8
XFILLER_48_599 VPWR VGND sg13g2_fill_2
XFILLER_17_986 VPWR VGND sg13g2_fill_2
XFILLER_31_400 VPWR VGND sg13g2_decap_8
XFILLER_31_411 VPWR VGND sg13g2_fill_1
XFILLER_32_945 VPWR VGND sg13g2_decap_8
X_5490_ _2475_ VPWR _2476_ VGND _2442_ _2461_ sg13g2_o21ai_1
X_4510_ videogen.test_lut_thingy.pixel_feeder_inst.row\[37\]\[3\] net627 _1517_ VPWR
+ VGND sg13g2_nor2_1
X_4441_ videogen.test_lut_thingy.pixel_feeder_inst.row\[2\]\[1\] net633 _1448_ VPWR
+ VGND sg13g2_nor2_1
X_6294__272 VPWR VGND net272 sg13g2_tiehi
X_4372_ _1375_ _1376_ _1377_ _1378_ _1379_ VPWR VGND sg13g2_nor4_1
X_6111_ net766 net808 _0171_ VPWR VGND sg13g2_nor2_1
X_3323_ VPWR _0716_ videogen.test_lut_thingy.pixel_feeder_inst.row\[31\]\[0\] VGND
+ sg13g2_inv_1
Xfanout619 net620 net619 VPWR VGND sg13g2_buf_8
X_6042_ net780 net823 _0103_ VPWR VGND sg13g2_nor2_1
XFILLER_39_555 VPWR VGND sg13g2_fill_1
XFILLER_23_901 VPWR VGND sg13g2_fill_1
XFILLER_35_783 VPWR VGND sg13g2_decap_8
X_5826_ _2784_ _2743_ _2746_ VPWR VGND sg13g2_nand2_1
X_5757_ VPWR _2717_ net614 VGND sg13g2_inv_1
X_4708_ _1691_ _1699_ _1705_ _1711_ _1715_ VPWR VGND sg13g2_or4_1
X_5688_ _2651_ _2653_ _2654_ VPWR VGND sg13g2_and2_1
X_4639_ _1646_ net653 videogen.test_lut_thingy.pixel_feeder_inst.row\[36\]\[0\] VPWR
+ VGND sg13g2_nand2b_1
XFILLER_1_304 VPWR VGND sg13g2_fill_1
X_6309_ net242 VGND VPWR _0368_ videogen.another_shader.time_cnt\[24\] net729 sg13g2_dfrbpq_2
XFILLER_1_337 VPWR VGND sg13g2_decap_8
XFILLER_49_319 VPWR VGND sg13g2_decap_8
XFILLER_17_227 VPWR VGND sg13g2_fill_1
XFILLER_45_569 VPWR VGND sg13g2_fill_1
XFILLER_17_238 VPWR VGND sg13g2_decap_8
XFILLER_26_750 VPWR VGND sg13g2_decap_4
XFILLER_33_709 VPWR VGND sg13g2_fill_1
XFILLER_13_433 VPWR VGND sg13g2_fill_2
XFILLER_14_956 VPWR VGND sg13g2_fill_2
XFILLER_40_263 VPWR VGND sg13g2_decap_8
XFILLER_5_643 VPWR VGND sg13g2_fill_1
XFILLER_49_820 VPWR VGND sg13g2_decap_8
XFILLER_1_893 VPWR VGND sg13g2_decap_8
XFILLER_48_330 VPWR VGND sg13g2_decap_8
XFILLER_0_392 VPWR VGND sg13g2_decap_8
XFILLER_49_897 VPWR VGND sg13g2_decap_8
X_4990_ _1965_ VPWR _1997_ VGND _1979_ _1995_ sg13g2_o21ai_1
XFILLER_17_772 VPWR VGND sg13g2_fill_1
XFILLER_17_783 VPWR VGND sg13g2_decap_8
X_3941_ VGND VPWR videogen.another_shader.time_cnt\[4\] _0997_ _1000_ videogen.another_shader.time_cnt\[5\]
+ sg13g2_a21oi_1
XFILLER_32_731 VPWR VGND sg13g2_decap_4
X_3872_ _0951_ _0955_ _0316_ VPWR VGND sg13g2_nor2_1
XFILLER_17_1028 VPWR VGND sg13g2_fill_1
X_6591_ net203 VGND VPWR _0646_ videogen.test_lut_thingy.pixel_feeder_inst.row\[59\]\[0\]
+ _0233_ sg13g2_dfrbpq_1
X_5611_ _2586_ VPWR _2588_ VGND _2574_ _2587_ sg13g2_o21ai_1
X_5542_ VPWR _2526_ _2525_ VGND sg13g2_inv_1
X_5473_ _0753_ _2457_ _2459_ VPWR VGND sg13g2_nor2_1
X_4424_ _1431_ net662 videogen.test_lut_thingy.pixel_feeder_inst.row\[23\]\[1\] VPWR
+ VGND sg13g2_nand2b_1
X_4355_ videogen.test_lut_thingy.pixel_feeder_inst.h_pix\[5\] _1361_ _1362_ VPWR VGND
+ sg13g2_nor2_1
X_6632__191 VPWR VGND net191 sg13g2_tiehi
X_4286_ _1293_ _1291_ _1292_ VPWR VGND sg13g2_xnor2_1
XFILLER_39_352 VPWR VGND sg13g2_fill_1
X_6025_ net794 net837 _0086_ VPWR VGND sg13g2_nor2_1
X_6419__75 VPWR VGND net75 sg13g2_tiehi
XFILLER_39_385 VPWR VGND sg13g2_fill_2
X_6434__45 VPWR VGND net45 sg13g2_tiehi
XFILLER_42_506 VPWR VGND sg13g2_decap_8
XFILLER_14_208 VPWR VGND sg13g2_fill_2
X_5809_ _2716_ _2765_ _2768_ VPWR VGND sg13g2_nor2_1
XFILLER_10_403 VPWR VGND sg13g2_decap_8
XFILLER_11_926 VPWR VGND sg13g2_decap_8
XFILLER_6_407 VPWR VGND sg13g2_fill_2
XFILLER_22_296 VPWR VGND sg13g2_fill_1
XFILLER_6_418 VPWR VGND sg13g2_fill_2
XFILLER_2_635 VPWR VGND sg13g2_decap_8
XFILLER_1_112 VPWR VGND sg13g2_decap_8
XFILLER_1_156 VPWR VGND sg13g2_decap_4
XFILLER_49_149 VPWR VGND sg13g2_decap_8
XFILLER_38_52 VPWR VGND sg13g2_fill_1
XFILLER_46_834 VPWR VGND sg13g2_decap_8
XFILLER_14_720 VPWR VGND sg13g2_decap_4
XFILLER_41_583 VPWR VGND sg13g2_fill_2
XFILLER_10_981 VPWR VGND sg13g2_decap_8
XFILLER_6_985 VPWR VGND sg13g2_decap_8
X_4140_ VGND VPWR net715 videogen.fancy_shader.shader_counter_reg\[4\] _1147_ _1146_
+ sg13g2_a21oi_1
XFILLER_49_661 VPWR VGND sg13g2_fill_1
X_4071_ _0717_ videogen.another_shader.video_y\[8\] _0905_ _1091_ VPWR VGND sg13g2_nor3_1
XFILLER_23_1010 VPWR VGND sg13g2_fill_2
XFILLER_37_867 VPWR VGND sg13g2_fill_1
XFILLER_37_878 VPWR VGND sg13g2_fill_2
X_4973_ _1980_ _1966_ _1975_ VPWR VGND sg13g2_xnor2_1
X_3924_ _0990_ videogen.test_lut_thingy.pixel_feeder_inst.h_counter\[2\] _0989_ VPWR
+ VGND sg13g2_xnor2_1
X_6643_ net467 VGND VPWR _0698_ serialize.shift_reg_g\[5\] clknet_3_7__leaf_clk_regs
+ sg13g2_dfrbpq_1
XFILLER_20_756 VPWR VGND sg13g2_fill_2
XFILLER_20_767 VPWR VGND sg13g2_decap_4
X_3855_ net898 _0945_ _0301_ VPWR VGND sg13g2_and2_1
X_6574_ net362 VGND VPWR _0629_ videogen.test_lut_thingy.pixel_feeder_inst.row\[3\]\[3\]
+ _0216_ sg13g2_dfrbpq_1
X_3786_ VGND VPWR net619 _0783_ _0912_ videogen.test_lut_thingy.pixel_feeder_inst.v_pix\[0\]
+ sg13g2_a21oi_1
X_5525_ _2509_ VPWR _2510_ VGND _2499_ _2507_ sg13g2_o21ai_1
X_5456_ _2442_ red\[4\] _2440_ VPWR VGND sg13g2_xnor2_1
X_4407_ net689 VPWR _1414_ VGND videogen.test_lut_thingy.pixel_feeder_inst.row\[25\]\[1\]
+ net624 sg13g2_o21ai_1
X_5387_ _2380_ _2277_ _2346_ VPWR VGND sg13g2_xnor2_1
X_4338_ videogen.test_lut_thingy.pixel_feeder_inst.row\[15\]\[2\] net659 _1345_ VPWR
+ VGND sg13g2_nor2_1
X_7126_ net666 net12 VPWR VGND sg13g2_buf_1
X_4269_ _1275_ _1262_ _1265_ _1276_ VPWR VGND sg13g2_a21o_1
X_6008_ net793 net838 _0069_ VPWR VGND sg13g2_nor2_1
XFILLER_27_377 VPWR VGND sg13g2_decap_4
XFILLER_42_325 VPWR VGND sg13g2_fill_2
XFILLER_24_10 VPWR VGND sg13g2_fill_1
XFILLER_7_727 VPWR VGND sg13g2_decap_8
XFILLER_6_226 VPWR VGND sg13g2_decap_8
XFILLER_2_410 VPWR VGND sg13g2_decap_8
XFILLER_3_966 VPWR VGND sg13g2_decap_8
XFILLER_2_465 VPWR VGND sg13g2_decap_8
XFILLER_1_14 VPWR VGND sg13g2_decap_8
Xfanout780 net782 net780 VPWR VGND sg13g2_buf_8
XFILLER_19_801 VPWR VGND sg13g2_fill_1
Xfanout791 net792 net791 VPWR VGND sg13g2_buf_8
XFILLER_46_620 VPWR VGND sg13g2_fill_1
XFILLER_18_322 VPWR VGND sg13g2_fill_1
XFILLER_19_867 VPWR VGND sg13g2_fill_1
XFILLER_19_856 VPWR VGND sg13g2_fill_1
XFILLER_14_561 VPWR VGND sg13g2_fill_1
XFILLER_14_594 VPWR VGND sg13g2_fill_1
X_3640_ videogen.test_lut_thingy.pixel_feeder_inst.row\[30\]\[1\] net878 _0857_ _0490_
+ VPWR VGND sg13g2_mux2_1
X_3571_ _0778_ _0807_ _0843_ VPWR VGND sg13g2_nor2_2
X_6290_ net280 VGND VPWR _0349_ videogen.another_shader.time_cnt\[5\] net728 sg13g2_dfrbpq_2
X_6219__408 VPWR VGND net408 sg13g2_tiehi
X_5310_ VGND VPWR _2301_ _2302_ _2303_ _2299_ sg13g2_a21oi_1
X_5241_ _2240_ _2238_ _2239_ VPWR VGND sg13g2_xnor2_1
X_5172_ _0405_ _2168_ _2175_ VPWR VGND sg13g2_nand2_1
X_4123_ _1130_ videogen.another_shader.video_y\[2\] videogen.fancy_shader.shader_counter_reg\[2\]
+ VPWR VGND sg13g2_xnor2_1
X_4054_ VGND VPWR videogen.fancy_shader.shader_counter_reg\[6\] _1077_ _1079_ videogen.fancy_shader.shader_counter_reg\[7\]
+ sg13g2_a21oi_1
XFILLER_28_119 VPWR VGND sg13g2_fill_2
Xinput2 ui_in[1] net2 VPWR VGND sg13g2_buf_2
XFILLER_37_642 VPWR VGND sg13g2_decap_8
XFILLER_37_686 VPWR VGND sg13g2_fill_1
XFILLER_37_675 VPWR VGND sg13g2_decap_8
XFILLER_25_837 VPWR VGND sg13g2_fill_1
X_4956_ _1961_ _1958_ _1736_ _1963_ VPWR VGND sg13g2_a21o_1
X_4887_ _1892_ _1891_ _1889_ _1894_ VPWR VGND sg13g2_a21o_1
X_3907_ _0979_ videogen.test_lut_thingy.pixel_feeder_inst.v_counter\[0\] _0949_ VPWR
+ VGND sg13g2_xnor2_1
X_6626_ net275 VGND VPWR _0681_ videogen.test_lut_thingy.pixel_feeder_inst.row\[21\]\[0\]
+ _0257_ sg13g2_dfrbpq_1
XFILLER_20_553 VPWR VGND sg13g2_decap_8
X_3838_ _0931_ VPWR _0939_ VGND net709 _0938_ sg13g2_o21ai_1
X_6456__458 VPWR VGND net458 sg13g2_tiehi
X_6557_ net477 VGND VPWR _0612_ videogen.test_lut_thingy.pixel_feeder_inst.row\[43\]\[2\]
+ _0199_ sg13g2_dfrbpq_1
X_5508_ _2494_ _2493_ VPWR VGND _2488_ sg13g2_nand2b_2
X_3769_ _0884_ net621 videogen.mem_read videogen.mem_row VPWR VGND sg13g2_a21o_2
X_6488_ net331 VGND VPWR _0543_ videogen.test_lut_thingy.pixel_feeder_inst.row\[53\]\[2\]
+ _0139_ sg13g2_dfrbpq_1
XFILLER_0_914 VPWR VGND sg13g2_decap_8
X_5439_ net1 _1565_ _2179_ _2432_ VPWR VGND sg13g2_nor3_1
XFILLER_47_439 VPWR VGND sg13g2_decap_8
XFILLER_28_653 VPWR VGND sg13g2_fill_1
XFILLER_15_303 VPWR VGND sg13g2_decap_8
XFILLER_16_859 VPWR VGND sg13g2_decap_4
XFILLER_43_678 VPWR VGND sg13g2_decap_4
XFILLER_42_144 VPWR VGND sg13g2_decap_8
XFILLER_37_1009 VPWR VGND sg13g2_decap_8
XFILLER_42_155 VPWR VGND sg13g2_fill_2
X_6549__52 VPWR VGND net52 sg13g2_tiehi
XFILLER_30_306 VPWR VGND sg13g2_fill_1
XFILLER_23_380 VPWR VGND sg13g2_fill_2
XFILLER_3_752 VPWR VGND sg13g2_decap_4
XFILLER_39_907 VPWR VGND sg13g2_decap_8
XFILLER_47_951 VPWR VGND sg13g2_decap_8
XFILLER_38_439 VPWR VGND sg13g2_decap_8
XFILLER_46_461 VPWR VGND sg13g2_fill_1
XFILLER_46_450 VPWR VGND sg13g2_decap_8
X_4810_ _1816_ VPWR _1817_ VGND _1792_ _1796_ sg13g2_o21ai_1
XFILLER_22_807 VPWR VGND sg13g2_fill_2
XFILLER_34_645 VPWR VGND sg13g2_fill_1
X_5790_ tmds_blue.dc_balancing_reg\[4\] _2744_ _2749_ _2750_ VPWR VGND sg13g2_nor3_1
XFILLER_21_306 VPWR VGND sg13g2_decap_8
XFILLER_33_166 VPWR VGND sg13g2_decap_4
X_4741_ _1037_ _1742_ _1748_ VPWR VGND sg13g2_nor2_1
XFILLER_14_380 VPWR VGND sg13g2_decap_4
X_4672_ _1678_ _1677_ _1679_ VPWR VGND sg13g2_nor2b_1
X_6411_ net88 VGND VPWR _0466_ tmds_green.dc_balancing_reg\[2\] net740 sg13g2_dfrbpq_1
X_3623_ net861 videogen.test_lut_thingy.pixel_feeder_inst.row\[62\]\[2\] _0853_ _0503_
+ VPWR VGND sg13g2_mux2_1
X_3554_ videogen.test_lut_thingy.pixel_feeder_inst.row\[27\]\[1\] net874 _0839_ _0567_
+ VPWR VGND sg13g2_mux2_1
X_6342_ net177 VGND VPWR _0401_ display_enable net728 sg13g2_dfrbpq_1
X_6273_ net314 VGND VPWR _0332_ videogen.test_lut_thingy.pixel_feeder_inst.h_counter\[0\]
+ net725 sg13g2_dfrbpq_1
X_3485_ videogen.test_lut_thingy.pixel_feeder_inst.row\[41\]\[2\] net868 _0823_ _0620_
+ VPWR VGND sg13g2_mux2_1
X_5224_ _2219_ _2222_ _2223_ VPWR VGND sg13g2_nor2_1
X_5155_ _2162_ _2146_ _2149_ _2144_ _0735_ VPWR VGND sg13g2_a22oi_1
XFILLER_29_417 VPWR VGND sg13g2_fill_2
XFILLER_38_951 VPWR VGND sg13g2_decap_8
X_5086_ _2080_ _2083_ _2076_ _2093_ VPWR VGND sg13g2_mux2_1
X_4106_ VGND VPWR _0766_ _0934_ _1114_ _1113_ sg13g2_a21oi_1
X_4037_ videogen.fancy_shader.shader_counter_reg\[1\] _1064_ _1068_ VPWR VGND sg13g2_nor2_1
XFILLER_37_494 VPWR VGND sg13g2_fill_1
XFILLER_24_144 VPWR VGND sg13g2_decap_8
X_5988_ net779 net822 _0049_ VPWR VGND sg13g2_nor2_1
X_4939_ _1941_ _1943_ _1944_ _1946_ VPWR VGND sg13g2_or3_1
XFILLER_20_361 VPWR VGND sg13g2_decap_8
XFILLER_21_11 VPWR VGND sg13g2_fill_2
XFILLER_21_895 VPWR VGND sg13g2_fill_2
X_6609_ net50 VGND VPWR net526 serialize.bit_cnt\[2\] clknet_3_2__leaf_clk_regs sg13g2_dfrbpq_1
XFILLER_21_66 VPWR VGND sg13g2_fill_2
XFILLER_21_88 VPWR VGND sg13g2_fill_2
XFILLER_0_700 VPWR VGND sg13g2_decap_8
XFILLER_43_1024 VPWR VGND sg13g2_decap_4
XFILLER_0_788 VPWR VGND sg13g2_decap_8
XFILLER_47_236 VPWR VGND sg13g2_decap_8
XFILLER_47_247 VPWR VGND sg13g2_fill_1
X_6209__418 VPWR VGND net418 sg13g2_tiehi
XFILLER_28_472 VPWR VGND sg13g2_decap_4
XFILLER_28_494 VPWR VGND sg13g2_fill_2
XFILLER_44_954 VPWR VGND sg13g2_decap_8
XFILLER_43_475 VPWR VGND sg13g2_fill_2
XFILLER_16_689 VPWR VGND sg13g2_fill_2
XFILLER_43_497 VPWR VGND sg13g2_decap_8
XFILLER_31_637 VPWR VGND sg13g2_fill_1
XFILLER_8_811 VPWR VGND sg13g2_fill_2
X_6400__232 VPWR VGND net232 sg13g2_tiehi
X_6474__399 VPWR VGND net399 sg13g2_tiehi
XFILLER_23_4 VPWR VGND sg13g2_decap_8
XFILLER_38_225 VPWR VGND sg13g2_decap_8
XFILLER_38_236 VPWR VGND sg13g2_fill_1
X_5911_ VPWR _0693_ _2847_ VGND sg13g2_inv_1
XFILLER_46_280 VPWR VGND sg13g2_decap_4
XFILLER_35_965 VPWR VGND sg13g2_decap_8
XFILLER_22_604 VPWR VGND sg13g2_fill_2
XFILLER_22_626 VPWR VGND sg13g2_decap_8
X_5842_ _2779_ _2791_ _2800_ VPWR VGND sg13g2_nor2_1
X_5773_ _2733_ tmds_blue.dc_balancing_reg\[1\] _2732_ VPWR VGND sg13g2_xnor2_1
XFILLER_22_648 VPWR VGND sg13g2_fill_2
X_4724_ _1731_ _0731_ _1729_ VPWR VGND sg13g2_nand2_1
X_4655_ _1661_ videogen.test_lut_thingy.pixel_feeder_inst.h_pix\[5\] _1662_ VPWR VGND
+ sg13g2_nor2b_1
X_4586_ videogen.test_lut_thingy.pixel_feeder_inst.row\[5\]\[0\] net625 _1593_ VPWR
+ VGND sg13g2_nor2_1
X_3606_ _0778_ _0815_ _0850_ VPWR VGND sg13g2_nor2_2
X_6325_ net206 VGND VPWR _0384_ videogen.fancy_shader.shader_counter_reg\[8\] net720
+ sg13g2_dfrbpq_2
X_3537_ videogen.test_lut_thingy.pixel_feeder_inst.row\[51\]\[3\] net851 _0836_ _0581_
+ VPWR VGND sg13g2_mux2_1
XFILLER_27_1019 VPWR VGND sg13g2_decap_8
X_3468_ videogen.test_lut_thingy.pixel_feeder_inst.row\[38\]\[3\] net855 _0819_ _0633_
+ VPWR VGND sg13g2_mux2_1
X_6256_ net347 VGND VPWR _0315_ tmds_blue.vsync net735 sg13g2_dfrbpq_1
X_6187_ net789 net832 _0247_ VPWR VGND sg13g2_nor2_1
X_5207_ _2203_ VPWR _2206_ VGND _2199_ _2201_ sg13g2_o21ai_1
X_3399_ _0778_ _0790_ _0791_ VPWR VGND sg13g2_nor2_2
X_5138_ _0401_ _1670_ _2141_ _2143_ _2145_ VPWR VGND sg13g2_and4_1
XFILLER_45_707 VPWR VGND sg13g2_decap_8
X_5069_ _2073_ _2075_ _2072_ _2076_ VPWR VGND sg13g2_nand3_1
XFILLER_41_924 VPWR VGND sg13g2_decap_8
XFILLER_25_453 VPWR VGND sg13g2_decap_8
XFILLER_32_32 VPWR VGND sg13g2_fill_2
XFILLER_5_814 VPWR VGND sg13g2_fill_2
XFILLER_10_1023 VPWR VGND sg13g2_decap_4
XFILLER_4_357 VPWR VGND sg13g2_fill_2
X_6542__80 VPWR VGND net80 sg13g2_tiehi
XFILLER_0_574 VPWR VGND sg13g2_decap_8
XFILLER_36_718 VPWR VGND sg13g2_fill_1
XFILLER_29_781 VPWR VGND sg13g2_fill_2
X_6222__404 VPWR VGND net404 sg13g2_tiehi
XFILLER_31_434 VPWR VGND sg13g2_decap_8
XFILLER_32_957 VPWR VGND sg13g2_fill_1
XFILLER_12_670 VPWR VGND sg13g2_decap_8
X_4440_ net664 _1441_ _1446_ _1447_ VPWR VGND sg13g2_nor3_1
X_4371_ videogen.test_lut_thingy.pixel_feeder_inst.row\[61\]\[2\] net626 _1378_ VPWR
+ VGND sg13g2_nor2_1
X_6110_ net766 net808 _0170_ VPWR VGND sg13g2_nor2_1
X_3322_ VPWR _0715_ videogen.test_lut_thingy.pixel_feeder_inst.row\[31\]\[2\] VGND
+ sg13g2_inv_1
X_6041_ net780 net823 _0102_ VPWR VGND sg13g2_nor2_1
XFILLER_27_729 VPWR VGND sg13g2_fill_1
X_5825_ _2783_ _2762_ _2765_ VPWR VGND sg13g2_nand2_1
XFILLER_22_445 VPWR VGND sg13g2_fill_1
X_5756_ _2715_ VPWR _2716_ VGND _2697_ _2710_ sg13g2_o21ai_1
X_5687_ _2653_ _2630_ _2652_ VPWR VGND sg13g2_nand2_1
X_4707_ videogen.another_shader.time_cnt\[8\] net710 _1714_ VPWR VGND sg13g2_and2_1
X_6570__405 VPWR VGND net405 sg13g2_tiehi
X_4638_ videogen.test_lut_thingy.pixel_feeder_inst.row\[37\]\[0\] net626 _1645_ VPWR
+ VGND sg13g2_nor2_1
XFILLER_2_806 VPWR VGND sg13g2_fill_1
X_4569_ videogen.test_lut_thingy.pixel_feeder_inst.row\[17\]\[0\] net623 _1576_ VPWR
+ VGND sg13g2_nor2_1
XFILLER_1_316 VPWR VGND sg13g2_decap_8
X_6308_ net244 VGND VPWR _0367_ videogen.another_shader.time_cnt\[23\] net729 sg13g2_dfrbpq_2
X_6239_ net374 VGND VPWR _0298_ videogen.test_lut_thingy.pixel_feeder_inst.row\[17\]\[2\]
+ _0023_ sg13g2_dfrbpq_1
XFILLER_18_729 VPWR VGND sg13g2_decap_4
XFILLER_41_765 VPWR VGND sg13g2_fill_2
XFILLER_41_787 VPWR VGND sg13g2_decap_8
XFILLER_5_655 VPWR VGND sg13g2_fill_2
XFILLER_4_176 VPWR VGND sg13g2_fill_2
XFILLER_4_47 VPWR VGND sg13g2_fill_2
XFILLER_1_872 VPWR VGND sg13g2_decap_8
XFILLER_0_371 VPWR VGND sg13g2_decap_8
XFILLER_49_876 VPWR VGND sg13g2_decap_8
XFILLER_48_386 VPWR VGND sg13g2_decap_8
XFILLER_36_526 VPWR VGND sg13g2_decap_4
X_3940_ net846 _0999_ _0348_ VPWR VGND sg13g2_nor2_1
XFILLER_44_581 VPWR VGND sg13g2_fill_2
X_3871_ _0954_ VPWR _0955_ VGND videogen.test_lut_thingy.pixel_feeder_inst.v_pix\[0\]
+ _0950_ sg13g2_o21ai_1
XFILLER_16_294 VPWR VGND sg13g2_decap_8
XFILLER_31_231 VPWR VGND sg13g2_decap_4
X_5610_ _2584_ _2585_ _2587_ VPWR VGND sg13g2_nor2_1
X_6590_ net211 VGND VPWR _0645_ videogen.test_lut_thingy.pixel_feeder_inst.row\[63\]\[3\]
+ _0232_ sg13g2_dfrbpq_1
X_5541_ _2487_ _2485_ _2525_ VPWR VGND sg13g2_nor2b_1
XFILLER_9_983 VPWR VGND sg13g2_decap_8
X_5472_ _2458_ _2454_ _2456_ VPWR VGND sg13g2_nand2_2
X_4423_ videogen.test_lut_thingy.pixel_feeder_inst.row\[20\]\[1\] net649 _1430_ VPWR
+ VGND sg13g2_nor2_1
X_4354_ net685 _1349_ _1360_ _1361_ VPWR VGND sg13g2_nor3_1
X_6024_ net794 net837 _0085_ VPWR VGND sg13g2_nor2_1
X_4285_ _1278_ _1269_ _1292_ VPWR VGND sg13g2_xor2_1
XFILLER_39_331 VPWR VGND sg13g2_fill_2
XFILLER_22_264 VPWR VGND sg13g2_decap_8
X_5808_ VGND VPWR _2717_ _2733_ _2767_ _2766_ sg13g2_a21oi_1
X_5739_ _2687_ _2698_ _2699_ VPWR VGND sg13g2_nor2_1
XFILLER_2_614 VPWR VGND sg13g2_decap_8
XFILLER_49_128 VPWR VGND sg13g2_decap_8
XFILLER_38_42 VPWR VGND sg13g2_fill_2
X_6466__438 VPWR VGND net438 sg13g2_tiehi
XFILLER_46_813 VPWR VGND sg13g2_decap_8
XFILLER_38_75 VPWR VGND sg13g2_fill_2
XFILLER_14_743 VPWR VGND sg13g2_decap_4
XFILLER_13_264 VPWR VGND sg13g2_decap_8
XFILLER_10_960 VPWR VGND sg13g2_decap_8
XFILLER_6_964 VPWR VGND sg13g2_decap_8
X_4070_ net670 net671 net672 net673 _1090_ VPWR VGND sg13g2_nor4_1
XFILLER_36_378 VPWR VGND sg13g2_fill_1
XFILLER_45_890 VPWR VGND sg13g2_decap_8
X_4972_ _1966_ _1975_ _1979_ VPWR VGND sg13g2_and2_1
X_6263__334 VPWR VGND net334 sg13g2_tiehi
X_3923_ _0986_ _0988_ _0989_ _0333_ VPWR VGND sg13g2_nor3_1
XFILLER_32_540 VPWR VGND sg13g2_fill_2
X_6642_ net475 VGND VPWR _0697_ serialize.shift_reg_g\[4\] clknet_3_6__leaf_clk_regs
+ sg13g2_dfrbpq_1
X_3854_ _0942_ _0944_ _0945_ VPWR VGND sg13g2_nor2b_1
X_3785_ _0911_ videogen.test_lut_thingy.pixel_feeder_inst.v_pix\[0\] net619 _0783_
+ VPWR VGND sg13g2_and3_2
X_6573_ net377 VGND VPWR _0628_ videogen.test_lut_thingy.pixel_feeder_inst.row\[3\]\[2\]
+ _0215_ sg13g2_dfrbpq_1
X_5524_ _2491_ _2508_ _2509_ VPWR VGND sg13g2_nor2b_1
X_5455_ VGND VPWR red\[5\] _2440_ _2441_ _2439_ sg13g2_a21oi_1
X_4406_ _1412_ VPWR _1413_ VGND net891 _0747_ sg13g2_o21ai_1
X_5386_ _2379_ _2368_ _2375_ VPWR VGND sg13g2_xnor2_1
X_7125_ videogen.mem_row net11 VPWR VGND sg13g2_buf_8
XFILLER_8_1027 VPWR VGND sg13g2_fill_2
X_4337_ net692 VPWR _1344_ VGND videogen.test_lut_thingy.pixel_feeder_inst.row\[12\]\[2\]
+ net648 sg13g2_o21ai_1
X_4268_ _1275_ _1200_ _1266_ VPWR VGND sg13g2_nand2_1
X_6007_ net779 net822 _0068_ VPWR VGND sg13g2_nor2_1
X_4199_ _1195_ _1204_ _1206_ VPWR VGND sg13g2_nor2b_1
X_6309__242 VPWR VGND net242 sg13g2_tiehi
XFILLER_43_849 VPWR VGND sg13g2_decap_8
XFILLER_7_717 VPWR VGND sg13g2_fill_1
X_6316__224 VPWR VGND net224 sg13g2_tiehi
XFILLER_3_945 VPWR VGND sg13g2_decap_8
XFILLER_2_433 VPWR VGND sg13g2_decap_4
XFILLER_49_63 VPWR VGND sg13g2_decap_8
XFILLER_49_96 VPWR VGND sg13g2_decap_8
Xfanout770 net771 net770 VPWR VGND sg13g2_buf_8
Xfanout781 net782 net781 VPWR VGND sg13g2_buf_8
Xfanout792 net796 net792 VPWR VGND sg13g2_buf_8
XFILLER_19_879 VPWR VGND sg13g2_fill_1
XFILLER_33_337 VPWR VGND sg13g2_fill_1
XFILLER_42_882 VPWR VGND sg13g2_decap_8
X_6421__71 VPWR VGND net71 sg13g2_tiehi
X_3570_ videogen.test_lut_thingy.pixel_feeder_inst.row\[54\]\[0\] net884 _0842_ _0545_
+ VPWR VGND sg13g2_mux2_1
X_5240_ _2188_ _2227_ _2233_ _2239_ VPWR VGND sg13g2_nor3_1
X_5171_ VGND VPWR videogen.another_shader.time_cnt\[3\] _2145_ _2175_ _1669_ sg13g2_a21oi_1
X_4122_ _1129_ _1128_ _1127_ VPWR VGND sg13g2_nand2b_1
X_4053_ _1067_ _1078_ _0382_ VPWR VGND sg13g2_nor2_1
XFILLER_18_890 VPWR VGND sg13g2_fill_1
X_4955_ VGND VPWR _1958_ _1961_ _1962_ _1736_ sg13g2_a21oi_1
XFILLER_24_348 VPWR VGND sg13g2_fill_2
XFILLER_36_197 VPWR VGND sg13g2_fill_1
X_3906_ _0978_ _0954_ _0950_ VPWR VGND sg13g2_nand2b_1
X_4886_ _1891_ _1892_ _1893_ VPWR VGND sg13g2_and2_1
X_6625_ net309 VGND VPWR _0680_ videogen.test_lut_thingy.pixel_feeder_inst.row\[22\]\[3\]
+ _0256_ sg13g2_dfrbpq_1
X_3837_ net615 _0937_ _0938_ _0275_ VPWR VGND sg13g2_nor3_1
X_3768_ _0401_ _0901_ _0002_ VPWR VGND sg13g2_nor2_1
X_6556_ net481 VGND VPWR _0611_ videogen.test_lut_thingy.pixel_feeder_inst.row\[43\]\[1\]
+ _0198_ sg13g2_dfrbpq_1
X_5507_ _2493_ _2489_ tmds_red.dc_balancing_reg\[4\] VPWR VGND sg13g2_nand2b_1
X_3699_ _0790_ _0794_ _0871_ VPWR VGND sg13g2_nor2_2
X_6487_ net335 VGND VPWR _0542_ videogen.test_lut_thingy.pixel_feeder_inst.row\[53\]\[1\]
+ _0138_ sg13g2_dfrbpq_1
X_5438_ _2338_ _2340_ _2341_ _2430_ _2431_ VPWR VGND sg13g2_nor4_1
X_5369_ _2355_ _2361_ _2362_ VPWR VGND sg13g2_nor2_1
XFILLER_47_407 VPWR VGND sg13g2_decap_8
XFILLER_28_621 VPWR VGND sg13g2_fill_2
XFILLER_42_112 VPWR VGND sg13g2_fill_2
XFILLER_28_687 VPWR VGND sg13g2_decap_4
XFILLER_35_65 VPWR VGND sg13g2_decap_8
XFILLER_31_819 VPWR VGND sg13g2_fill_1
XFILLER_7_547 VPWR VGND sg13g2_decap_8
XFILLER_7_569 VPWR VGND sg13g2_fill_2
XFILLER_2_263 VPWR VGND sg13g2_fill_2
XFILLER_47_930 VPWR VGND sg13g2_decap_8
X_4740_ _1746_ videogen.another_shader.time_cnt\[20\] videogen.another_shader.time_cnt\[21\]
+ _1747_ VPWR VGND sg13g2_a21o_1
X_4671_ _1678_ videogen.another_shader.time_cnt\[2\] net717 VPWR VGND sg13g2_xnor2_1
X_6410_ net89 VGND VPWR _0465_ tmds_green.dc_balancing_reg\[1\] net740 sg13g2_dfrbpq_1
X_3622_ net850 videogen.test_lut_thingy.pixel_feeder_inst.row\[62\]\[3\] _0853_ _0504_
+ VPWR VGND sg13g2_mux2_1
X_6341_ net178 VGND VPWR _0400_ hsync net735 sg13g2_dfrbpq_2
X_3553_ videogen.test_lut_thingy.pixel_feeder_inst.row\[27\]\[2\] net863 _0839_ _0568_
+ VPWR VGND sg13g2_mux2_1
XFILLER_6_580 VPWR VGND sg13g2_decap_8
XFILLER_44_0 VPWR VGND sg13g2_fill_1
X_6272_ net316 VGND VPWR _0331_ videogen.test_lut_thingy.pixel_feeder_inst.v_counter\[3\]
+ net718 sg13g2_dfrbpq_1
X_3484_ videogen.test_lut_thingy.pixel_feeder_inst.row\[41\]\[3\] net857 _0823_ _0621_
+ VPWR VGND sg13g2_mux2_1
X_5223_ VPWR _2222_ _2221_ VGND sg13g2_inv_1
X_5154_ _2161_ _2153_ _2160_ VPWR VGND sg13g2_nand2_1
XFILLER_5_1008 VPWR VGND sg13g2_decap_8
X_4105_ _0765_ VPWR _1113_ VGND _0891_ _0934_ sg13g2_o21ai_1
XFILLER_38_930 VPWR VGND sg13g2_decap_8
X_5085_ _2092_ _2090_ _2091_ VPWR VGND sg13g2_xnor2_1
X_4036_ net892 _0881_ _1067_ VPWR VGND sg13g2_nor2_2
XFILLER_25_602 VPWR VGND sg13g2_decap_8
XFILLER_25_646 VPWR VGND sg13g2_decap_8
X_5987_ net768 net810 _0048_ VPWR VGND sg13g2_nor2_1
XFILLER_40_627 VPWR VGND sg13g2_decap_8
X_4938_ VGND VPWR _1945_ _1944_ _1943_ sg13g2_or2_1
X_4869_ _1873_ _1874_ _1871_ _1876_ VPWR VGND sg13g2_nand3_1
X_6608_ net54 VGND VPWR _0663_ blue_tmds_par\[9\] net741 sg13g2_dfrbpq_1
X_6539_ net101 VGND VPWR _0594_ videogen.test_lut_thingy.pixel_feeder_inst.row\[47\]\[0\]
+ _0181_ sg13g2_dfrbpq_1
XFILLER_43_1003 VPWR VGND sg13g2_decap_8
XFILLER_48_716 VPWR VGND sg13g2_fill_2
XFILLER_46_75 VPWR VGND sg13g2_fill_2
XFILLER_46_64 VPWR VGND sg13g2_fill_2
XFILLER_44_933 VPWR VGND sg13g2_decap_8
XFILLER_15_112 VPWR VGND sg13g2_decap_8
XFILLER_31_627 VPWR VGND sg13g2_decap_4
XFILLER_11_395 VPWR VGND sg13g2_fill_1
XFILLER_35_900 VPWR VGND sg13g2_fill_1
X_5910_ _2847_ net748 net518 net753 green_tmds_par\[0\] VPWR VGND sg13g2_a22oi_1
XFILLER_35_944 VPWR VGND sg13g2_decap_8
X_5841_ _2798_ _2795_ _2799_ VPWR VGND sg13g2_xor2_1
XFILLER_15_690 VPWR VGND sg13g2_fill_2
X_5772_ _2732_ _2729_ _2731_ VPWR VGND sg13g2_xnor2_1
X_4723_ _1730_ videogen.another_shader.time_cnt\[12\] _1728_ VPWR VGND sg13g2_nand2_1
XFILLER_30_671 VPWR VGND sg13g2_fill_1
X_4654_ net683 _1649_ _1660_ _1661_ VPWR VGND sg13g2_nor3_1
X_4585_ videogen.test_lut_thingy.pixel_feeder_inst.row\[4\]\[0\] net644 _1592_ VPWR
+ VGND sg13g2_nor2_1
X_3605_ videogen.test_lut_thingy.pixel_feeder_inst.row\[0\]\[0\] net881 _0849_ _0517_
+ VPWR VGND sg13g2_mux2_1
X_6324_ net208 VGND VPWR _0383_ videogen.fancy_shader.shader_counter_reg\[7\] net721
+ sg13g2_dfrbpq_2
X_3536_ _0794_ _0807_ _0836_ VPWR VGND sg13g2_nor2_2
X_6255_ net349 VGND VPWR _0314_ videogen.test_lut_thingy.pixel_feeder_inst.row\[18\]\[3\]
+ _0032_ sg13g2_dfrbpq_1
X_3467_ _0797_ _0817_ _0819_ VPWR VGND sg13g2_nor2_2
X_5206_ _2205_ _2194_ _2203_ VPWR VGND sg13g2_xnor2_1
X_6186_ net788 net833 _0246_ VPWR VGND sg13g2_nor2_1
X_3398_ VGND VPWR _0790_ _0789_ _0786_ sg13g2_or2_1
X_5137_ _2141_ _2143_ _2144_ VPWR VGND sg13g2_and2_1
X_5068_ _1697_ _2064_ _2075_ VPWR VGND sg13g2_nor2_1
X_6644__459 VPWR VGND net459 sg13g2_tiehi
X_4019_ _0724_ VPWR _1055_ VGND _1043_ _1053_ sg13g2_o21ai_1
XFILLER_41_903 VPWR VGND sg13g2_decap_8
X_6497__301 VPWR VGND net301 sg13g2_tiehi
XFILLER_12_104 VPWR VGND sg13g2_fill_1
XFILLER_32_88 VPWR VGND sg13g2_decap_8
XFILLER_4_314 VPWR VGND sg13g2_decap_4
XFILLER_10_1002 VPWR VGND sg13g2_decap_8
X_6215__412 VPWR VGND net412 sg13g2_tiehi
X_6510__261 VPWR VGND net261 sg13g2_tiehi
XFILLER_0_553 VPWR VGND sg13g2_decap_8
XFILLER_44_763 VPWR VGND sg13g2_decap_4
X_6445__480 VPWR VGND net480 sg13g2_tiehi
X_6480__371 VPWR VGND net371 sg13g2_tiehi
XFILLER_43_273 VPWR VGND sg13g2_decap_8
XFILLER_12_660 VPWR VGND sg13g2_fill_1
XFILLER_8_664 VPWR VGND sg13g2_fill_2
XFILLER_11_170 VPWR VGND sg13g2_fill_2
X_4370_ videogen.test_lut_thingy.pixel_feeder_inst.row\[60\]\[2\] net644 _1377_ VPWR
+ VGND sg13g2_nor2_1
X_3321_ VPWR _0714_ videogen.test_lut_thingy.pixel_feeder_inst.row\[63\]\[0\] VGND
+ sg13g2_inv_1
X_6040_ net786 net829 _0101_ VPWR VGND sg13g2_nor2_1
XFILLER_27_708 VPWR VGND sg13g2_fill_2
XFILLER_35_741 VPWR VGND sg13g2_decap_4
XFILLER_35_752 VPWR VGND sg13g2_fill_1
XFILLER_22_424 VPWR VGND sg13g2_decap_8
XFILLER_34_273 VPWR VGND sg13g2_fill_1
X_6603__74 VPWR VGND net74 sg13g2_tiehi
X_5824_ VGND VPWR _2769_ _2782_ _0555_ net643 sg13g2_a21oi_1
X_5755_ _2711_ _2712_ _2714_ _2715_ VPWR VGND sg13g2_or3_1
XFILLER_33_1024 VPWR VGND sg13g2_decap_4
X_5686_ _2652_ _2600_ _2596_ VPWR VGND sg13g2_nand2b_1
X_4706_ _1713_ _1708_ _1712_ VPWR VGND sg13g2_xnor2_1
X_4637_ videogen.test_lut_thingy.pixel_feeder_inst.row\[38\]\[0\] net638 _1644_ VPWR
+ VGND sg13g2_nor2_1
X_6273__314 VPWR VGND net314 sg13g2_tiehi
X_4568_ videogen.test_lut_thingy.pixel_feeder_inst.row\[19\]\[0\] net655 _1575_ VPWR
+ VGND sg13g2_nor2_1
XFILLER_2_829 VPWR VGND sg13g2_decap_8
X_6307_ net246 VGND VPWR _0366_ videogen.another_shader.time_cnt\[22\] net730 sg13g2_dfrbpq_2
X_3519_ videogen.test_lut_thingy.pixel_feeder_inst.row\[47\]\[1\] net877 _0832_ _0595_
+ VPWR VGND sg13g2_mux2_1
X_4499_ net683 _1494_ _1505_ _1506_ VPWR VGND sg13g2_nor3_1
X_6238_ net376 VGND VPWR _0297_ videogen.test_lut_thingy.pixel_feeder_inst.row\[17\]\[1\]
+ _0022_ sg13g2_dfrbpq_1
X_6169_ net780 net823 _0229_ VPWR VGND sg13g2_nor2_1
XFILLER_40_1028 VPWR VGND sg13g2_fill_1
XFILLER_45_549 VPWR VGND sg13g2_fill_1
XFILLER_45_538 VPWR VGND sg13g2_decap_8
XFILLER_38_590 VPWR VGND sg13g2_fill_1
XFILLER_43_32 VPWR VGND sg13g2_fill_2
XFILLER_41_722 VPWR VGND sg13g2_fill_2
XFILLER_14_958 VPWR VGND sg13g2_fill_1
XFILLER_25_262 VPWR VGND sg13g2_decap_8
XFILLER_25_273 VPWR VGND sg13g2_fill_1
XFILLER_13_435 VPWR VGND sg13g2_fill_1
XFILLER_5_667 VPWR VGND sg13g2_fill_1
XFILLER_4_166 VPWR VGND sg13g2_decap_4
XFILLER_4_188 VPWR VGND sg13g2_fill_2
XFILLER_1_851 VPWR VGND sg13g2_decap_8
XFILLER_0_350 VPWR VGND sg13g2_decap_8
XFILLER_49_855 VPWR VGND sg13g2_decap_8
XFILLER_48_365 VPWR VGND sg13g2_decap_8
X_6326__204 VPWR VGND net204 sg13g2_tiehi
XFILLER_16_251 VPWR VGND sg13g2_decap_8
X_3870_ _0953_ _0954_ VPWR VGND sg13g2_inv_4
XFILLER_32_788 VPWR VGND sg13g2_fill_1
X_5540_ VGND VPWR _2472_ _2506_ _2524_ _2505_ sg13g2_a21oi_1
XFILLER_9_962 VPWR VGND sg13g2_decap_8
X_5471_ _2454_ _2456_ _2457_ VPWR VGND sg13g2_and2_1
X_4422_ _1425_ _1426_ _1427_ _1428_ _1429_ VPWR VGND sg13g2_nor4_1
X_4353_ net696 _1354_ _1359_ _1360_ VPWR VGND sg13g2_nor3_1
X_4284_ _1137_ _1281_ _1286_ _1291_ VPWR VGND sg13g2_nor3_1
X_6023_ net794 net837 _0084_ VPWR VGND sg13g2_nor2_1
X_6233__386 VPWR VGND net386 sg13g2_tiehi
XFILLER_11_906 VPWR VGND sg13g2_decap_8
X_3999_ videogen.another_shader.time_cnt\[21\] videogen.another_shader.time_cnt\[20\]
+ videogen.another_shader.time_cnt\[22\] _1041_ VPWR VGND _1033_ sg13g2_nand4_1
X_5807_ _2763_ _2733_ _2766_ VPWR VGND sg13g2_xor2_1
XFILLER_23_788 VPWR VGND sg13g2_fill_1
XFILLER_13_46 VPWR VGND sg13g2_fill_2
X_5738_ _2698_ blue\[5\] _2691_ VPWR VGND sg13g2_xnor2_1
X_5669_ _2636_ _2624_ _2635_ VPWR VGND sg13g2_xnor2_1
XFILLER_49_107 VPWR VGND sg13g2_decap_8
X_6212__415 VPWR VGND net415 sg13g2_tiehi
X_6384__128 VPWR VGND net128 sg13g2_tiehi
XFILLER_46_869 VPWR VGND sg13g2_decap_8
XFILLER_18_527 VPWR VGND sg13g2_decap_8
XFILLER_33_508 VPWR VGND sg13g2_fill_1
XFILLER_14_766 VPWR VGND sg13g2_fill_2
XFILLER_41_585 VPWR VGND sg13g2_fill_1
XFILLER_6_943 VPWR VGND sg13g2_decap_8
XFILLER_5_453 VPWR VGND sg13g2_fill_2
XFILLER_48_7 VPWR VGND sg13g2_decap_8
XFILLER_1_692 VPWR VGND sg13g2_decap_8
XFILLER_23_1012 VPWR VGND sg13g2_fill_1
XFILLER_23_1023 VPWR VGND sg13g2_decap_4
XFILLER_49_674 VPWR VGND sg13g2_fill_1
X_4971_ VPWR _1978_ _1977_ VGND sg13g2_inv_1
X_3922_ videogen.test_lut_thingy.pixel_feeder_inst.h_counter\[1\] _0882_ _0989_ VPWR
+ VGND sg13g2_and2_1
XFILLER_20_703 VPWR VGND sg13g2_fill_2
X_6641_ net483 VGND VPWR _0696_ serialize.shift_reg_g\[3\] clknet_3_5__leaf_clk_regs
+ sg13g2_dfrbpq_1
X_3853_ _0944_ net527 net491 VPWR VGND sg13g2_nand2_1
XFILLER_32_585 VPWR VGND sg13g2_fill_1
X_6572_ net385 VGND VPWR _0627_ videogen.test_lut_thingy.pixel_feeder_inst.row\[3\]\[1\]
+ _0214_ sg13g2_dfrbpq_1
X_3784_ net666 VPWR _0910_ VGND _0903_ _0909_ sg13g2_o21ai_1
X_5523_ _2508_ _2499_ _2506_ VPWR VGND sg13g2_nand2_1
XFILLER_30_1027 VPWR VGND sg13g2_fill_2
X_5454_ red\[0\] red\[2\] _2440_ VPWR VGND sg13g2_xor2_1
X_5385_ _2378_ _2377_ _2365_ _2371_ _2370_ VPWR VGND sg13g2_a22oi_1
X_4405_ _1363_ _1411_ net891 _1412_ VPWR VGND sg13g2_nand3_1
X_4336_ net687 _1339_ _1340_ _1342_ _1343_ VPWR VGND sg13g2_nor4_1
XFILLER_8_1006 VPWR VGND sg13g2_decap_8
X_4267_ _1274_ _1273_ _1270_ VPWR VGND sg13g2_nand2b_1
X_6006_ net783 net826 _0067_ VPWR VGND sg13g2_nor2_1
X_4198_ VGND VPWR _1183_ _1194_ _1205_ _1203_ sg13g2_a21oi_1
XFILLER_39_173 VPWR VGND sg13g2_fill_2
XFILLER_43_828 VPWR VGND sg13g2_decap_8
XFILLER_23_541 VPWR VGND sg13g2_fill_2
XFILLER_24_45 VPWR VGND sg13g2_fill_1
XFILLER_10_202 VPWR VGND sg13g2_decap_8
XFILLER_10_268 VPWR VGND sg13g2_fill_2
X_6652__333 VPWR VGND net333 sg13g2_tiehi
XFILLER_40_55 VPWR VGND sg13g2_fill_2
XFILLER_3_924 VPWR VGND sg13g2_decap_8
XFILLER_46_1023 VPWR VGND sg13g2_decap_4
XFILLER_49_42 VPWR VGND sg13g2_decap_8
XFILLER_49_86 VPWR VGND sg13g2_decap_4
Xfanout760 net761 net760 VPWR VGND sg13g2_buf_8
Xfanout793 net795 net793 VPWR VGND sg13g2_buf_8
Xfanout771 net777 net771 VPWR VGND sg13g2_buf_8
Xfanout782 net796 net782 VPWR VGND sg13g2_buf_8
XFILLER_1_49 VPWR VGND sg13g2_decap_8
XFILLER_46_655 VPWR VGND sg13g2_decap_8
XFILLER_14_574 VPWR VGND sg13g2_decap_4
XFILLER_6_795 VPWR VGND sg13g2_decap_4
XFILLER_46_4 VPWR VGND sg13g2_fill_2
X_5170_ _2168_ _2174_ _0404_ VPWR VGND _1669_ sg13g2_nand3b_1
X_4121_ videogen.fancy_shader.shader_counter_reg\[1\] videogen.another_shader.video_y\[1\]
+ _1128_ VPWR VGND sg13g2_xor2_1
X_4052_ _1078_ videogen.fancy_shader.shader_counter_reg\[6\] _1077_ VPWR VGND sg13g2_xnor2_1
XFILLER_37_622 VPWR VGND sg13g2_fill_2
XFILLER_25_817 VPWR VGND sg13g2_decap_4
X_4954_ VPWR _1961_ _1960_ VGND sg13g2_inv_1
X_3905_ _0897_ _0977_ _0327_ VPWR VGND sg13g2_nor2_1
XFILLER_33_861 VPWR VGND sg13g2_decap_4
X_4885_ _1852_ VPWR _1892_ VGND _1864_ _1890_ sg13g2_o21ai_1
X_6624_ net325 VGND VPWR _0679_ videogen.test_lut_thingy.pixel_feeder_inst.row\[22\]\[2\]
+ _0255_ sg13g2_dfrbpq_1
X_3836_ net711 _0892_ _0938_ VPWR VGND sg13g2_and2_1
X_3767_ _0897_ _0900_ _0901_ VPWR VGND sg13g2_nor2_1
X_6555_ net485 VGND VPWR _0610_ videogen.test_lut_thingy.pixel_feeder_inst.row\[43\]\[0\]
+ _0197_ sg13g2_dfrbpq_1
X_5506_ VPWR _2492_ _2491_ VGND sg13g2_inv_1
X_3698_ videogen.test_lut_thingy.pixel_feeder_inst.row\[12\]\[0\] net886 _0870_ _0432_
+ VPWR VGND sg13g2_mux2_1
X_6486_ net339 VGND VPWR _0541_ videogen.test_lut_thingy.pixel_feeder_inst.row\[53\]\[0\]
+ _0137_ sg13g2_dfrbpq_1
X_5437_ _2429_ VPWR _2430_ VGND _2425_ _2426_ sg13g2_o21ai_1
X_5368_ _2351_ _2357_ _2360_ _2361_ VPWR VGND sg13g2_nor3_1
XFILLER_48_909 VPWR VGND sg13g2_decap_8
XFILLER_0_949 VPWR VGND sg13g2_decap_8
X_6647__435 VPWR VGND net435 sg13g2_tiehi
X_5299_ _2292_ _2280_ _2291_ VPWR VGND sg13g2_nand2_1
X_4319_ net688 _1322_ _1324_ _1325_ _1326_ VPWR VGND sg13g2_nor4_1
XFILLER_19_34 VPWR VGND sg13g2_fill_1
XFILLER_19_89 VPWR VGND sg13g2_decap_4
XFILLER_28_666 VPWR VGND sg13g2_decap_4
XFILLER_43_669 VPWR VGND sg13g2_decap_4
XFILLER_24_872 VPWR VGND sg13g2_fill_1
X_6281__298 VPWR VGND net298 sg13g2_tiehi
XFILLER_23_382 VPWR VGND sg13g2_fill_1
XFILLER_23_393 VPWR VGND sg13g2_fill_1
XFILLER_13_1022 VPWR VGND sg13g2_decap_8
XFILLER_2_275 VPWR VGND sg13g2_decap_8
XFILLER_38_419 VPWR VGND sg13g2_fill_1
XFILLER_18_143 VPWR VGND sg13g2_fill_2
XFILLER_20_1026 VPWR VGND sg13g2_fill_2
XFILLER_47_986 VPWR VGND sg13g2_decap_8
XFILLER_22_809 VPWR VGND sg13g2_fill_1
XFILLER_33_113 VPWR VGND sg13g2_fill_2
XFILLER_15_850 VPWR VGND sg13g2_decap_4
XFILLER_15_883 VPWR VGND sg13g2_decap_8
X_4670_ _1673_ VPWR _1677_ VGND _1672_ _1674_ sg13g2_o21ai_1
XFILLER_30_842 VPWR VGND sg13g2_decap_4
XFILLER_30_864 VPWR VGND sg13g2_fill_2
X_3621_ net617 net661 net697 _0853_ VPWR VGND _0809_ sg13g2_nand4_1
X_3552_ videogen.test_lut_thingy.pixel_feeder_inst.row\[27\]\[3\] net853 _0839_ _0569_
+ VPWR VGND sg13g2_mux2_1
X_6340_ net179 VGND VPWR _0399_ videogen.test_lut_thingy.gol_counter_reg\[3\] net741
+ sg13g2_dfrbpq_1
X_6455__460 VPWR VGND net460 sg13g2_tiehi
XFILLER_6_592 VPWR VGND sg13g2_fill_2
X_6271_ net318 VGND VPWR _0330_ videogen.test_lut_thingy.pixel_feeder_inst.v_counter\[2\]
+ net719 sg13g2_dfrbpq_2
X_3483_ _0805_ _0821_ _0823_ VPWR VGND sg13g2_nor2_2
X_5222_ _2220_ _2209_ _2208_ _2221_ VPWR VGND sg13g2_mux2_1
X_5153_ VPWR VGND _2156_ _2159_ _2155_ _2141_ _2160_ _2143_ sg13g2_a221oi_1
X_6334__188 VPWR VGND net188 sg13g2_tiehi
XFILLER_37_0 VPWR VGND sg13g2_fill_2
X_4104_ VGND VPWR videogen.test_lut_thingy.gol_counter_reg\[3\] _1111_ _0399_ _1112_
+ sg13g2_a21oi_1
X_5084_ _2072_ _2064_ _2091_ VPWR VGND sg13g2_xor2_1
XFILLER_2_70 VPWR VGND sg13g2_decap_8
X_4035_ videogen.fancy_shader.shader_counter_reg\[1\] _1064_ _1066_ VPWR VGND sg13g2_and2_1
XFILLER_38_986 VPWR VGND sg13g2_decap_8
X_5986_ net768 net810 _0047_ VPWR VGND sg13g2_nor2_1
XFILLER_25_669 VPWR VGND sg13g2_decap_4
X_4937_ _1944_ _1928_ _1942_ _1911_ _1910_ VPWR VGND sg13g2_a22oi_1
XFILLER_33_680 VPWR VGND sg13g2_decap_8
XFILLER_36_1022 VPWR VGND sg13g2_decap_8
X_4868_ _1873_ _1874_ _1875_ VPWR VGND sg13g2_and2_1
X_3819_ net709 net708 _0890_ _0927_ _0928_ VPWR VGND sg13g2_and4_1
X_6607_ net58 VGND VPWR _0662_ blue_tmds_par\[8\] net743 sg13g2_dfrbpq_1
X_4799_ _1760_ _1805_ _1806_ VPWR VGND sg13g2_and2_1
XFILLER_4_507 VPWR VGND sg13g2_decap_4
XFILLER_21_24 VPWR VGND sg13g2_decap_4
X_6538_ net105 VGND VPWR _0593_ videogen.test_lut_thingy.pixel_feeder_inst.row\[48\]\[3\]
+ _0180_ sg13g2_dfrbpq_1
X_6469_ net432 VGND VPWR _0524_ videogen.test_lut_thingy.pixel_feeder_inst.row\[58\]\[3\]
+ _0120_ sg13g2_dfrbpq_1
XFILLER_0_735 VPWR VGND sg13g2_decap_4
XFILLER_48_728 VPWR VGND sg13g2_fill_1
XFILLER_44_912 VPWR VGND sg13g2_decap_8
XFILLER_16_603 VPWR VGND sg13g2_fill_2
XFILLER_44_989 VPWR VGND sg13g2_decap_8
XFILLER_15_157 VPWR VGND sg13g2_decap_8
XFILLER_12_820 VPWR VGND sg13g2_decap_8
XFILLER_8_835 VPWR VGND sg13g2_decap_4
XFILLER_3_584 VPWR VGND sg13g2_decap_8
XFILLER_39_739 VPWR VGND sg13g2_fill_2
XFILLER_47_783 VPWR VGND sg13g2_decap_8
XFILLER_47_772 VPWR VGND sg13g2_decap_4
XFILLER_34_400 VPWR VGND sg13g2_decap_4
XFILLER_35_912 VPWR VGND sg13g2_decap_8
X_5840_ _2798_ _2786_ _2796_ VPWR VGND sg13g2_xnor2_1
X_5771_ _2731_ _2692_ net614 VPWR VGND sg13g2_xnor2_1
XFILLER_34_499 VPWR VGND sg13g2_fill_2
X_4722_ _0732_ _0733_ _1722_ _1726_ _1729_ VPWR VGND sg13g2_or4_1
X_4653_ net699 _1654_ _1659_ _1660_ VPWR VGND sg13g2_nor3_1
X_4584_ net684 VPWR _1591_ VGND _1585_ _1590_ sg13g2_o21ai_1
X_3604_ videogen.test_lut_thingy.pixel_feeder_inst.row\[0\]\[1\] net870 _0849_ _0518_
+ VPWR VGND sg13g2_mux2_1
X_6323_ net210 VGND VPWR _0382_ videogen.fancy_shader.shader_counter_reg\[6\] net720
+ sg13g2_dfrbpq_2
X_3535_ videogen.test_lut_thingy.pixel_feeder_inst.row\[50\]\[0\] net883 _0835_ _0582_
+ VPWR VGND sg13g2_mux2_1
X_6254_ net351 VGND VPWR _0313_ videogen.test_lut_thingy.pixel_feeder_inst.row\[18\]\[2\]
+ _0031_ sg13g2_dfrbpq_1
X_3466_ videogen.test_lut_thingy.pixel_feeder_inst.row\[6\]\[0\] net882 _0818_ _0634_
+ VPWR VGND sg13g2_mux2_1
X_5205_ _2194_ _2203_ _2204_ VPWR VGND sg13g2_nor2_1
X_6185_ net789 net832 _0245_ VPWR VGND sg13g2_nor2_1
X_3397_ net617 _0787_ net666 _0789_ VPWR VGND sg13g2_nand3_1
X_5136_ _2133_ _2142_ _2143_ VPWR VGND sg13g2_nor2_2
XFILLER_29_205 VPWR VGND sg13g2_decap_8
X_5067_ _2074_ _2072_ _2073_ VPWR VGND sg13g2_nand2_1
X_4018_ net847 _1051_ _1054_ _0371_ VPWR VGND sg13g2_nor3_1
XFILLER_25_411 VPWR VGND sg13g2_decap_8
XFILLER_25_422 VPWR VGND sg13g2_decap_4
X_6208__420 VPWR VGND net420 sg13g2_tiehi
X_5969_ net768 net810 _0030_ VPWR VGND sg13g2_nor2_1
XFILLER_41_959 VPWR VGND sg13g2_decap_8
XFILLER_40_469 VPWR VGND sg13g2_decap_4
XFILLER_21_683 VPWR VGND sg13g2_decap_4
XFILLER_32_34 VPWR VGND sg13g2_fill_1
XFILLER_20_171 VPWR VGND sg13g2_decap_4
XFILLER_4_359 VPWR VGND sg13g2_fill_1
XFILLER_0_532 VPWR VGND sg13g2_decap_8
XFILLER_48_514 VPWR VGND sg13g2_fill_2
XFILLER_48_503 VPWR VGND sg13g2_fill_1
X_6250__359 VPWR VGND net359 sg13g2_tiehi
XFILLER_29_783 VPWR VGND sg13g2_fill_1
XFILLER_44_731 VPWR VGND sg13g2_fill_2
XFILLER_17_956 VPWR VGND sg13g2_fill_1
XFILLER_43_241 VPWR VGND sg13g2_fill_1
XFILLER_16_466 VPWR VGND sg13g2_decap_8
XFILLER_16_488 VPWR VGND sg13g2_decap_8
XFILLER_8_610 VPWR VGND sg13g2_decap_4
X_6394__108 VPWR VGND net108 sg13g2_tiehi
XFILLER_7_142 VPWR VGND sg13g2_fill_2
X_3320_ VPWR _0713_ videogen.test_lut_thingy.pixel_feeder_inst.row\[63\]\[1\] VGND
+ sg13g2_inv_1
XFILLER_19_282 VPWR VGND sg13g2_decap_4
XFILLER_35_797 VPWR VGND sg13g2_fill_2
X_5823_ VPWR VGND _2775_ _2780_ _2781_ _2776_ _2782_ _2778_ sg13g2_a221oi_1
X_5754_ _2714_ blue\[0\] _2713_ VPWR VGND sg13g2_nand2_1
XFILLER_33_1003 VPWR VGND sg13g2_decap_8
X_5685_ _2651_ _0742_ _2650_ VPWR VGND sg13g2_xnor2_1
X_4705_ _1711_ net670 _1712_ VPWR VGND sg13g2_xor2_1
X_4636_ _1639_ _1640_ _1641_ _1642_ _1643_ VPWR VGND sg13g2_nor4_1
X_6306_ net248 VGND VPWR _0365_ videogen.another_shader.time_cnt\[21\] net730 sg13g2_dfrbpq_1
X_4567_ _1570_ _1571_ _1572_ _1573_ _1574_ VPWR VGND sg13g2_nor4_1
X_3518_ videogen.test_lut_thingy.pixel_feeder_inst.row\[47\]\[2\] net866 _0832_ _0596_
+ VPWR VGND sg13g2_mux2_1
X_4498_ net699 _1499_ _1504_ _1505_ VPWR VGND sg13g2_nor3_1
X_6237_ net378 VGND VPWR _0296_ videogen.test_lut_thingy.pixel_feeder_inst.row\[17\]\[0\]
+ _0021_ sg13g2_dfrbpq_1
X_3449_ net865 videogen.test_lut_thingy.pixel_feeder_inst.row\[63\]\[2\] _0811_ _0644_
+ VPWR VGND sg13g2_mux2_1
X_6168_ net763 net805 _0228_ VPWR VGND sg13g2_nor2_1
XFILLER_40_1007 VPWR VGND sg13g2_decap_8
X_5119_ _2126_ _2111_ _2125_ VPWR VGND sg13g2_nand2_1
X_6099_ net775 net819 _0159_ VPWR VGND sg13g2_nor2_1
XFILLER_26_720 VPWR VGND sg13g2_decap_8
XFILLER_27_56 VPWR VGND sg13g2_decap_8
XFILLER_27_67 VPWR VGND sg13g2_decap_8
XFILLER_5_602 VPWR VGND sg13g2_fill_2
XFILLER_4_123 VPWR VGND sg13g2_decap_8
XFILLER_5_679 VPWR VGND sg13g2_decap_8
XFILLER_4_134 VPWR VGND sg13g2_fill_1
XFILLER_1_830 VPWR VGND sg13g2_decap_8
XFILLER_49_834 VPWR VGND sg13g2_decap_8
XFILLER_1_1012 VPWR VGND sg13g2_decap_8
XFILLER_44_572 VPWR VGND sg13g2_fill_1
XFILLER_44_561 VPWR VGND sg13g2_decap_4
XFILLER_32_767 VPWR VGND sg13g2_decap_8
XFILLER_9_941 VPWR VGND sg13g2_decap_8
X_5470_ _2456_ _2448_ _2455_ VPWR VGND sg13g2_nand2_1
X_4421_ videogen.test_lut_thingy.pixel_feeder_inst.row\[30\]\[1\] net639 _1428_ VPWR
+ VGND sg13g2_nor2_1
X_4352_ net686 _1355_ _1356_ _1358_ _1359_ VPWR VGND sg13g2_nor4_1
X_4283_ _1231_ _1281_ _1288_ _1290_ VPWR VGND sg13g2_nor3_1
X_6022_ net795 net837 _0083_ VPWR VGND sg13g2_nor2_1
XFILLER_39_300 VPWR VGND sg13g2_fill_1
XFILLER_23_734 VPWR VGND sg13g2_decap_4
XFILLER_23_756 VPWR VGND sg13g2_fill_1
X_3998_ videogen.another_shader.time_cnt\[22\] _1039_ _1040_ VPWR VGND sg13g2_nor2_1
X_5806_ _2765_ _2733_ _2764_ VPWR VGND sg13g2_nand2_1
X_5737_ VGND VPWR _2690_ _2696_ _2697_ _2686_ sg13g2_a21oi_1
X_6574__362 VPWR VGND net362 sg13g2_tiehi
X_5668_ _2635_ _2631_ _2633_ VPWR VGND sg13g2_xnor2_1
X_5599_ green\[0\] _2575_ _2576_ VPWR VGND sg13g2_and2_1
X_4619_ net688 _1622_ _1623_ _1625_ _1626_ VPWR VGND sg13g2_nor4_1
XFILLER_2_649 VPWR VGND sg13g2_decap_8
XFILLER_1_126 VPWR VGND sg13g2_fill_2
XFILLER_38_11 VPWR VGND sg13g2_decap_4
XFILLER_38_66 VPWR VGND sg13g2_fill_1
XFILLER_46_848 VPWR VGND sg13g2_decap_8
X_6249__361 VPWR VGND net361 sg13g2_tiehi
XFILLER_14_701 VPWR VGND sg13g2_fill_1
XFILLER_14_756 VPWR VGND sg13g2_fill_1
XFILLER_9_215 VPWR VGND sg13g2_fill_1
XFILLER_10_995 VPWR VGND sg13g2_decap_8
XFILLER_5_432 VPWR VGND sg13g2_fill_2
XFILLER_6_999 VPWR VGND sg13g2_decap_8
X_6291__278 VPWR VGND net278 sg13g2_tiehi
XFILLER_1_671 VPWR VGND sg13g2_decap_8
XFILLER_49_620 VPWR VGND sg13g2_decap_8
XFILLER_0_181 VPWR VGND sg13g2_fill_1
XFILLER_48_130 VPWR VGND sg13g2_decap_8
XFILLER_49_686 VPWR VGND sg13g2_decap_8
XFILLER_36_314 VPWR VGND sg13g2_fill_2
X_4970_ _1972_ _1976_ _1977_ VPWR VGND sg13g2_nor2b_1
XFILLER_44_391 VPWR VGND sg13g2_decap_4
X_3921_ videogen.test_lut_thingy.pixel_feeder_inst.h_counter\[1\] _0882_ _0988_ VPWR
+ VGND sg13g2_nor2_1
X_3852_ net491 net746 _0300_ VPWR VGND sg13g2_nor2b_1
X_6640_ net34 VGND VPWR _0695_ serialize.shift_reg_g\[2\] clknet_3_6__leaf_clk_regs
+ sg13g2_dfrbpq_1
X_6571_ net393 VGND VPWR _0626_ videogen.test_lut_thingy.pixel_feeder_inst.row\[3\]\[0\]
+ _0213_ sg13g2_dfrbpq_1
X_5522_ _2506_ _2472_ _2507_ VPWR VGND sg13g2_xor2_1
X_3783_ _0761_ _0908_ _0909_ VPWR VGND sg13g2_nor2_2
X_5453_ red\[2\] red\[0\] _2439_ VPWR VGND sg13g2_and2_1
X_5384_ VGND VPWR _2377_ _2375_ _2369_ sg13g2_or2_1
X_4404_ _1410_ VPWR _1411_ VGND _1374_ _1386_ sg13g2_o21ai_1
XFILLER_5_70 VPWR VGND sg13g2_fill_2
X_4335_ _1341_ VPWR _1342_ VGND videogen.test_lut_thingy.pixel_feeder_inst.row\[6\]\[2\]
+ net633 sg13g2_o21ai_1
X_4266_ _1273_ _1271_ _1272_ VPWR VGND sg13g2_xnor2_1
X_6005_ net783 net822 _0066_ VPWR VGND sg13g2_nor2_1
X_4197_ VGND VPWR _1179_ _1184_ _1204_ _1189_ sg13g2_a21oi_1
X_6465__440 VPWR VGND net440 sg13g2_tiehi
XFILLER_43_807 VPWR VGND sg13g2_decap_8
XFILLER_11_715 VPWR VGND sg13g2_fill_2
XFILLER_23_564 VPWR VGND sg13g2_decap_4
XFILLER_10_225 VPWR VGND sg13g2_fill_1
XFILLER_23_586 VPWR VGND sg13g2_decap_4
XFILLER_40_34 VPWR VGND sg13g2_decap_8
XFILLER_49_21 VPWR VGND sg13g2_decap_8
XFILLER_46_1002 VPWR VGND sg13g2_decap_8
XFILLER_6_4 VPWR VGND sg13g2_fill_1
XFILLER_2_424 VPWR VGND sg13g2_decap_4
Xfanout750 _0943_ net750 VPWR VGND sg13g2_buf_8
Xfanout794 net795 net794 VPWR VGND sg13g2_buf_8
XFILLER_1_28 VPWR VGND sg13g2_decap_8
Xfanout783 net785 net783 VPWR VGND sg13g2_buf_8
Xfanout761 net797 net761 VPWR VGND sg13g2_buf_8
Xfanout772 net777 net772 VPWR VGND sg13g2_buf_8
XFILLER_27_870 VPWR VGND sg13g2_fill_2
XFILLER_33_306 VPWR VGND sg13g2_fill_2
XFILLER_41_361 VPWR VGND sg13g2_fill_2
XFILLER_14_90 VPWR VGND sg13g2_fill_1
XFILLER_6_785 VPWR VGND sg13g2_fill_2
X_4120_ _1127_ net677 videogen.fancy_shader.shader_counter_reg\[0\] VPWR VGND sg13g2_nand2_1
X_4051_ _1067_ _1076_ _1077_ _0381_ VPWR VGND sg13g2_nor3_1
X_6484__348 VPWR VGND net348 sg13g2_tiehi
XFILLER_36_122 VPWR VGND sg13g2_decap_4
X_4953_ _1946_ _1959_ _1960_ VPWR VGND sg13g2_and2_1
X_3904_ _0975_ net682 _0977_ VPWR VGND sg13g2_xor2_1
XFILLER_33_873 VPWR VGND sg13g2_decap_4
X_4884_ _1852_ _1864_ _1890_ _1891_ VPWR VGND sg13g2_or3_1
X_6623_ net341 VGND VPWR _0678_ videogen.test_lut_thingy.pixel_feeder_inst.row\[22\]\[1\]
+ _0254_ sg13g2_dfrbpq_1
X_3835_ net711 _0892_ _0937_ VPWR VGND sg13g2_nor2_1
X_3766_ _0894_ _0898_ _0899_ _0900_ VPWR VGND sg13g2_nor3_1
X_6554_ net32 VGND VPWR _0609_ videogen.test_lut_thingy.pixel_feeder_inst.row\[44\]\[3\]
+ _0196_ sg13g2_dfrbpq_1
X_6491__319 VPWR VGND net319 sg13g2_tiehi
X_5505_ VGND VPWR _2490_ _2491_ _2482_ tmds_red.dc_balancing_reg\[4\] sg13g2_a21oi_2
X_6485_ net343 VGND VPWR _0540_ videogen.test_lut_thingy.pixel_feeder_inst.row\[52\]\[3\]
+ _0136_ sg13g2_dfrbpq_1
X_5436_ VGND VPWR _2421_ _2427_ _2429_ _2428_ sg13g2_a21oi_1
X_3697_ videogen.test_lut_thingy.pixel_feeder_inst.row\[12\]\[1\] net876 _0870_ _0433_
+ VPWR VGND sg13g2_mux2_1
XFILLER_0_928 VPWR VGND sg13g2_decap_8
X_5367_ VPWR _2360_ _2359_ VGND sg13g2_inv_1
X_4318_ videogen.test_lut_thingy.pixel_feeder_inst.row\[17\]\[2\] net623 _1325_ VPWR
+ VGND sg13g2_nor2_1
X_5298_ VGND VPWR _2287_ _2290_ _2291_ _2284_ sg13g2_a21oi_1
X_4249_ _1254_ _1255_ _1253_ _1256_ VPWR VGND sg13g2_nand3_1
XFILLER_27_100 VPWR VGND sg13g2_decap_8
XFILLER_28_623 VPWR VGND sg13g2_fill_1
XFILLER_27_111 VPWR VGND sg13g2_fill_1
XFILLER_27_166 VPWR VGND sg13g2_fill_2
XFILLER_11_534 VPWR VGND sg13g2_fill_2
XFILLER_13_1001 VPWR VGND sg13g2_decap_8
XFILLER_7_516 VPWR VGND sg13g2_fill_2
XFILLER_2_232 VPWR VGND sg13g2_decap_8
XFILLER_47_965 VPWR VGND sg13g2_decap_8
XFILLER_19_656 VPWR VGND sg13g2_decap_8
X_3620_ net887 videogen.test_lut_thingy.pixel_feeder_inst.row\[61\]\[0\] _0852_ _0505_
+ VPWR VGND sg13g2_mux2_1
X_3551_ _0794_ _0803_ _0839_ VPWR VGND sg13g2_nor2_2
X_6270_ net320 VGND VPWR _0329_ videogen.test_lut_thingy.pixel_feeder_inst.v_counter\[1\]
+ net718 sg13g2_dfrbpq_2
X_3482_ videogen.test_lut_thingy.pixel_feeder_inst.row\[40\]\[0\] net888 _0822_ _0622_
+ VPWR VGND sg13g2_mux2_1
X_5221_ _2209_ _2212_ _2220_ VPWR VGND sg13g2_nor2_1
X_5152_ _2138_ _2158_ _2159_ VPWR VGND sg13g2_and2_1
X_4103_ net899 VPWR _1112_ VGND videogen.test_lut_thingy.gol_counter_reg\[3\] _1111_
+ sg13g2_o21ai_1
X_5083_ VPWR VGND _2084_ _2074_ _2081_ _1694_ _2090_ _1695_ sg13g2_a221oi_1
XFILLER_49_291 VPWR VGND sg13g2_fill_1
XFILLER_38_965 VPWR VGND sg13g2_decap_8
XFILLER_37_442 VPWR VGND sg13g2_decap_8
X_4034_ _1064_ _1065_ _0376_ VPWR VGND sg13g2_nor2_1
X_5985_ net770 net811 _0046_ VPWR VGND sg13g2_nor2_1
X_6525__197 VPWR VGND net197 sg13g2_tiehi
XFILLER_36_1001 VPWR VGND sg13g2_decap_8
X_4936_ _1910_ _1911_ _1928_ _1942_ _1943_ VPWR VGND sg13g2_and4_1
X_4867_ _1846_ VPWR _1874_ VGND _1851_ _1872_ sg13g2_o21ai_1
XFILLER_21_865 VPWR VGND sg13g2_fill_2
X_3818_ net711 net712 net713 _0927_ VPWR VGND sg13g2_nor3_1
X_6606_ net62 VGND VPWR _0661_ blue_tmds_par\[7\] net743 sg13g2_dfrbpq_1
X_4798_ _1757_ videogen.another_shader.time_cnt\[24\] videogen.another_shader.time_cnt\[25\]
+ _1805_ VPWR VGND sg13g2_a21o_1
X_6537_ net109 VGND VPWR _0592_ videogen.test_lut_thingy.pixel_feeder_inst.row\[48\]\[2\]
+ _0179_ sg13g2_dfrbpq_1
X_3749_ videogen.test_lut_thingy.pixel_feeder_inst.h_counter\[2\] videogen.test_lut_thingy.pixel_feeder_inst.h_counter\[1\]
+ _0885_ VPWR VGND sg13g2_nor2_1
X_6468_ net434 VGND VPWR _0523_ videogen.test_lut_thingy.pixel_feeder_inst.row\[58\]\[2\]
+ _0119_ sg13g2_dfrbpq_1
X_5419_ _2342_ _2411_ _2412_ VPWR VGND sg13g2_nor2_1
XFILLER_0_714 VPWR VGND sg13g2_decap_8
X_6399_ net98 VGND VPWR _0458_ videogen.test_lut_thingy.pixel_feeder_inst.row\[14\]\[2\]
+ _0063_ sg13g2_dfrbpq_1
XFILLER_0_758 VPWR VGND sg13g2_fill_2
XFILLER_28_420 VPWR VGND sg13g2_fill_2
XFILLER_46_66 VPWR VGND sg13g2_fill_1
XFILLER_16_615 VPWR VGND sg13g2_fill_2
XFILLER_44_968 VPWR VGND sg13g2_decap_8
XFILLER_43_445 VPWR VGND sg13g2_fill_2
XFILLER_12_810 VPWR VGND sg13g2_fill_1
XFILLER_7_27 VPWR VGND sg13g2_fill_2
XFILLER_11_364 VPWR VGND sg13g2_decap_4
XFILLER_12_887 VPWR VGND sg13g2_fill_2
XFILLER_3_563 VPWR VGND sg13g2_decap_8
XFILLER_4_1010 VPWR VGND sg13g2_decap_8
XFILLER_19_431 VPWR VGND sg13g2_fill_2
XFILLER_34_423 VPWR VGND sg13g2_fill_2
XFILLER_35_979 VPWR VGND sg13g2_decap_8
X_5770_ VPWR _2730_ _2729_ VGND sg13g2_inv_1
X_4721_ _0732_ _0733_ _1722_ _1726_ _1728_ VPWR VGND sg13g2_nor4_1
XFILLER_14_180 VPWR VGND sg13g2_fill_1
XFILLER_21_139 VPWR VGND sg13g2_fill_1
XFILLER_30_662 VPWR VGND sg13g2_decap_8
X_4652_ net693 _1655_ _1656_ _1658_ _1659_ VPWR VGND sg13g2_nor4_1
X_3603_ videogen.test_lut_thingy.pixel_feeder_inst.row\[0\]\[2\] net860 _0849_ _0519_
+ VPWR VGND sg13g2_mux2_1
X_4583_ net700 VPWR _1590_ VGND _1586_ _1589_ sg13g2_o21ai_1
X_6322_ net212 VGND VPWR _0381_ videogen.fancy_shader.shader_counter_reg\[5\] net721
+ sg13g2_dfrbpq_1
X_3534_ videogen.test_lut_thingy.pixel_feeder_inst.row\[50\]\[1\] net872 _0835_ _0583_
+ VPWR VGND sg13g2_mux2_1
X_6253_ net353 VGND VPWR _0312_ videogen.test_lut_thingy.pixel_feeder_inst.row\[18\]\[1\]
+ _0030_ sg13g2_dfrbpq_1
X_3465_ videogen.test_lut_thingy.pixel_feeder_inst.row\[6\]\[1\] net871 _0818_ _0635_
+ VPWR VGND sg13g2_mux2_1
X_5204_ _2201_ _2202_ _2199_ _2203_ VPWR VGND sg13g2_nand3_1
X_6184_ net774 net819 _0244_ VPWR VGND sg13g2_nor2_1
X_3396_ _0788_ net617 _0787_ VPWR VGND sg13g2_nand2_1
X_5135_ _2142_ _2116_ _2128_ VPWR VGND sg13g2_xnor2_1
X_5066_ _2062_ _2070_ _1703_ _2073_ VPWR VGND sg13g2_nand3_1
X_4017_ _1043_ _1053_ _1054_ VPWR VGND sg13g2_nor2_1
XFILLER_26_902 VPWR VGND sg13g2_fill_2
X_6606__62 VPWR VGND net62 sg13g2_tiehi
XFILLER_37_294 VPWR VGND sg13g2_fill_1
X_5968_ net770 net811 _0029_ VPWR VGND sg13g2_nor2_1
XFILLER_41_938 VPWR VGND sg13g2_decap_8
X_4919_ _1921_ VPWR _1926_ VGND _1916_ _1924_ sg13g2_o21ai_1
X_5899_ VPWR _0687_ _2841_ VGND sg13g2_inv_1
XFILLER_21_695 VPWR VGND sg13g2_fill_2
XFILLER_32_68 VPWR VGND sg13g2_fill_1
XFILLER_0_511 VPWR VGND sg13g2_decap_8
XFILLER_0_588 VPWR VGND sg13g2_decap_8
XFILLER_28_283 VPWR VGND sg13g2_fill_1
XFILLER_31_459 VPWR VGND sg13g2_decap_4
XFILLER_40_993 VPWR VGND sg13g2_decap_8
XFILLER_7_110 VPWR VGND sg13g2_decap_4
XFILLER_8_666 VPWR VGND sg13g2_fill_1
XFILLER_4_850 VPWR VGND sg13g2_fill_1
XFILLER_3_393 VPWR VGND sg13g2_fill_2
XFILLER_21_4 VPWR VGND sg13g2_decap_8
XFILLER_19_250 VPWR VGND sg13g2_decap_4
XFILLER_34_231 VPWR VGND sg13g2_decap_4
X_5822_ net614 _2755_ _2781_ VPWR VGND sg13g2_nor2_2
XFILLER_35_776 VPWR VGND sg13g2_decap_8
X_5753_ _2713_ _2704_ _2708_ VPWR VGND sg13g2_xnor2_1
X_4704_ _1711_ videogen.another_shader.time_cnt\[7\] videogen.another_shader.video_x\[7\]
+ VPWR VGND sg13g2_xnor2_1
X_5684_ _2596_ VPWR _2650_ VGND _2598_ _2599_ sg13g2_o21ai_1
XFILLER_30_470 VPWR VGND sg13g2_fill_1
XFILLER_30_492 VPWR VGND sg13g2_decap_8
X_4635_ videogen.test_lut_thingy.pixel_feeder_inst.row\[45\]\[0\] net627 _1642_ VPWR
+ VGND sg13g2_nor2_1
X_4566_ videogen.test_lut_thingy.pixel_feeder_inst.row\[24\]\[0\] net647 _1573_ VPWR
+ VGND sg13g2_nor2_1
X_6305_ net250 VGND VPWR _0364_ videogen.another_shader.time_cnt\[20\] net730 sg13g2_dfrbpq_2
X_3517_ videogen.test_lut_thingy.pixel_feeder_inst.row\[47\]\[3\] net854 _0832_ _0597_
+ VPWR VGND sg13g2_mux2_1
X_4497_ net693 _1500_ _1502_ _1503_ _1504_ VPWR VGND sg13g2_nor4_1
X_6236_ net380 VGND VPWR _0295_ videogen.test_lut_thingy.pixel_feeder_inst.row\[39\]\[3\]
+ _0020_ sg13g2_dfrbpq_1
X_3448_ net854 videogen.test_lut_thingy.pixel_feeder_inst.row\[63\]\[3\] _0811_ _0645_
+ VPWR VGND sg13g2_mux2_1
X_6167_ net763 net805 _0227_ VPWR VGND sg13g2_nor2_1
X_3379_ _0743_ _0761_ net619 _0771_ VPWR VGND sg13g2_nor3_1
X_5118_ _2110_ VPWR _2125_ VGND _2105_ _2106_ sg13g2_o21ai_1
X_6098_ net775 net818 _0158_ VPWR VGND sg13g2_nor2_1
XFILLER_45_518 VPWR VGND sg13g2_fill_2
X_5049_ _2045_ _2055_ _2056_ VPWR VGND sg13g2_and2_1
XFILLER_9_408 VPWR VGND sg13g2_fill_1
XFILLER_13_426 VPWR VGND sg13g2_decap_8
XFILLER_40_256 VPWR VGND sg13g2_decap_8
XFILLER_49_813 VPWR VGND sg13g2_decap_8
XFILLER_1_886 VPWR VGND sg13g2_decap_8
XFILLER_0_385 VPWR VGND sg13g2_decap_8
X_6428__57 VPWR VGND net57 sg13g2_tiehi
XFILLER_16_286 VPWR VGND sg13g2_decap_4
XFILLER_32_735 VPWR VGND sg13g2_fill_1
XFILLER_9_997 VPWR VGND sg13g2_decap_8
X_4420_ videogen.test_lut_thingy.pixel_feeder_inst.row\[31\]\[1\] net660 _1427_ VPWR
+ VGND sg13g2_nor2_1
X_4351_ _1357_ VPWR _1358_ VGND videogen.test_lut_thingy.pixel_feeder_inst.row\[3\]\[2\]
+ net654 sg13g2_o21ai_1
X_4282_ _1280_ _1285_ _1283_ _1289_ VPWR VGND sg13g2_mux2_1
X_6021_ net795 net837 _0082_ VPWR VGND sg13g2_nor2_1
X_6487__335 VPWR VGND net335 sg13g2_tiehi
XFILLER_27_518 VPWR VGND sg13g2_decap_4
XFILLER_39_378 VPWR VGND sg13g2_decap_8
X_3997_ net843 _1036_ _1039_ _0365_ VPWR VGND sg13g2_nor3_1
X_5805_ VPWR _2764_ _2763_ VGND sg13g2_inv_1
X_5736_ _2696_ blue\[5\] _2691_ VPWR VGND sg13g2_nand2_1
X_6500__295 VPWR VGND net295 sg13g2_tiehi
X_5667_ _2631_ _2633_ _2634_ VPWR VGND sg13g2_nor2b_1
X_4618_ _1624_ VPWR _1625_ VGND videogen.test_lut_thingy.pixel_feeder_inst.row\[48\]\[0\]
+ net646 sg13g2_o21ai_1
X_5598_ _2574_ green\[7\] _2575_ VPWR VGND sg13g2_xor2_1
XFILLER_8_8 VPWR VGND sg13g2_fill_2
XFILLER_2_628 VPWR VGND sg13g2_decap_8
XFILLER_1_105 VPWR VGND sg13g2_decap_8
X_4549_ VGND VPWR net698 _1553_ _1556_ _1555_ sg13g2_a21oi_1
X_6219_ net408 VGND VPWR _0278_ serialize.shift_reg_r\[8\] clknet_3_4__leaf_clk_regs
+ sg13g2_dfrbpq_1
XFILLER_46_827 VPWR VGND sg13g2_decap_8
XFILLER_14_713 VPWR VGND sg13g2_decap_8
XFILLER_14_724 VPWR VGND sg13g2_fill_1
XFILLER_13_256 VPWR VGND sg13g2_fill_2
XFILLER_16_1021 VPWR VGND sg13g2_decap_8
XFILLER_10_974 VPWR VGND sg13g2_decap_8
XFILLER_6_978 VPWR VGND sg13g2_decap_8
XFILLER_5_499 VPWR VGND sg13g2_decap_8
XFILLER_1_650 VPWR VGND sg13g2_decap_8
XFILLER_49_632 VPWR VGND sg13g2_fill_2
XFILLER_0_171 VPWR VGND sg13g2_fill_2
XFILLER_49_654 VPWR VGND sg13g2_decap_8
XFILLER_37_849 VPWR VGND sg13g2_fill_1
X_6409__90 VPWR VGND net90 sg13g2_tiehi
X_3920_ _0882_ _0986_ _0987_ _0332_ VPWR VGND sg13g2_nor3_1
XFILLER_17_551 VPWR VGND sg13g2_fill_1
XFILLER_32_510 VPWR VGND sg13g2_fill_1
X_3851_ VGND VPWR net528 _0942_ _0943_ net845 sg13g2_a21oi_1
X_3782_ net672 _0756_ _0907_ _0908_ VPWR VGND sg13g2_nor3_2
X_6570_ net405 VGND VPWR _0625_ videogen.test_lut_thingy.pixel_feeder_inst.row\[40\]\[3\]
+ _0212_ sg13g2_dfrbpq_1
X_5521_ _2504_ _2502_ _2506_ VPWR VGND sg13g2_xor2_1
XFILLER_9_794 VPWR VGND sg13g2_decap_8
X_5452_ tmds_red.dc_balancing_reg\[0\] net632 _0422_ VPWR VGND sg13g2_and2_1
X_5383_ _2368_ VPWR _2376_ VGND _2370_ _2374_ sg13g2_o21ai_1
X_4403_ _1409_ net682 _1410_ VPWR VGND sg13g2_nor2b_1
XFILLER_5_82 VPWR VGND sg13g2_decap_8
X_4334_ _1341_ net661 videogen.test_lut_thingy.pixel_feeder_inst.row\[7\]\[2\] VPWR
+ VGND sg13g2_nand2b_1
XFILLER_5_93 VPWR VGND sg13g2_fill_1
X_6004_ net779 net822 _0065_ VPWR VGND sg13g2_nor2_1
X_4265_ _1260_ _1268_ _1272_ VPWR VGND sg13g2_nor2_1
X_4196_ _1201_ _1202_ _1203_ VPWR VGND _1191_ sg13g2_nand3b_1
XFILLER_28_849 VPWR VGND sg13g2_fill_2
X_6383__130 VPWR VGND net130 sg13g2_tiehi
X_5719_ _2617_ VPWR _2683_ VGND _2567_ net611 sg13g2_o21ai_1
XFILLER_40_57 VPWR VGND sg13g2_fill_1
XFILLER_2_403 VPWR VGND sg13g2_decap_8
XFILLER_3_959 VPWR VGND sg13g2_decap_8
XFILLER_49_77 VPWR VGND sg13g2_decap_4
Xfanout740 net745 net740 VPWR VGND sg13g2_buf_8
Xfanout751 net752 net751 VPWR VGND sg13g2_buf_8
Xfanout762 net763 net762 VPWR VGND sg13g2_buf_8
Xfanout784 net785 net784 VPWR VGND sg13g2_buf_8
Xfanout773 net777 net773 VPWR VGND sg13g2_buf_1
XFILLER_46_635 VPWR VGND sg13g2_fill_2
Xfanout795 net796 net795 VPWR VGND sg13g2_buf_8
XFILLER_45_123 VPWR VGND sg13g2_decap_4
XFILLER_45_156 VPWR VGND sg13g2_fill_1
X_6406__93 VPWR VGND net93 sg13g2_tiehi
XFILLER_42_863 VPWR VGND sg13g2_fill_1
XFILLER_42_852 VPWR VGND sg13g2_decap_8
XFILLER_42_896 VPWR VGND sg13g2_decap_8
X_6657__235 VPWR VGND net235 sg13g2_tiehi
XFILLER_10_771 VPWR VGND sg13g2_fill_2
X_4050_ net679 _1074_ _1077_ VPWR VGND sg13g2_and2_1
XFILLER_37_668 VPWR VGND sg13g2_decap_8
X_4952_ _1945_ VPWR _1959_ VGND _1941_ _1948_ sg13g2_o21ai_1
XFILLER_33_830 VPWR VGND sg13g2_fill_2
X_4883_ VPWR VGND _1878_ _1867_ _1876_ _1751_ _1890_ _1868_ sg13g2_a221oi_1
X_3903_ _0897_ _0976_ _0326_ VPWR VGND sg13g2_nor2_1
XFILLER_17_392 VPWR VGND sg13g2_fill_1
X_6622_ net358 VGND VPWR _0677_ videogen.test_lut_thingy.pixel_feeder_inst.row\[22\]\[0\]
+ _0253_ sg13g2_dfrbpq_1
X_3834_ _0892_ net615 _0936_ _0274_ VPWR VGND sg13g2_nor3_1
XFILLER_20_546 VPWR VGND sg13g2_fill_2
X_3765_ net892 VPWR _0899_ VGND videogen.test_lut_thingy.pixel_feeder_inst.state\[1\]
+ videogen.test_lut_thingy.pixel_feeder_inst.state\[3\] sg13g2_o21ai_1
X_6553_ net36 VGND VPWR _0608_ videogen.test_lut_thingy.pixel_feeder_inst.row\[44\]\[2\]
+ _0195_ sg13g2_dfrbpq_1
X_5504_ tmds_red.dc_balancing_reg\[4\] _2482_ _2488_ _2489_ _2490_ VPWR VGND sg13g2_nor4_1
X_3696_ videogen.test_lut_thingy.pixel_feeder_inst.row\[12\]\[2\] net865 _0870_ _0434_
+ VPWR VGND sg13g2_mux2_1
X_6484_ net348 VGND VPWR _0539_ videogen.test_lut_thingy.pixel_feeder_inst.row\[52\]\[2\]
+ _0135_ sg13g2_dfrbpq_1
X_5435_ _1313_ VPWR _2428_ VGND _2415_ _2417_ sg13g2_o21ai_1
XFILLER_0_907 VPWR VGND sg13g2_decap_8
X_5366_ _2359_ _2289_ _2358_ VPWR VGND sg13g2_xnor2_1
X_5297_ _2290_ _2197_ _2289_ VPWR VGND sg13g2_xnor2_1
X_4317_ _1323_ VPWR _1324_ VGND videogen.test_lut_thingy.pixel_feeder_inst.row\[18\]\[2\]
+ net634 sg13g2_o21ai_1
X_4248_ _1255_ _1241_ _1247_ VPWR VGND sg13g2_xnor2_1
X_4179_ _1186_ _1164_ _1185_ VPWR VGND sg13g2_xnor2_1
XFILLER_35_13 VPWR VGND sg13g2_fill_1
XFILLER_24_830 VPWR VGND sg13g2_fill_2
XFILLER_35_35 VPWR VGND sg13g2_decap_4
X_6246__365 VPWR VGND net365 sg13g2_tiehi
XFILLER_3_745 VPWR VGND sg13g2_decap_8
XFILLER_2_200 VPWR VGND sg13g2_fill_1
XFILLER_3_756 VPWR VGND sg13g2_fill_2
XFILLER_47_944 VPWR VGND sg13g2_decap_8
XFILLER_20_1028 VPWR VGND sg13g2_fill_1
XFILLER_18_145 VPWR VGND sg13g2_fill_1
XFILLER_33_115 VPWR VGND sg13g2_fill_1
X_3550_ videogen.test_lut_thingy.pixel_feeder_inst.row\[26\]\[0\] net884 _0838_ _0570_
+ VPWR VGND sg13g2_mux2_1
X_5220_ _2206_ _2216_ _2218_ _2219_ VPWR VGND sg13g2_nor3_1
X_3481_ videogen.test_lut_thingy.pixel_feeder_inst.row\[40\]\[1\] net879 _0822_ _0623_
+ VPWR VGND sg13g2_mux2_1
X_5151_ _2132_ _2136_ _2129_ _2158_ VPWR VGND sg13g2_nand3_1
X_5082_ _1685_ _2074_ _2085_ _2086_ _2089_ VPWR VGND sg13g2_or4_1
X_4102_ net848 _1110_ _1111_ _0398_ VPWR VGND sg13g2_nor3_1
X_4033_ VGND VPWR net892 _1062_ _1065_ videogen.fancy_shader.shader_counter_reg\[0\]
+ sg13g2_a21oi_1
XFILLER_49_270 VPWR VGND sg13g2_decap_8
XFILLER_38_944 VPWR VGND sg13g2_decap_8
XFILLER_37_487 VPWR VGND sg13g2_decap_8
X_5984_ net770 net811 _0045_ VPWR VGND sg13g2_nor2_1
X_4935_ _1741_ _1932_ _1935_ _1937_ _1942_ VPWR VGND sg13g2_or4_1
X_6306__248 VPWR VGND net248 sg13g2_tiehi
XFILLER_33_660 VPWR VGND sg13g2_decap_8
X_4866_ _1846_ _1851_ _1872_ _1873_ VPWR VGND sg13g2_or3_1
X_4797_ _1801_ _1802_ _1804_ VPWR VGND sg13g2_nor2_1
X_6605_ net66 VGND VPWR _0660_ blue_tmds_par\[6\] net743 sg13g2_dfrbpq_1
X_3817_ _0263_ net895 net836 net523 VPWR VGND sg13g2_and3_1
X_3748_ _0736_ videogen.test_lut_thingy.pixel_feeder_inst.v_counter\[2\] videogen.test_lut_thingy.pixel_feeder_inst.v_counter\[1\]
+ _0737_ _0884_ VPWR VGND sg13g2_nor4_1
XFILLER_20_398 VPWR VGND sg13g2_fill_2
X_6536_ net113 VGND VPWR _0591_ videogen.test_lut_thingy.pixel_feeder_inst.row\[48\]\[1\]
+ _0178_ sg13g2_dfrbpq_1
X_3679_ _0794_ _0854_ _0867_ VPWR VGND sg13g2_nor2_2
X_6467_ net436 VGND VPWR _0522_ videogen.test_lut_thingy.pixel_feeder_inst.row\[58\]\[1\]
+ _0118_ sg13g2_dfrbpq_1
X_5418_ _2409_ _2401_ _2411_ VPWR VGND sg13g2_xor2_1
X_6398_ net100 VGND VPWR _0457_ videogen.test_lut_thingy.pixel_feeder_inst.row\[14\]\[1\]
+ _0062_ sg13g2_dfrbpq_1
X_5349_ _2329_ _1238_ _2342_ VPWR VGND sg13g2_xor2_1
XFILLER_43_1028 VPWR VGND sg13g2_fill_1
XFILLER_43_1017 VPWR VGND sg13g2_decap_8
XFILLER_28_443 VPWR VGND sg13g2_fill_2
XFILLER_28_476 VPWR VGND sg13g2_fill_1
XFILLER_44_947 VPWR VGND sg13g2_decap_8
XFILLER_24_671 VPWR VGND sg13g2_fill_2
XFILLER_24_682 VPWR VGND sg13g2_decap_8
XFILLER_11_354 VPWR VGND sg13g2_decap_4
XFILLER_3_542 VPWR VGND sg13g2_decap_8
X_6333__190 VPWR VGND net190 sg13g2_tiehi
XFILLER_47_752 VPWR VGND sg13g2_fill_2
XFILLER_46_284 VPWR VGND sg13g2_fill_1
XFILLER_35_958 VPWR VGND sg13g2_decap_8
XFILLER_34_446 VPWR VGND sg13g2_decap_4
XFILLER_22_619 VPWR VGND sg13g2_decap_8
X_4720_ _1722_ _1726_ _1727_ VPWR VGND sg13g2_nor2_1
X_4651_ _1657_ VPWR _1658_ VGND videogen.test_lut_thingy.pixel_feeder_inst.row\[33\]\[0\]
+ net628 sg13g2_o21ai_1
X_3602_ videogen.test_lut_thingy.pixel_feeder_inst.row\[0\]\[3\] net849 _0849_ _0520_
+ VPWR VGND sg13g2_mux2_1
X_4582_ _1588_ VPWR _1589_ VGND videogen.test_lut_thingy.pixel_feeder_inst.row\[28\]\[0\]
+ net650 sg13g2_o21ai_1
XFILLER_7_870 VPWR VGND sg13g2_decap_8
X_6321_ net214 VGND VPWR _0380_ videogen.fancy_shader.shader_counter_reg\[4\] net720
+ sg13g2_dfrbpq_2
X_3533_ videogen.test_lut_thingy.pixel_feeder_inst.row\[50\]\[2\] net862 _0835_ _0584_
+ VPWR VGND sg13g2_mux2_1
X_6252_ net355 VGND VPWR _0311_ videogen.test_lut_thingy.pixel_feeder_inst.row\[18\]\[0\]
+ _0029_ sg13g2_dfrbpq_1
XFILLER_42_0 VPWR VGND sg13g2_decap_4
X_3464_ videogen.test_lut_thingy.pixel_feeder_inst.row\[6\]\[2\] net861 _0818_ _0636_
+ VPWR VGND sg13g2_mux2_1
X_6183_ net776 net819 _0243_ VPWR VGND sg13g2_nor2_1
X_5203_ _2198_ _2201_ _2193_ _2202_ VPWR VGND sg13g2_nand3_1
X_5134_ _2141_ _2129_ _2140_ VPWR VGND sg13g2_xnor2_1
X_3395_ _0787_ net686 _0779_ VPWR VGND sg13g2_xnor2_1
X_5065_ _2070_ _2062_ _1703_ _2072_ VPWR VGND sg13g2_a21o_1
X_4016_ videogen.another_shader.time_cnt\[26\] videogen.another_shader.time_cnt\[25\]
+ videogen.another_shader.time_cnt\[27\] _1053_ VPWR VGND videogen.another_shader.time_cnt\[24\]
+ sg13g2_nand4_1
XFILLER_26_958 VPWR VGND sg13g2_fill_1
XFILLER_41_917 VPWR VGND sg13g2_decap_8
XFILLER_25_446 VPWR VGND sg13g2_decap_8
XFILLER_25_468 VPWR VGND sg13g2_decap_4
X_5967_ net794 net836 _0028_ VPWR VGND sg13g2_nor2_1
X_4918_ _1925_ _1922_ _1924_ VPWR VGND sg13g2_nand2_2
X_6243__368 VPWR VGND net368 sg13g2_tiehi
X_5898_ _2841_ net749 net522 net755 blue_tmds_par\[2\] VPWR VGND sg13g2_a22oi_1
X_4849_ _1754_ _1846_ _1850_ _1856_ VPWR VGND sg13g2_nor3_1
XFILLER_10_1016 VPWR VGND sg13g2_decap_8
X_6519_ net221 VGND VPWR _0574_ videogen.test_lut_thingy.pixel_feeder_inst.row\[25\]\[0\]
+ _0161_ sg13g2_dfrbpq_1
XFILLER_10_1027 VPWR VGND sg13g2_fill_2
XFILLER_48_516 VPWR VGND sg13g2_fill_1
XFILLER_0_567 VPWR VGND sg13g2_decap_8
XFILLER_44_733 VPWR VGND sg13g2_fill_1
XFILLER_43_210 VPWR VGND sg13g2_decap_4
XFILLER_28_262 VPWR VGND sg13g2_fill_2
XFILLER_44_755 VPWR VGND sg13g2_fill_2
XFILLER_40_972 VPWR VGND sg13g2_decap_8
XFILLER_8_645 VPWR VGND sg13g2_fill_1
XFILLER_8_623 VPWR VGND sg13g2_fill_2
XFILLER_12_696 VPWR VGND sg13g2_fill_2
XFILLER_7_155 VPWR VGND sg13g2_decap_4
XFILLER_7_144 VPWR VGND sg13g2_fill_1
X_6259__342 VPWR VGND net342 sg13g2_tiehi
XFILLER_39_527 VPWR VGND sg13g2_decap_4
XFILLER_47_560 VPWR VGND sg13g2_fill_2
X_5821_ _2766_ _2779_ _2780_ VPWR VGND sg13g2_nor2_1
X_5752_ _2695_ blue\[7\] _2712_ VPWR VGND sg13g2_xor2_1
X_4703_ videogen.another_shader.time_cnt\[7\] videogen.another_shader.video_x\[7\]
+ _1710_ VPWR VGND sg13g2_nor2_1
X_5683_ _2635_ _2623_ _2634_ _2649_ VPWR VGND sg13g2_a21o_1
XFILLER_8_71 VPWR VGND sg13g2_fill_1
X_4634_ videogen.test_lut_thingy.pixel_feeder_inst.row\[46\]\[0\] net637 _1641_ VPWR
+ VGND sg13g2_nor2_1
X_4565_ videogen.test_lut_thingy.pixel_feeder_inst.row\[27\]\[0\] net656 _1572_ VPWR
+ VGND sg13g2_nor2_1
X_6304_ net252 VGND VPWR _0363_ videogen.another_shader.time_cnt\[19\] net730 sg13g2_dfrbpq_2
X_3516_ net616 _0821_ _0832_ VPWR VGND sg13g2_nor2_2
XFILLER_1_309 VPWR VGND sg13g2_decap_8
X_4496_ videogen.test_lut_thingy.pixel_feeder_inst.row\[32\]\[1\] net649 _1503_ VPWR
+ VGND sg13g2_nor2_1
X_6235_ net382 VGND VPWR _0294_ videogen.test_lut_thingy.pixel_feeder_inst.row\[39\]\[2\]
+ _0019_ sg13g2_dfrbpq_1
X_3447_ _0811_ _0809_ VPWR VGND net616 sg13g2_nand2b_2
X_6166_ net762 net804 _0226_ VPWR VGND sg13g2_nor2_1
X_3378_ _0761_ net620 _0770_ VPWR VGND sg13g2_nor2_1
X_6097_ net776 net817 _0157_ VPWR VGND sg13g2_nor2_1
X_5117_ _2122_ VPWR _2124_ VGND _2120_ _2121_ sg13g2_o21ai_1
X_5048_ _2039_ _2030_ _2028_ _2055_ VPWR VGND sg13g2_a21o_1
XFILLER_14_917 VPWR VGND sg13g2_fill_1
XFILLER_22_961 VPWR VGND sg13g2_fill_1
XFILLER_21_460 VPWR VGND sg13g2_decap_8
X_6393__110 VPWR VGND net110 sg13g2_tiehi
XFILLER_49_1023 VPWR VGND sg13g2_decap_4
XFILLER_48_302 VPWR VGND sg13g2_fill_1
XFILLER_0_364 VPWR VGND sg13g2_decap_8
XFILLER_1_865 VPWR VGND sg13g2_decap_8
XFILLER_49_869 VPWR VGND sg13g2_decap_8
XFILLER_48_379 VPWR VGND sg13g2_decap_8
XFILLER_36_519 VPWR VGND sg13g2_decap_8
XFILLER_16_210 VPWR VGND sg13g2_fill_1
XFILLER_17_777 VPWR VGND sg13g2_fill_1
XFILLER_31_235 VPWR VGND sg13g2_fill_2
XFILLER_9_910 VPWR VGND sg13g2_fill_2
XFILLER_13_994 VPWR VGND sg13g2_decap_8
XFILLER_9_976 VPWR VGND sg13g2_decap_8
X_4350_ _1357_ net652 videogen.test_lut_thingy.pixel_feeder_inst.row\[0\]\[2\] VPWR
+ VGND sg13g2_nand2b_1
X_4281_ _1288_ _1137_ _1286_ VPWR VGND sg13g2_xnor2_1
X_6020_ net795 net836 _0081_ VPWR VGND sg13g2_nor2_1
XFILLER_39_324 VPWR VGND sg13g2_fill_1
XFILLER_35_530 VPWR VGND sg13g2_decap_8
X_5804_ _2761_ _2760_ _2763_ VPWR VGND sg13g2_xor2_1
XFILLER_23_747 VPWR VGND sg13g2_fill_2
XFILLER_35_585 VPWR VGND sg13g2_decap_8
X_3996_ VPWR _1039_ _1038_ VGND sg13g2_inv_1
X_6494__307 VPWR VGND net307 sg13g2_tiehi
XFILLER_22_246 VPWR VGND sg13g2_decap_4
X_5735_ _2695_ blue\[6\] _2694_ VPWR VGND sg13g2_xnor2_1
X_5666_ _2595_ tmds_green.dc_balancing_reg\[1\] _2632_ _2633_ VPWR VGND sg13g2_a21o_1
X_6377__138 VPWR VGND net138 sg13g2_tiehi
X_4617_ _1624_ net661 videogen.test_lut_thingy.pixel_feeder_inst.row\[51\]\[0\] VPWR
+ VGND sg13g2_nand2b_1
X_5597_ _2574_ green\[6\] _2568_ VPWR VGND sg13g2_xnor2_1
XFILLER_2_607 VPWR VGND sg13g2_decap_8
X_4548_ net689 VPWR _1555_ VGND net698 _1554_ sg13g2_o21ai_1
XFILLER_1_128 VPWR VGND sg13g2_fill_1
X_4479_ videogen.test_lut_thingy.pixel_feeder_inst.row\[47\]\[1\] net658 _1486_ VPWR
+ VGND sg13g2_nor2_1
Xfanout900 rst_n net900 VPWR VGND sg13g2_buf_8
X_6218_ net409 VGND VPWR _0277_ videogen.another_shader.video_x\[9\] net723 sg13g2_dfrbpq_1
XFILLER_46_806 VPWR VGND sg13g2_decap_8
X_6149_ net786 net829 _0209_ VPWR VGND sg13g2_nor2_1
XFILLER_13_202 VPWR VGND sg13g2_decap_8
XFILLER_14_736 VPWR VGND sg13g2_decap_8
XFILLER_41_566 VPWR VGND sg13g2_decap_4
X_6442__486 VPWR VGND net486 sg13g2_tiehi
XFILLER_9_228 VPWR VGND sg13g2_fill_2
XFILLER_6_957 VPWR VGND sg13g2_decap_8
XFILLER_48_198 VPWR VGND sg13g2_fill_2
XFILLER_45_883 VPWR VGND sg13g2_decap_8
X_3850_ blue_tmds_par\[9\] net752 _0287_ VPWR VGND sg13g2_and2_1
X_3781_ net674 net675 net673 _0907_ VPWR VGND _0904_ sg13g2_nand4_1
XFILLER_20_728 VPWR VGND sg13g2_decap_4
X_5520_ _2502_ _2504_ _2505_ VPWR VGND sg13g2_nor2_1
XFILLER_13_791 VPWR VGND sg13g2_decap_8
XFILLER_9_773 VPWR VGND sg13g2_fill_1
X_5451_ _2438_ VPWR _0421_ VGND _1671_ _2153_ sg13g2_o21ai_1
X_5382_ _2370_ _2374_ _2375_ VPWR VGND sg13g2_nor2_1
X_4402_ net683 _1397_ _1408_ _1409_ VPWR VGND sg13g2_nor3_1
X_4333_ videogen.test_lut_thingy.pixel_feeder_inst.row\[4\]\[2\] net644 _1340_ VPWR
+ VGND sg13g2_nor2_1
X_4264_ _1261_ _1263_ _1271_ VPWR VGND sg13g2_nor2_1
X_6003_ net778 net821 _0064_ VPWR VGND sg13g2_nor2_1
XFILLER_39_121 VPWR VGND sg13g2_fill_1
X_4195_ _1202_ _1183_ _1189_ VPWR VGND sg13g2_nand2_1
XFILLER_27_305 VPWR VGND sg13g2_decap_8
XFILLER_27_316 VPWR VGND sg13g2_decap_8
XFILLER_28_828 VPWR VGND sg13g2_decap_4
X_6528__185 VPWR VGND net185 sg13g2_tiehi
X_6415__83 VPWR VGND net83 sg13g2_tiehi
XFILLER_24_15 VPWR VGND sg13g2_fill_2
XFILLER_36_894 VPWR VGND sg13g2_fill_2
X_6430__53 VPWR VGND net53 sg13g2_tiehi
XFILLER_10_216 VPWR VGND sg13g2_decap_4
X_3979_ VGND VPWR _0728_ _1024_ _0360_ _1026_ sg13g2_a21oi_1
X_5718_ VGND VPWR _2681_ _2682_ _0468_ net642 sg13g2_a21oi_1
XFILLER_40_14 VPWR VGND sg13g2_fill_2
X_5649_ _2519_ _2442_ _2621_ VPWR VGND sg13g2_xor2_1
XFILLER_3_938 VPWR VGND sg13g2_decap_8
XFILLER_49_56 VPWR VGND sg13g2_decap_8
Xfanout730 net731 net730 VPWR VGND sg13g2_buf_8
X_6290__280 VPWR VGND net280 sg13g2_tiehi
Xfanout741 net744 net741 VPWR VGND sg13g2_buf_8
Xfanout774 net776 net774 VPWR VGND sg13g2_buf_8
Xfanout763 net765 net763 VPWR VGND sg13g2_buf_8
Xfanout785 net796 net785 VPWR VGND sg13g2_buf_8
Xfanout752 net755 net752 VPWR VGND sg13g2_buf_8
Xfanout796 net797 net796 VPWR VGND sg13g2_buf_8
XFILLER_27_872 VPWR VGND sg13g2_fill_1
XFILLER_42_831 VPWR VGND sg13g2_decap_8
XFILLER_26_382 VPWR VGND sg13g2_decap_4
XFILLER_42_875 VPWR VGND sg13g2_decap_8
XFILLER_41_363 VPWR VGND sg13g2_fill_1
XFILLER_6_710 VPWR VGND sg13g2_fill_2
XFILLER_10_750 VPWR VGND sg13g2_decap_8
XFILLER_10_761 VPWR VGND sg13g2_fill_2
XFILLER_10_794 VPWR VGND sg13g2_fill_2
XFILLER_2_993 VPWR VGND sg13g2_decap_8
XFILLER_1_470 VPWR VGND sg13g2_decap_8
XFILLER_49_485 VPWR VGND sg13g2_decap_4
XFILLER_49_452 VPWR VGND sg13g2_decap_8
XFILLER_36_157 VPWR VGND sg13g2_fill_1
XFILLER_45_691 VPWR VGND sg13g2_fill_1
X_4951_ _1956_ _1955_ _1953_ _1958_ VPWR VGND sg13g2_a21o_2
XFILLER_17_371 VPWR VGND sg13g2_decap_8
XFILLER_17_382 VPWR VGND sg13g2_fill_2
X_4882_ _1867_ _1880_ _1881_ _1884_ _1889_ VPWR VGND sg13g2_nor4_1
X_3902_ _0976_ _0975_ _0974_ VPWR VGND sg13g2_nand2b_1
X_3833_ VGND VPWR net713 _0890_ _0936_ net712 sg13g2_a21oi_1
X_6621_ net381 VGND VPWR _0676_ videogen.test_lut_thingy.pixel_feeder_inst.row\[35\]\[3\]
+ _0252_ sg13g2_dfrbpq_1
X_3764_ _0744_ net621 _0898_ VPWR VGND sg13g2_nor2_1
X_6552_ net40 VGND VPWR _0607_ videogen.test_lut_thingy.pixel_feeder_inst.row\[44\]\[1\]
+ _0194_ sg13g2_dfrbpq_1
XFILLER_20_569 VPWR VGND sg13g2_decap_4
X_5503_ tmds_red.dc_balancing_reg\[1\] tmds_red.dc_balancing_reg\[0\] tmds_red.dc_balancing_reg\[3\]
+ tmds_red.dc_balancing_reg\[2\] _2489_ VPWR VGND sg13g2_nor4_1
X_3695_ videogen.test_lut_thingy.pixel_feeder_inst.row\[12\]\[3\] net854 _0870_ _0435_
+ VPWR VGND sg13g2_mux2_1
X_6483_ net352 VGND VPWR _0538_ videogen.test_lut_thingy.pixel_feeder_inst.row\[52\]\[1\]
+ _0134_ sg13g2_dfrbpq_1
X_5434_ _2427_ _2342_ _2420_ VPWR VGND sg13g2_xnor2_1
X_5365_ _2358_ _1181_ _2352_ VPWR VGND sg13g2_xnor2_1
X_5296_ _2289_ _1182_ _2285_ VPWR VGND sg13g2_xnor2_1
X_4316_ _1323_ net652 videogen.test_lut_thingy.pixel_feeder_inst.row\[16\]\[2\] VPWR
+ VGND sg13g2_nand2b_1
X_4247_ _1247_ _1250_ _1245_ _1254_ VPWR VGND sg13g2_nand3_1
X_4178_ videogen.fancy_shader.shader_counter_reg\[7\] net711 _1185_ VPWR VGND sg13g2_xor2_1
XFILLER_42_105 VPWR VGND sg13g2_decap_8
XFILLER_24_886 VPWR VGND sg13g2_fill_1
XFILLER_7_518 VPWR VGND sg13g2_fill_1
XFILLER_2_289 VPWR VGND sg13g2_decap_4
XFILLER_47_923 VPWR VGND sg13g2_decap_8
XFILLER_19_603 VPWR VGND sg13g2_fill_2
XFILLER_15_831 VPWR VGND sg13g2_decap_8
XFILLER_30_801 VPWR VGND sg13g2_decap_4
XFILLER_14_396 VPWR VGND sg13g2_decap_8
X_3480_ videogen.test_lut_thingy.pixel_feeder_inst.row\[40\]\[2\] net868 _0822_ _0624_
+ VPWR VGND sg13g2_mux2_1
X_5150_ _2157_ _2155_ _2156_ VPWR VGND sg13g2_nand2_1
X_5081_ _2088_ _2087_ VPWR VGND sg13g2_inv_2
X_4101_ _0740_ _0746_ _0747_ _1111_ VPWR VGND sg13g2_nor3_1
XFILLER_38_923 VPWR VGND sg13g2_decap_8
X_6269__322 VPWR VGND net322 sg13g2_tiehi
X_4032_ videogen.fancy_shader.shader_counter_reg\[0\] _1062_ _1064_ VPWR VGND sg13g2_and2_1
XFILLER_2_84 VPWR VGND sg13g2_decap_4
X_5983_ net778 net821 _0044_ VPWR VGND sg13g2_nor2_1
XFILLER_24_116 VPWR VGND sg13g2_fill_1
XFILLER_25_628 VPWR VGND sg13g2_fill_2
X_4934_ _1740_ _1935_ _1938_ _1939_ _1941_ VPWR VGND sg13g2_nor4_1
X_4865_ VPWR VGND _1862_ _1853_ _1860_ _1747_ _1872_ _1749_ sg13g2_a221oi_1
XFILLER_33_694 VPWR VGND sg13g2_fill_1
X_4796_ VGND VPWR _1803_ _1802_ _1801_ sg13g2_or2_1
XFILLER_21_867 VPWR VGND sg13g2_fill_1
X_6604_ net70 VGND VPWR _0659_ blue_tmds_par\[5\] net743 sg13g2_dfrbpq_1
X_3816_ VGND VPWR net836 net523 _0262_ _0926_ sg13g2_a21oi_1
X_3747_ videogen.test_lut_thingy.pixel_feeder_inst.v_counter\[2\] videogen.test_lut_thingy.pixel_feeder_inst.v_counter\[1\]
+ _0883_ VPWR VGND sg13g2_nor2_1
X_6535_ net117 VGND VPWR _0590_ videogen.test_lut_thingy.pixel_feeder_inst.row\[48\]\[0\]
+ _0177_ sg13g2_dfrbpq_1
X_3678_ videogen.test_lut_thingy.pixel_feeder_inst.row\[13\]\[0\] net886 _0866_ _0452_
+ VPWR VGND sg13g2_mux2_1
X_6466_ net438 VGND VPWR _0521_ videogen.test_lut_thingy.pixel_feeder_inst.row\[58\]\[0\]
+ _0117_ sg13g2_dfrbpq_1
X_5417_ VGND VPWR _2406_ _2408_ _2410_ _2401_ sg13g2_a21oi_1
X_6397_ net102 VGND VPWR _0456_ videogen.test_lut_thingy.pixel_feeder_inst.row\[14\]\[0\]
+ _0061_ sg13g2_dfrbpq_1
X_5348_ _2327_ _2335_ _2341_ VPWR VGND sg13g2_and2_1
XFILLER_48_709 VPWR VGND sg13g2_decap_8
XFILLER_47_208 VPWR VGND sg13g2_fill_1
X_5279_ _2272_ _0750_ _1510_ _2182_ VPWR VGND sg13g2_and3_1
X_6609__50 VPWR VGND net50 sg13g2_tiehi
XFILLER_46_57 VPWR VGND sg13g2_decap_8
XFILLER_44_926 VPWR VGND sg13g2_decap_8
XFILLER_15_105 VPWR VGND sg13g2_decap_8
XFILLER_16_617 VPWR VGND sg13g2_fill_1
XFILLER_43_458 VPWR VGND sg13g2_decap_4
XFILLER_43_447 VPWR VGND sg13g2_fill_1
X_6578__329 VPWR VGND net329 sg13g2_tiehi
XFILLER_12_801 VPWR VGND sg13g2_decap_8
XFILLER_11_322 VPWR VGND sg13g2_decap_4
XFILLER_11_344 VPWR VGND sg13g2_fill_2
XFILLER_12_889 VPWR VGND sg13g2_fill_1
XFILLER_7_29 VPWR VGND sg13g2_fill_1
XFILLER_3_598 VPWR VGND sg13g2_decap_8
XFILLER_19_411 VPWR VGND sg13g2_fill_2
XFILLER_47_797 VPWR VGND sg13g2_decap_8
XFILLER_34_425 VPWR VGND sg13g2_fill_1
XFILLER_35_926 VPWR VGND sg13g2_decap_4
X_6229__394 VPWR VGND net394 sg13g2_tiehi
XFILLER_15_683 VPWR VGND sg13g2_decap_8
X_4650_ _1657_ net663 videogen.test_lut_thingy.pixel_feeder_inst.row\[35\]\[0\] VPWR
+ VGND sg13g2_nand2b_1
X_3601_ _0801_ _0815_ _0849_ VPWR VGND sg13g2_nor2_2
X_4581_ VGND VPWR _0716_ net662 _1588_ _1587_ sg13g2_a21oi_1
X_6320_ net216 VGND VPWR _0379_ videogen.fancy_shader.shader_counter_reg\[3\] net726
+ sg13g2_dfrbpq_2
X_3532_ videogen.test_lut_thingy.pixel_feeder_inst.row\[50\]\[3\] net851 _0835_ _0585_
+ VPWR VGND sg13g2_mux2_1
X_3463_ videogen.test_lut_thingy.pixel_feeder_inst.row\[6\]\[3\] net850 _0818_ _0637_
+ VPWR VGND sg13g2_mux2_1
X_6251_ net357 VGND VPWR _0310_ videogen.test_lut_thingy.pixel_feeder_inst.row\[29\]\[3\]
+ _0028_ sg13g2_dfrbpq_1
X_6182_ net774 net819 _0242_ VPWR VGND sg13g2_nor2_1
X_5202_ _2201_ _1160_ _2191_ VPWR VGND sg13g2_xnor2_1
X_5133_ VGND VPWR _2131_ _2140_ _2139_ _2137_ sg13g2_a21oi_2
X_3394_ VGND VPWR _0786_ _0785_ _0782_ sg13g2_or2_1
XFILLER_35_0 VPWR VGND sg13g2_decap_8
XFILLER_38_720 VPWR VGND sg13g2_decap_8
X_5064_ _2062_ _2070_ _2071_ VPWR VGND sg13g2_and2_1
X_4015_ videogen.another_shader.time_cnt\[27\] videogen.another_shader.time_cnt\[26\]
+ videogen.another_shader.time_cnt\[25\] videogen.another_shader.time_cnt\[24\] _1052_
+ VPWR VGND sg13g2_and4_1
XFILLER_38_764 VPWR VGND sg13g2_decap_4
XFILLER_38_742 VPWR VGND sg13g2_decap_8
XFILLER_26_904 VPWR VGND sg13g2_fill_1
XFILLER_37_241 VPWR VGND sg13g2_fill_1
X_5966_ net793 net838 _0027_ VPWR VGND sg13g2_nor2_1
X_4917_ _1908_ _1923_ _1901_ _1924_ VPWR VGND sg13g2_nand3_1
X_5897_ VPWR _0686_ _2840_ VGND sg13g2_inv_1
X_4848_ _1844_ VPWR _1855_ VGND _1754_ _1850_ sg13g2_o21ai_1
X_4779_ _1778_ _1779_ _1785_ _1786_ VPWR VGND sg13g2_or3_1
XFILLER_4_318 VPWR VGND sg13g2_fill_2
X_6518_ net225 VGND VPWR _0573_ videogen.test_lut_thingy.pixel_feeder_inst.row\[26\]\[3\]
+ _0160_ sg13g2_dfrbpq_1
X_6449_ net472 VGND VPWR _0504_ videogen.test_lut_thingy.pixel_feeder_inst.row\[62\]\[3\]
+ _0100_ sg13g2_dfrbpq_1
XFILLER_0_546 VPWR VGND sg13g2_decap_8
XFILLER_29_731 VPWR VGND sg13g2_fill_2
XFILLER_44_767 VPWR VGND sg13g2_fill_1
XFILLER_40_951 VPWR VGND sg13g2_decap_8
XFILLER_7_123 VPWR VGND sg13g2_fill_1
XFILLER_11_163 VPWR VGND sg13g2_fill_2
XFILLER_8_657 VPWR VGND sg13g2_decap_8
X_6452__466 VPWR VGND net466 sg13g2_tiehi
XFILLER_35_745 VPWR VGND sg13g2_fill_2
X_5820_ _2779_ _2716_ _2754_ VPWR VGND sg13g2_nand2_1
X_5751_ _2697_ _2710_ _2711_ VPWR VGND sg13g2_and2_1
X_4702_ _1709_ videogen.another_shader.time_cnt\[7\] videogen.another_shader.video_x\[7\]
+ VPWR VGND sg13g2_nand2_1
XFILLER_33_1017 VPWR VGND sg13g2_decap_8
X_5682_ VGND VPWR _2647_ _2648_ _0466_ net642 sg13g2_a21oi_1
XFILLER_30_461 VPWR VGND sg13g2_decap_8
XFILLER_33_1028 VPWR VGND sg13g2_fill_1
XFILLER_8_83 VPWR VGND sg13g2_fill_1
X_4633_ videogen.test_lut_thingy.pixel_feeder_inst.row\[47\]\[0\] net659 _1640_ VPWR
+ VGND sg13g2_nor2_1
X_4564_ videogen.test_lut_thingy.pixel_feeder_inst.row\[26\]\[0\] net635 _1571_ VPWR
+ VGND sg13g2_nor2_1
X_6303_ net254 VGND VPWR _0362_ videogen.another_shader.time_cnt\[18\] net730 sg13g2_dfrbpq_2
X_3515_ videogen.test_lut_thingy.pixel_feeder_inst.row\[46\]\[0\] net887 _0831_ _0598_
+ VPWR VGND sg13g2_mux2_1
X_6234_ net384 VGND VPWR _0293_ videogen.test_lut_thingy.pixel_feeder_inst.row\[39\]\[1\]
+ _0018_ sg13g2_dfrbpq_1
X_4495_ _1501_ VPWR _1502_ VGND videogen.test_lut_thingy.pixel_feeder_inst.row\[33\]\[1\]
+ net628 sg13g2_o21ai_1
X_3446_ net884 videogen.test_lut_thingy.pixel_feeder_inst.row\[59\]\[0\] _0810_ _0646_
+ VPWR VGND sg13g2_mux2_1
X_6165_ net763 net805 _0225_ VPWR VGND sg13g2_nor2_1
X_3377_ _0766_ _0767_ _0765_ _0769_ VPWR VGND _0768_ sg13g2_nand4_1
X_6096_ net775 net818 _0156_ VPWR VGND sg13g2_nor2_1
X_5116_ _2121_ _2088_ _2120_ _2123_ VPWR VGND sg13g2_mux2_1
X_5047_ VGND VPWR _2054_ _2053_ _2050_ sg13g2_or2_1
XFILLER_38_583 VPWR VGND sg13g2_decap_8
XFILLER_41_715 VPWR VGND sg13g2_decap_8
XFILLER_43_25 VPWR VGND sg13g2_decap_8
X_5949_ net788 net831 _0010_ VPWR VGND sg13g2_nor2_1
XFILLER_49_1002 VPWR VGND sg13g2_decap_8
XFILLER_1_844 VPWR VGND sg13g2_decap_8
XFILLER_0_343 VPWR VGND sg13g2_decap_8
XFILLER_49_848 VPWR VGND sg13g2_decap_8
XFILLER_1_1026 VPWR VGND sg13g2_fill_2
XFILLER_16_244 VPWR VGND sg13g2_decap_8
XFILLER_32_704 VPWR VGND sg13g2_fill_1
X_6226__397 VPWR VGND net397 sg13g2_tiehi
XFILLER_9_955 VPWR VGND sg13g2_decap_8
XFILLER_12_483 VPWR VGND sg13g2_fill_1
XFILLER_4_693 VPWR VGND sg13g2_fill_1
X_4280_ _1137_ _1286_ _1287_ VPWR VGND sg13g2_nor2_1
XFILLER_48_881 VPWR VGND sg13g2_decap_8
XFILLER_47_380 VPWR VGND sg13g2_decap_4
X_5803_ _2762_ _2761_ _2760_ VPWR VGND sg13g2_nand2b_1
XFILLER_22_214 VPWR VGND sg13g2_fill_1
X_3995_ VGND VPWR _1038_ _1037_ _1029_ sg13g2_or2_1
X_6205__426 VPWR VGND net426 sg13g2_tiehi
X_5734_ _2694_ blue\[5\] _2693_ VPWR VGND sg13g2_xnor2_1
X_5665_ _2594_ _2595_ _2632_ VPWR VGND sg13g2_nor2_1
X_4616_ videogen.test_lut_thingy.pixel_feeder_inst.row\[49\]\[0\] net623 _1623_ VPWR
+ VGND sg13g2_nor2_1
X_5596_ green\[3\] VPWR _2573_ VGND _2571_ _2572_ sg13g2_o21ai_1
X_4547_ net706 videogen.test_lut_thingy.pixel_feeder_inst.row\[56\]\[3\] videogen.test_lut_thingy.pixel_feeder_inst.row\[57\]\[3\]
+ videogen.test_lut_thingy.pixel_feeder_inst.row\[58\]\[3\] videogen.test_lut_thingy.pixel_feeder_inst.row\[59\]\[3\]
+ net702 _1554_ VPWR VGND sg13g2_mux4_1
X_4478_ videogen.test_lut_thingy.pixel_feeder_inst.row\[45\]\[1\] net627 _1485_ VPWR
+ VGND sg13g2_nor2_1
X_6217_ net410 VGND VPWR _0276_ videogen.another_shader.video_x\[8\] net723 sg13g2_dfrbpq_1
X_3429_ videogen.test_lut_thingy.pixel_feeder_inst.row\[24\]\[3\] net852 _0804_ _0668_
+ VPWR VGND sg13g2_mux2_1
X_6148_ net786 net829 _0208_ VPWR VGND sg13g2_nor2_1
X_6079_ net772 net815 _0140_ VPWR VGND sg13g2_nor2_1
XFILLER_26_553 VPWR VGND sg13g2_fill_1
XFILLER_26_586 VPWR VGND sg13g2_fill_1
XFILLER_13_258 VPWR VGND sg13g2_fill_1
XFILLER_6_936 VPWR VGND sg13g2_decap_8
XFILLER_49_634 VPWR VGND sg13g2_fill_1
XFILLER_1_685 VPWR VGND sg13g2_decap_8
X_6586__247 VPWR VGND net247 sg13g2_tiehi
XFILLER_49_667 VPWR VGND sg13g2_decap_8
XFILLER_49_645 VPWR VGND sg13g2_decap_4
XFILLER_48_144 VPWR VGND sg13g2_fill_1
XFILLER_0_195 VPWR VGND sg13g2_decap_4
XFILLER_23_1027 VPWR VGND sg13g2_fill_2
XFILLER_45_862 VPWR VGND sg13g2_decap_8
X_3780_ _0906_ net675 _0904_ VPWR VGND sg13g2_nand2_1
XFILLER_32_578 VPWR VGND sg13g2_decap_8
X_5450_ VGND VPWR _1666_ _2433_ _2438_ _0416_ sg13g2_a21oi_1
X_4401_ net699 _1402_ _1407_ _1408_ VPWR VGND sg13g2_nor3_1
X_5381_ _2372_ _2373_ _2374_ VPWR VGND sg13g2_and2_1
X_4332_ videogen.test_lut_thingy.pixel_feeder_inst.row\[5\]\[2\] net622 _1339_ VPWR
+ VGND sg13g2_nor2_1
XFILLER_5_980 VPWR VGND sg13g2_decap_8
X_4263_ _1210_ _1260_ _1269_ _1270_ VPWR VGND sg13g2_nor3_1
X_6002_ net779 net822 _0063_ VPWR VGND sg13g2_nor2_1
X_4194_ _1184_ _1190_ _1179_ _1201_ VPWR VGND sg13g2_nand3_1
XFILLER_39_1012 VPWR VGND sg13g2_decap_8
X_6598__107 VPWR VGND net107 sg13g2_tiehi
XFILLER_23_501 VPWR VGND sg13g2_fill_2
XFILLER_35_383 VPWR VGND sg13g2_fill_1
XFILLER_35_394 VPWR VGND sg13g2_fill_2
X_3978_ _1026_ net895 _1025_ VPWR VGND sg13g2_nand2_1
X_6279__302 VPWR VGND net302 sg13g2_tiehi
X_5717_ _2682_ _2679_ _2609_ _2673_ _2639_ VPWR VGND sg13g2_a22oi_1
X_5648_ VGND VPWR net667 _2620_ _0460_ net844 sg13g2_a21oi_1
X_5579_ _2558_ VPWR _2559_ VGND red\[2\] _2491_ sg13g2_o21ai_1
XFILLER_49_35 VPWR VGND sg13g2_decap_8
XFILLER_46_1027 VPWR VGND sg13g2_fill_2
XFILLER_46_1016 VPWR VGND sg13g2_decap_8
Xfanout742 net744 net742 VPWR VGND sg13g2_buf_2
Xfanout720 net721 net720 VPWR VGND sg13g2_buf_8
Xfanout731 net733 net731 VPWR VGND sg13g2_buf_2
Xfanout775 net776 net775 VPWR VGND sg13g2_buf_8
Xfanout764 net765 net764 VPWR VGND sg13g2_buf_8
Xfanout753 net754 net753 VPWR VGND sg13g2_buf_8
Xfanout797 clockdiv.q2temp net797 VPWR VGND sg13g2_buf_8
Xfanout786 net790 net786 VPWR VGND sg13g2_buf_8
XFILLER_42_810 VPWR VGND sg13g2_decap_8
XFILLER_14_512 VPWR VGND sg13g2_fill_2
XFILLER_41_331 VPWR VGND sg13g2_fill_1
XFILLER_14_567 VPWR VGND sg13g2_decap_8
XFILLER_6_766 VPWR VGND sg13g2_fill_1
XFILLER_6_799 VPWR VGND sg13g2_fill_1
XFILLER_5_298 VPWR VGND sg13g2_fill_2
XFILLER_2_972 VPWR VGND sg13g2_decap_8
XFILLER_49_431 VPWR VGND sg13g2_decap_8
XFILLER_37_615 VPWR VGND sg13g2_decap_8
XFILLER_18_851 VPWR VGND sg13g2_decap_4
X_4950_ _1957_ _1955_ _1956_ VPWR VGND sg13g2_nand2_1
XFILLER_33_832 VPWR VGND sg13g2_fill_1
X_4881_ VPWR _1888_ _1887_ VGND sg13g2_inv_1
X_3901_ net691 _0971_ net685 _0975_ VPWR VGND sg13g2_nand3_1
XFILLER_32_320 VPWR VGND sg13g2_fill_2
XFILLER_33_854 VPWR VGND sg13g2_fill_1
X_6412__87 VPWR VGND net87 sg13g2_tiehi
X_3832_ net615 _0935_ _0273_ VPWR VGND sg13g2_nor2_1
X_6620_ net401 VGND VPWR _0675_ videogen.test_lut_thingy.pixel_feeder_inst.row\[35\]\[2\]
+ _0251_ sg13g2_dfrbpq_1
X_6551_ net44 VGND VPWR _0606_ videogen.test_lut_thingy.pixel_feeder_inst.row\[44\]\[0\]
+ _0193_ sg13g2_dfrbpq_1
X_6202__429 VPWR VGND net429 sg13g2_tiehi
X_5502_ _2485_ _2487_ _2488_ VPWR VGND sg13g2_and2_1
X_3763_ _0897_ net892 VPWR VGND videogen.test_lut_thingy.pixel_feeder_inst.state\[0\]
+ sg13g2_nand2b_2
XFILLER_9_582 VPWR VGND sg13g2_fill_1
X_3694_ _0828_ _0854_ _0870_ VPWR VGND sg13g2_nor2_2
X_6482_ net356 VGND VPWR _0537_ videogen.test_lut_thingy.pixel_feeder_inst.row\[52\]\[0\]
+ _0133_ sg13g2_dfrbpq_1
X_5433_ _2342_ _2412_ _2417_ _2420_ _2426_ VPWR VGND sg13g2_nor4_1
X_6239__374 VPWR VGND net374 sg13g2_tiehi
XFILLER_10_29 VPWR VGND sg13g2_fill_2
X_5364_ _2357_ _1160_ _2356_ VPWR VGND sg13g2_xnor2_1
X_4315_ videogen.test_lut_thingy.pixel_feeder_inst.row\[19\]\[2\] net655 _1322_ VPWR
+ VGND sg13g2_nor2_1
X_5295_ VPWR _2288_ _2287_ VGND sg13g2_inv_1
X_4246_ _1246_ _1227_ _1252_ _1253_ VPWR VGND sg13g2_a21o_1
X_4177_ VPWR _1184_ _1183_ VGND sg13g2_inv_1
XFILLER_28_659 VPWR VGND sg13g2_decap_8
XFILLER_24_832 VPWR VGND sg13g2_fill_1
XFILLER_13_1015 VPWR VGND sg13g2_decap_8
XFILLER_3_703 VPWR VGND sg13g2_decap_4
XFILLER_4_4 VPWR VGND sg13g2_fill_2
XFILLER_2_246 VPWR VGND sg13g2_decap_8
XFILLER_47_902 VPWR VGND sg13g2_decap_8
XFILLER_18_103 VPWR VGND sg13g2_fill_2
XFILLER_20_1019 VPWR VGND sg13g2_decap_8
XFILLER_47_979 VPWR VGND sg13g2_decap_8
XFILLER_46_489 VPWR VGND sg13g2_decap_4
XFILLER_18_169 VPWR VGND sg13g2_fill_2
XFILLER_42_640 VPWR VGND sg13g2_fill_2
XFILLER_42_651 VPWR VGND sg13g2_fill_1
XFILLER_30_846 VPWR VGND sg13g2_fill_1
X_5080_ _2085_ _2086_ _2087_ VPWR VGND sg13g2_nor2_1
X_4100_ VGND VPWR videogen.test_lut_thingy.gol_counter_reg\[0\] videogen.test_lut_thingy.gol_counter_reg\[1\]
+ _1110_ videogen.test_lut_thingy.gol_counter_reg\[2\] sg13g2_a21oi_1
X_4031_ VPWR _1063_ _1062_ VGND sg13g2_inv_1
XFILLER_2_63 VPWR VGND sg13g2_decap_8
XFILLER_38_979 VPWR VGND sg13g2_decap_8
XFILLER_2_96 VPWR VGND sg13g2_decap_8
X_6462__446 VPWR VGND net446 sg13g2_tiehi
X_5982_ net780 net823 _0043_ VPWR VGND sg13g2_nor2_1
X_4933_ VGND VPWR _1940_ _1939_ _1938_ sg13g2_or2_1
XFILLER_17_191 VPWR VGND sg13g2_fill_1
X_6380__135 VPWR VGND net135 sg13g2_tiehi
XFILLER_36_1015 VPWR VGND sg13g2_decap_8
X_4864_ _1864_ _1865_ _1870_ _1871_ VPWR VGND sg13g2_or3_1
X_4795_ VPWR VGND _1783_ _1763_ _1798_ _1793_ _1802_ _1797_ sg13g2_a221oi_1
X_3815_ net895 VPWR _0926_ VGND net836 net523 sg13g2_o21ai_1
X_6603_ net74 VGND VPWR _0658_ blue_tmds_par\[4\] net743 sg13g2_dfrbpq_1
X_6534_ net121 VGND VPWR _0589_ videogen.test_lut_thingy.pixel_feeder_inst.row\[4\]\[3\]
+ _0176_ sg13g2_dfrbpq_1
X_3746_ videogen.test_lut_thingy.pixel_feeder_inst.h_counter\[0\] net621 _0882_ VPWR
+ VGND sg13g2_and2_1
XFILLER_21_17 VPWR VGND sg13g2_fill_2
XFILLER_21_28 VPWR VGND sg13g2_fill_1
X_6465_ net440 VGND VPWR _0520_ videogen.test_lut_thingy.pixel_feeder_inst.row\[0\]\[3\]
+ _0116_ sg13g2_dfrbpq_1
X_5416_ _2409_ _2406_ _2408_ VPWR VGND sg13g2_nand2_1
X_3677_ videogen.test_lut_thingy.pixel_feeder_inst.row\[13\]\[1\] net876 _0866_ _0453_
+ VPWR VGND sg13g2_mux2_1
X_6396_ net104 VGND VPWR _0455_ videogen.test_lut_thingy.pixel_feeder_inst.row\[13\]\[3\]
+ _0060_ sg13g2_dfrbpq_1
XFILLER_0_728 VPWR VGND sg13g2_decap_8
X_5347_ _1250_ _2334_ _2339_ _2340_ VPWR VGND sg13g2_nor3_1
XFILLER_0_739 VPWR VGND sg13g2_fill_1
X_5278_ VPWR _2271_ _2270_ VGND sg13g2_inv_1
XFILLER_29_913 VPWR VGND sg13g2_fill_1
X_4229_ VPWR _1236_ _1235_ VGND sg13g2_inv_1
XFILLER_28_401 VPWR VGND sg13g2_fill_2
XFILLER_44_905 VPWR VGND sg13g2_decap_8
XFILLER_43_404 VPWR VGND sg13g2_fill_1
XFILLER_24_673 VPWR VGND sg13g2_fill_1
XFILLER_8_828 VPWR VGND sg13g2_decap_8
XFILLER_12_879 VPWR VGND sg13g2_fill_2
XFILLER_8_839 VPWR VGND sg13g2_fill_2
XFILLER_11_378 VPWR VGND sg13g2_fill_2
XFILLER_11_389 VPWR VGND sg13g2_fill_1
XFILLER_11_72 VPWR VGND sg13g2_fill_1
XFILLER_11_83 VPWR VGND sg13g2_decap_8
XFILLER_3_577 VPWR VGND sg13g2_decap_8
XFILLER_4_1024 VPWR VGND sg13g2_decap_4
XFILLER_35_905 VPWR VGND sg13g2_decap_8
XFILLER_34_404 VPWR VGND sg13g2_fill_1
XFILLER_43_982 VPWR VGND sg13g2_decap_8
XFILLER_15_640 VPWR VGND sg13g2_fill_2
X_6305__250 VPWR VGND net250 sg13g2_tiehi
XFILLER_30_621 VPWR VGND sg13g2_fill_2
X_6594__143 VPWR VGND net143 sg13g2_tiehi
X_4580_ videogen.test_lut_thingy.pixel_feeder_inst.row\[30\]\[0\] net639 _1587_ VPWR
+ VGND sg13g2_nor2_1
X_3600_ net885 videogen.test_lut_thingy.pixel_feeder_inst.row\[58\]\[0\] _0848_ _0521_
+ VPWR VGND sg13g2_mux2_1
X_3531_ _0807_ _0825_ _0835_ VPWR VGND sg13g2_nor2_2
X_3462_ _0815_ _0817_ _0818_ VPWR VGND sg13g2_nor2_2
X_6250_ net359 VGND VPWR _0309_ videogen.test_lut_thingy.pixel_feeder_inst.row\[29\]\[2\]
+ _0027_ sg13g2_dfrbpq_1
X_6181_ net774 net817 _0241_ VPWR VGND sg13g2_nor2_1
X_3393_ _0785_ net617 _0784_ VPWR VGND sg13g2_nand2_1
X_5201_ VPWR _2200_ _2199_ VGND sg13g2_inv_1
X_5132_ VGND VPWR _2124_ _2127_ _2139_ _2138_ sg13g2_a21oi_1
Xclkbuf_1_0__f_clk clknet_0_clk clknet_1_0__leaf_clk VPWR VGND sg13g2_buf_8
X_5063_ _2067_ _2068_ _2070_ VPWR VGND _2065_ sg13g2_nand3b_1
X_4014_ VGND VPWR videogen.another_shader.time_cnt\[26\] _1048_ _1051_ videogen.another_shader.time_cnt\[27\]
+ sg13g2_a21oi_1
XFILLER_25_404 VPWR VGND sg13g2_decap_8
XFILLER_25_426 VPWR VGND sg13g2_fill_1
XFILLER_25_437 VPWR VGND sg13g2_decap_4
X_5965_ net794 net836 _0026_ VPWR VGND sg13g2_nor2_1
X_4916_ _1923_ _1906_ _1900_ VPWR VGND sg13g2_nand2b_1
XFILLER_21_610 VPWR VGND sg13g2_fill_2
X_5896_ _2840_ net749 net517 net754 blue_tmds_par\[1\] VPWR VGND sg13g2_a22oi_1
XFILLER_34_993 VPWR VGND sg13g2_decap_8
X_4847_ _1844_ _1845_ _1752_ _1854_ VPWR VGND _1852_ sg13g2_nand4_1
XFILLER_20_175 VPWR VGND sg13g2_fill_2
XFILLER_21_676 VPWR VGND sg13g2_decap_8
X_4778_ VGND VPWR _1784_ _1785_ _1782_ _1780_ sg13g2_a21oi_2
X_6517_ net229 VGND VPWR _0572_ videogen.test_lut_thingy.pixel_feeder_inst.row\[26\]\[2\]
+ _0159_ sg13g2_dfrbpq_1
X_3729_ _0805_ _0815_ _0877_ VPWR VGND sg13g2_nor2_2
X_6448_ net474 VGND VPWR _0503_ videogen.test_lut_thingy.pixel_feeder_inst.row\[62\]\[2\]
+ _0099_ sg13g2_dfrbpq_1
X_6379_ net136 VGND VPWR _0438_ green_tmds_par\[3\] net739 sg13g2_dfrbpq_1
XFILLER_0_525 VPWR VGND sg13g2_decap_8
XFILLER_29_754 VPWR VGND sg13g2_fill_1
X_6287__286 VPWR VGND net286 sg13g2_tiehi
XFILLER_28_242 VPWR VGND sg13g2_decap_8
XFILLER_44_757 VPWR VGND sg13g2_fill_1
XFILLER_43_234 VPWR VGND sg13g2_decap_8
XFILLER_31_407 VPWR VGND sg13g2_decap_4
XFILLER_40_930 VPWR VGND sg13g2_decap_8
XFILLER_12_610 VPWR VGND sg13g2_fill_1
XFILLER_25_993 VPWR VGND sg13g2_fill_1
XFILLER_8_614 VPWR VGND sg13g2_fill_1
XFILLER_11_142 VPWR VGND sg13g2_fill_2
XFILLER_7_135 VPWR VGND sg13g2_decap_8
XFILLER_47_584 VPWR VGND sg13g2_fill_1
XFILLER_19_286 VPWR VGND sg13g2_fill_1
X_5750_ _2709_ VPWR _2710_ VGND _2701_ _2703_ sg13g2_o21ai_1
X_5681_ VPWR VGND _2609_ _2638_ _2643_ _2636_ _2648_ _2639_ sg13g2_a221oi_1
X_4701_ _1704_ VPWR _1708_ VGND _1705_ _1707_ sg13g2_o21ai_1
X_4632_ net692 VPWR _1639_ VGND videogen.test_lut_thingy.pixel_feeder_inst.row\[44\]\[0\]
+ net648 sg13g2_o21ai_1
X_4563_ net690 VPWR _1570_ VGND videogen.test_lut_thingy.pixel_feeder_inst.row\[25\]\[0\]
+ net624 sg13g2_o21ai_1
X_6302_ net256 VGND VPWR _0361_ videogen.another_shader.time_cnt\[17\] net730 sg13g2_dfrbpq_2
X_3514_ videogen.test_lut_thingy.pixel_feeder_inst.row\[46\]\[1\] net877 _0831_ _0599_
+ VPWR VGND sg13g2_mux2_1
X_4494_ _1501_ net662 videogen.test_lut_thingy.pixel_feeder_inst.row\[35\]\[1\] VPWR
+ VGND sg13g2_nand2b_1
X_3445_ net873 videogen.test_lut_thingy.pixel_feeder_inst.row\[59\]\[1\] _0810_ _0647_
+ VPWR VGND sg13g2_mux2_1
X_6233_ net386 VGND VPWR _0292_ videogen.test_lut_thingy.pixel_feeder_inst.row\[39\]\[0\]
+ _0017_ sg13g2_dfrbpq_1
X_6164_ net763 net805 _0224_ VPWR VGND sg13g2_nor2_1
X_3376_ net715 net716 net717 _0768_ VPWR VGND sg13g2_nor3_1
X_6095_ net776 net818 _0155_ VPWR VGND sg13g2_nor2_1
X_5115_ _2088_ _2096_ _2103_ _2105_ _2122_ VPWR VGND sg13g2_or4_1
X_5046_ _2053_ _2042_ _2052_ VPWR VGND sg13g2_nand2_1
XFILLER_27_27 VPWR VGND sg13g2_fill_2
XFILLER_26_713 VPWR VGND sg13g2_decap_8
XFILLER_25_256 VPWR VGND sg13g2_fill_2
X_5948_ net788 net831 _0009_ VPWR VGND sg13g2_nor2_1
XFILLER_22_985 VPWR VGND sg13g2_fill_2
X_5879_ _2694_ _2754_ _2758_ _2830_ VPWR VGND sg13g2_nor3_1
XFILLER_1_823 VPWR VGND sg13g2_decap_8
XFILLER_0_322 VPWR VGND sg13g2_decap_8
XFILLER_49_827 VPWR VGND sg13g2_decap_8
XFILLER_48_337 VPWR VGND sg13g2_fill_1
XFILLER_0_399 VPWR VGND sg13g2_decap_8
XFILLER_1_1005 VPWR VGND sg13g2_decap_8
XFILLER_29_551 VPWR VGND sg13g2_decap_4
XFILLER_29_573 VPWR VGND sg13g2_fill_2
XFILLER_44_565 VPWR VGND sg13g2_fill_1
XFILLER_17_71 VPWR VGND sg13g2_fill_1
XFILLER_9_934 VPWR VGND sg13g2_fill_2
XFILLER_12_462 VPWR VGND sg13g2_decap_8
XFILLER_12_473 VPWR VGND sg13g2_fill_2
XFILLER_8_433 VPWR VGND sg13g2_fill_2
XFILLER_4_672 VPWR VGND sg13g2_decap_8
XFILLER_48_860 VPWR VGND sg13g2_decap_8
X_5802_ tmds_blue.dc_balancing_reg\[1\] _2742_ _2732_ _2761_ VPWR VGND sg13g2_mux2_1
XFILLER_23_727 VPWR VGND sg13g2_decap_8
XFILLER_23_738 VPWR VGND sg13g2_fill_1
X_3994_ videogen.another_shader.time_cnt\[20\] videogen.another_shader.time_cnt\[19\]
+ videogen.another_shader.time_cnt\[21\] _1037_ VPWR VGND videogen.another_shader.time_cnt\[18\]
+ sg13g2_nand4_1
X_5733_ _2692_ blue\[4\] _2693_ VPWR VGND sg13g2_xor2_1
X_5664_ _2631_ tmds_green.dc_balancing_reg\[2\] _2596_ VPWR VGND sg13g2_xnor2_1
XFILLER_30_270 VPWR VGND sg13g2_fill_2
X_5595_ _2572_ green\[1\] green\[0\] green\[2\] VPWR VGND sg13g2_and3_1
X_4615_ videogen.test_lut_thingy.pixel_feeder_inst.row\[50\]\[0\] net634 _1622_ VPWR
+ VGND sg13g2_nor2_1
X_4546_ VPWR _1553_ _1552_ VGND sg13g2_inv_1
XFILLER_1_119 VPWR VGND sg13g2_decap_8
X_4477_ net691 VPWR _1484_ VGND videogen.test_lut_thingy.pixel_feeder_inst.row\[44\]\[1\]
+ net648 sg13g2_o21ai_1
X_3428_ _0801_ _0803_ _0804_ VPWR VGND sg13g2_nor2_2
X_6216_ net411 VGND VPWR _0275_ videogen.another_shader.video_x\[7\] net723 sg13g2_dfrbpq_2
X_3359_ VPWR _0752_ tmds_red.dc_balancing_reg\[3\] VGND sg13g2_inv_1
X_6147_ net787 net830 _0207_ VPWR VGND sg13g2_nor2_1
XFILLER_38_15 VPWR VGND sg13g2_fill_2
XFILLER_38_59 VPWR VGND sg13g2_decap_8
X_6078_ net773 net816 _0139_ VPWR VGND sg13g2_nor2_1
XFILLER_26_521 VPWR VGND sg13g2_decap_4
X_5029_ _2031_ _2035_ _2036_ VPWR VGND sg13g2_nor2_1
XFILLER_26_576 VPWR VGND sg13g2_fill_2
XFILLER_10_988 VPWR VGND sg13g2_decap_8
XFILLER_5_425 VPWR VGND sg13g2_fill_1
X_6256__347 VPWR VGND net347 sg13g2_tiehi
XFILLER_1_664 VPWR VGND sg13g2_decap_8
XFILLER_49_679 VPWR VGND sg13g2_decap_8
XFILLER_45_841 VPWR VGND sg13g2_decap_8
XFILLER_44_91 VPWR VGND sg13g2_fill_1
XFILLER_8_252 VPWR VGND sg13g2_fill_2
X_6376__140 VPWR VGND net140 sg13g2_tiehi
X_4400_ net693 _1403_ _1404_ _1406_ _1407_ VPWR VGND sg13g2_nor4_1
X_5380_ _2359_ _2364_ _2373_ VPWR VGND sg13g2_nor2_1
XFILLER_5_52 VPWR VGND sg13g2_fill_2
X_4331_ net684 VPWR _1338_ VGND _1332_ _1337_ sg13g2_o21ai_1
X_4262_ _1269_ _1200_ _1267_ VPWR VGND sg13g2_xnor2_1
X_6001_ net778 net821 _0062_ VPWR VGND sg13g2_nor2_1
X_4193_ _1199_ _1197_ _1200_ VPWR VGND sg13g2_xor2_1
XFILLER_10_0 VPWR VGND sg13g2_fill_2
X_3977_ videogen.another_shader.time_cnt\[15\] _1019_ net680 _1025_ VPWR VGND sg13g2_nand3_1
X_5716_ net612 _2675_ _2680_ _2681_ VPWR VGND sg13g2_or3_1
X_6617__447 VPWR VGND net447 sg13g2_tiehi
X_5647_ _2620_ red\[2\] _2519_ VPWR VGND sg13g2_xnor2_1
X_5578_ _2558_ red\[2\] _2495_ VPWR VGND sg13g2_nand2_1
X_4529_ _1534_ _1535_ net689 _1536_ VPWR VGND sg13g2_mux2_1
XFILLER_2_417 VPWR VGND sg13g2_decap_8
XFILLER_2_428 VPWR VGND sg13g2_fill_1
XFILLER_49_14 VPWR VGND sg13g2_decap_8
Xfanout721 net722 net721 VPWR VGND sg13g2_buf_2
Xfanout710 videogen.another_shader.video_x\[8\] net710 VPWR VGND sg13g2_buf_1
Xfanout732 net733 net732 VPWR VGND sg13g2_buf_8
Xfanout776 net777 net776 VPWR VGND sg13g2_buf_8
Xfanout765 net797 net765 VPWR VGND sg13g2_buf_8
Xfanout754 net755 net754 VPWR VGND sg13g2_buf_8
Xfanout743 net744 net743 VPWR VGND sg13g2_buf_8
Xfanout798 net799 net798 VPWR VGND sg13g2_buf_8
Xfanout787 net790 net787 VPWR VGND sg13g2_buf_2
XFILLER_26_351 VPWR VGND sg13g2_fill_2
XFILLER_41_321 VPWR VGND sg13g2_fill_2
XFILLER_10_796 VPWR VGND sg13g2_fill_1
XFILLER_2_951 VPWR VGND sg13g2_decap_8
XFILLER_49_410 VPWR VGND sg13g2_decap_8
XFILLER_39_91 VPWR VGND sg13g2_fill_1
XFILLER_37_649 VPWR VGND sg13g2_decap_8
XFILLER_45_682 VPWR VGND sg13g2_decap_8
XFILLER_33_811 VPWR VGND sg13g2_fill_1
X_4880_ _1880_ _1881_ _1887_ VPWR VGND sg13g2_nor2_1
X_3900_ VGND VPWR net691 _0971_ _0974_ net685 sg13g2_a21oi_1
X_3831_ _0935_ net713 _0890_ VPWR VGND sg13g2_xnor2_1
X_3762_ net842 _0896_ _0003_ VPWR VGND sg13g2_nor2_1
X_6550_ net48 VGND VPWR _0605_ videogen.test_lut_thingy.pixel_feeder_inst.row\[45\]\[3\]
+ _0192_ sg13g2_dfrbpq_1
XFILLER_32_376 VPWR VGND sg13g2_decap_4
X_5501_ _2482_ _2486_ _2487_ VPWR VGND sg13g2_nor2_1
X_3693_ videogen.test_lut_thingy.pixel_feeder_inst.row\[16\]\[0\] net883 _0869_ _0440_
+ VPWR VGND sg13g2_mux2_1
XFILLER_9_594 VPWR VGND sg13g2_decap_8
X_6481_ net360 VGND VPWR _0536_ videogen.test_lut_thingy.pixel_feeder_inst.row\[55\]\[3\]
+ _0132_ sg13g2_dfrbpq_1
X_5432_ _2411_ _2422_ _2424_ _2425_ VPWR VGND sg13g2_nor3_1
X_5363_ _2356_ _2279_ _2348_ VPWR VGND sg13g2_xnor2_1
X_4314_ _1316_ _1317_ _1318_ _1320_ _1321_ VPWR VGND sg13g2_nor4_1
X_5294_ _2286_ _2199_ _2287_ VPWR VGND sg13g2_xor2_1
X_4245_ _1251_ VPWR _1252_ VGND _1227_ _1246_ sg13g2_o21ai_1
X_4176_ _1182_ _1181_ _1183_ VPWR VGND sg13g2_xor2_1
XFILLER_23_365 VPWR VGND sg13g2_fill_1
X_6322__212 VPWR VGND net212 sg13g2_tiehi
XFILLER_19_605 VPWR VGND sg13g2_fill_1
XFILLER_47_958 VPWR VGND sg13g2_decap_8
XFILLER_18_115 VPWR VGND sg13g2_fill_1
XFILLER_19_638 VPWR VGND sg13g2_fill_2
XFILLER_46_457 VPWR VGND sg13g2_decap_4
X_6483__352 VPWR VGND net352 sg13g2_tiehi
XFILLER_27_660 VPWR VGND sg13g2_fill_2
XFILLER_26_192 VPWR VGND sg13g2_decap_4
X_6297__266 VPWR VGND net266 sg13g2_tiehi
XFILLER_10_571 VPWR VGND sg13g2_decap_8
XFILLER_6_542 VPWR VGND sg13g2_fill_2
X_6490__323 VPWR VGND net323 sg13g2_tiehi
X_4030_ _0881_ _0954_ _1062_ VPWR VGND sg13g2_nor2_1
XFILLER_2_53 VPWR VGND sg13g2_decap_4
XFILLER_49_284 VPWR VGND sg13g2_decap_8
XFILLER_38_958 VPWR VGND sg13g2_decap_8
X_5981_ net778 net821 _0042_ VPWR VGND sg13g2_nor2_1
X_4932_ _1741_ _1932_ _1939_ VPWR VGND sg13g2_and2_1
XFILLER_45_490 VPWR VGND sg13g2_decap_8
XFILLER_21_814 VPWR VGND sg13g2_fill_2
X_4863_ _1870_ _1852_ _1869_ VPWR VGND sg13g2_nand2_1
XFILLER_21_836 VPWR VGND sg13g2_fill_2
X_6602_ net78 VGND VPWR _0657_ blue_tmds_par\[3\] net743 sg13g2_dfrbpq_1
X_4794_ VGND VPWR _1796_ _1799_ _1801_ _1762_ sg13g2_a21oi_1
X_3814_ tmds_green.dc_balancing_reg\[0\] net632 _0261_ VPWR VGND sg13g2_and2_1
X_6636__119 VPWR VGND net119 sg13g2_tiehi
X_6533_ net125 VGND VPWR _0588_ videogen.test_lut_thingy.pixel_feeder_inst.row\[4\]\[2\]
+ _0175_ sg13g2_dfrbpq_1
X_3745_ _0881_ _0757_ _0764_ _0880_ VPWR VGND sg13g2_and3_2
XFILLER_20_368 VPWR VGND sg13g2_fill_2
X_6464_ net442 VGND VPWR _0519_ videogen.test_lut_thingy.pixel_feeder_inst.row\[0\]\[2\]
+ _0115_ sg13g2_dfrbpq_1
X_5415_ _2396_ _2392_ _2407_ _2408_ VPWR VGND sg13g2_a21o_1
X_3676_ videogen.test_lut_thingy.pixel_feeder_inst.row\[13\]\[2\] net865 _0866_ _0454_
+ VPWR VGND sg13g2_mux2_1
X_6395_ net106 VGND VPWR _0454_ videogen.test_lut_thingy.pixel_feeder_inst.row\[13\]\[2\]
+ _0059_ sg13g2_dfrbpq_1
XFILLER_0_707 VPWR VGND sg13g2_decap_8
X_5346_ _2333_ _2336_ _2339_ VPWR VGND sg13g2_nor2_1
X_5277_ _1413_ _1510_ _2270_ VPWR VGND sg13g2_and2_1
X_4228_ _1231_ VPWR _1235_ VGND _1233_ _1234_ sg13g2_o21ai_1
X_4159_ _1165_ VPWR _1166_ VGND net711 videogen.fancy_shader.shader_counter_reg\[7\]
+ sg13g2_o21ai_1
XFILLER_11_51 VPWR VGND sg13g2_fill_2
XFILLER_3_556 VPWR VGND sg13g2_decap_8
XFILLER_11_95 VPWR VGND sg13g2_fill_2
XFILLER_4_1003 VPWR VGND sg13g2_decap_8
XFILLER_47_744 VPWR VGND sg13g2_fill_1
XFILLER_46_232 VPWR VGND sg13g2_decap_8
XFILLER_46_210 VPWR VGND sg13g2_fill_1
XFILLER_19_468 VPWR VGND sg13g2_decap_8
XFILLER_34_416 VPWR VGND sg13g2_decap_8
XFILLER_46_298 VPWR VGND sg13g2_fill_2
XFILLER_43_961 VPWR VGND sg13g2_decap_8
XFILLER_14_140 VPWR VGND sg13g2_decap_4
XFILLER_14_162 VPWR VGND sg13g2_decap_8
XFILLER_14_173 VPWR VGND sg13g2_fill_1
XFILLER_30_600 VPWR VGND sg13g2_fill_1
XFILLER_30_688 VPWR VGND sg13g2_decap_8
X_3530_ videogen.test_lut_thingy.pixel_feeder_inst.row\[4\]\[0\] net882 _0834_ _0586_
+ VPWR VGND sg13g2_mux2_1
XFILLER_6_383 VPWR VGND sg13g2_decap_8
X_3461_ net618 net661 net700 _0817_ VPWR VGND sg13g2_nand3_1
X_3392_ _0784_ net682 _0781_ VPWR VGND sg13g2_xnor2_1
X_6180_ net758 net801 _0240_ VPWR VGND sg13g2_nor2_1
X_5200_ _2199_ _1178_ _2196_ VPWR VGND sg13g2_xnor2_1
X_5131_ _2118_ _2124_ _2126_ _2138_ VPWR VGND sg13g2_nor3_1
X_5062_ _2067_ _2068_ _2069_ VPWR VGND sg13g2_and2_1
X_4013_ _0370_ net899 _1049_ _1050_ VPWR VGND sg13g2_and3_1
X_5964_ net793 net838 _0025_ VPWR VGND sg13g2_nor2_1
XFILLER_34_972 VPWR VGND sg13g2_decap_8
X_4915_ _1917_ VPWR _1922_ VGND _1919_ _1920_ sg13g2_o21ai_1
X_5895_ VPWR _0685_ _2839_ VGND sg13g2_inv_1
X_4846_ VPWR _1853_ _1852_ VGND sg13g2_inv_1
XFILLER_21_633 VPWR VGND sg13g2_fill_1
X_6516_ net237 VGND VPWR _0571_ videogen.test_lut_thingy.pixel_feeder_inst.row\[26\]\[1\]
+ _0158_ sg13g2_dfrbpq_1
X_4777_ _1774_ _1775_ _1784_ VPWR VGND sg13g2_nor2_1
X_3728_ videogen.test_lut_thingy.pixel_feeder_inst.row\[39\]\[0\] net887 _0876_ _0292_
+ VPWR VGND sg13g2_mux2_1
X_6447_ net476 VGND VPWR _0502_ videogen.test_lut_thingy.pixel_feeder_inst.row\[62\]\[1\]
+ _0098_ sg13g2_dfrbpq_1
X_3659_ _0797_ _0805_ _0863_ VPWR VGND sg13g2_nor2_2
XFILLER_0_504 VPWR VGND sg13g2_decap_8
X_6378_ net137 VGND VPWR _0437_ green_tmds_par\[1\] net739 sg13g2_dfrbpq_1
X_5329_ _2319_ _2321_ _2322_ VPWR VGND sg13g2_nor2_1
XFILLER_44_714 VPWR VGND sg13g2_decap_4
XFILLER_16_427 VPWR VGND sg13g2_fill_2
XFILLER_28_276 VPWR VGND sg13g2_decap_8
XFILLER_40_986 VPWR VGND sg13g2_decap_8
XFILLER_7_114 VPWR VGND sg13g2_fill_1
XFILLER_7_103 VPWR VGND sg13g2_fill_2
XFILLER_11_154 VPWR VGND sg13g2_decap_4
XFILLER_11_165 VPWR VGND sg13g2_fill_1
XFILLER_12_677 VPWR VGND sg13g2_fill_2
XFILLER_47_596 VPWR VGND sg13g2_fill_2
XFILLER_34_235 VPWR VGND sg13g2_fill_1
X_5680_ _2644_ _2646_ net610 _2647_ VPWR VGND sg13g2_nand3_1
X_4700_ _1706_ _1692_ _1698_ _1707_ VPWR VGND sg13g2_a21o_1
XFILLER_31_931 VPWR VGND sg13g2_fill_1
X_4631_ net683 VPWR _1638_ VGND _1632_ _1637_ sg13g2_o21ai_1
XFILLER_30_441 VPWR VGND sg13g2_decap_8
X_4562_ _1314_ _1568_ _1569_ VPWR VGND sg13g2_nor2_1
X_6301_ net258 VGND VPWR _0360_ videogen.another_shader.time_cnt\[16\] net730 sg13g2_dfrbpq_1
X_3513_ videogen.test_lut_thingy.pixel_feeder_inst.row\[46\]\[2\] net866 _0831_ _0600_
+ VPWR VGND sg13g2_mux2_1
X_4493_ videogen.test_lut_thingy.pixel_feeder_inst.row\[34\]\[1\] net639 _1500_ VPWR
+ VGND sg13g2_nor2_1
X_3444_ net863 videogen.test_lut_thingy.pixel_feeder_inst.row\[59\]\[2\] _0810_ _0648_
+ VPWR VGND sg13g2_mux2_1
X_6232_ net388 VGND VPWR _0291_ videogen.test_lut_thingy.pixel_feeder_inst.row\[1\]\[3\]
+ _0016_ sg13g2_dfrbpq_1
XFILLER_40_0 VPWR VGND sg13g2_decap_8
X_6163_ net763 net805 _0223_ VPWR VGND sg13g2_nor2_1
X_3375_ videogen.another_shader.video_x\[1\] videogen.another_shader.video_x\[0\]
+ _0767_ VPWR VGND sg13g2_nor2_1
X_6094_ net775 net818 _0154_ VPWR VGND sg13g2_nor2_1
X_6437__39 VPWR VGND net39 sg13g2_tiehi
X_5114_ _2121_ _2088_ _2095_ VPWR VGND sg13g2_xnor2_1
X_5045_ _2052_ net671 _2051_ VPWR VGND sg13g2_xnor2_1
XFILLER_25_279 VPWR VGND sg13g2_fill_2
X_5947_ net791 net834 _0008_ VPWR VGND sg13g2_nor2_1
XFILLER_40_249 VPWR VGND sg13g2_decap_8
X_5878_ VGND VPWR net668 _2829_ _0658_ _2824_ sg13g2_a21oi_1
X_4829_ _1835_ VPWR _1836_ VGND _1826_ _1828_ sg13g2_o21ai_1
XFILLER_21_474 VPWR VGND sg13g2_decap_4
XFILLER_4_106 VPWR VGND sg13g2_fill_1
XFILLER_4_117 VPWR VGND sg13g2_fill_2
XFILLER_1_802 VPWR VGND sg13g2_decap_8
XFILLER_0_301 VPWR VGND sg13g2_decap_8
XFILLER_49_806 VPWR VGND sg13g2_decap_8
XFILLER_1_879 VPWR VGND sg13g2_decap_8
XFILLER_0_378 VPWR VGND sg13g2_decap_8
X_6330__196 VPWR VGND net196 sg13g2_tiehi
XFILLER_1_1028 VPWR VGND sg13g2_fill_1
XFILLER_12_430 VPWR VGND sg13g2_fill_1
XFILLER_40_761 VPWR VGND sg13g2_decap_8
X_6517__229 VPWR VGND net229 sg13g2_tiehi
XFILLER_4_651 VPWR VGND sg13g2_decap_8
XFILLER_3_183 VPWR VGND sg13g2_decap_8
XFILLER_39_305 VPWR VGND sg13g2_decap_4
Xhold1 clockdiv.q2 VPWR VGND net489 sg13g2_dlygate4sd3_1
XFILLER_12_4 VPWR VGND sg13g2_decap_4
XFILLER_35_522 VPWR VGND sg13g2_fill_2
XFILLER_35_544 VPWR VGND sg13g2_fill_2
X_5801_ _2760_ tmds_blue.dc_balancing_reg\[2\] _2743_ VPWR VGND sg13g2_xnor2_1
X_3993_ VGND VPWR videogen.another_shader.time_cnt\[20\] _1033_ _1036_ videogen.another_shader.time_cnt\[21\]
+ sg13g2_a21oi_1
X_5732_ _2692_ _2687_ _2691_ VPWR VGND sg13g2_xnor2_1
X_5663_ _2630_ tmds_green.dc_balancing_reg\[2\] _2596_ VPWR VGND sg13g2_nand2_1
X_5594_ _2569_ _2570_ _2571_ VPWR VGND sg13g2_nor2_1
X_4614_ _1617_ _1618_ _1619_ _1620_ _1621_ VPWR VGND sg13g2_nor4_1
X_4545_ net704 videogen.test_lut_thingy.pixel_feeder_inst.row\[60\]\[3\] videogen.test_lut_thingy.pixel_feeder_inst.row\[61\]\[3\]
+ videogen.test_lut_thingy.pixel_feeder_inst.row\[62\]\[3\] videogen.test_lut_thingy.pixel_feeder_inst.row\[63\]\[3\]
+ net703 _1552_ VPWR VGND sg13g2_mux4_1
X_4476_ net683 VPWR _1483_ VGND _1477_ _1482_ sg13g2_o21ai_1
X_3427_ VGND VPWR _0803_ _0802_ _0786_ sg13g2_or2_1
X_6215_ net412 VGND VPWR _0274_ videogen.another_shader.video_x\[6\] net726 sg13g2_dfrbpq_1
X_3358_ VPWR _0751_ tmds_red.dc_balancing_reg\[1\] VGND sg13g2_inv_1
X_6146_ net787 net830 _0206_ VPWR VGND sg13g2_nor2_1
X_6077_ net773 net816 _0138_ VPWR VGND sg13g2_nor2_1
X_5028_ _2035_ _2032_ _2034_ VPWR VGND sg13g2_xnor2_1
XFILLER_14_706 VPWR VGND sg13g2_decap_8
XFILLER_16_1014 VPWR VGND sg13g2_decap_8
XFILLER_10_923 VPWR VGND sg13g2_fill_1
XFILLER_10_967 VPWR VGND sg13g2_decap_8
XFILLER_1_643 VPWR VGND sg13g2_decap_8
XFILLER_49_614 VPWR VGND sg13g2_fill_1
XFILLER_48_157 VPWR VGND sg13g2_decap_4
XFILLER_45_820 VPWR VGND sg13g2_decap_8
XFILLER_45_897 VPWR VGND sg13g2_decap_8
XFILLER_44_352 VPWR VGND sg13g2_decap_4
XFILLER_44_70 VPWR VGND sg13g2_fill_2
XFILLER_32_547 VPWR VGND sg13g2_decap_4
XFILLER_9_710 VPWR VGND sg13g2_fill_1
XFILLER_40_580 VPWR VGND sg13g2_fill_1
XFILLER_9_765 VPWR VGND sg13g2_decap_4
XFILLER_8_286 VPWR VGND sg13g2_fill_2
XFILLER_4_470 VPWR VGND sg13g2_fill_1
X_4330_ net699 VPWR _1337_ VGND _1333_ _1336_ sg13g2_o21ai_1
X_4261_ VGND VPWR _1268_ _1267_ _1200_ sg13g2_or2_1
X_6569__425 VPWR VGND net425 sg13g2_tiehi
X_6000_ net778 net821 _0061_ VPWR VGND sg13g2_nor2_1
X_4192_ _1199_ _1147_ _1198_ VPWR VGND sg13g2_xnor2_1
XFILLER_28_809 VPWR VGND sg13g2_fill_2
XFILLER_39_179 VPWR VGND sg13g2_fill_2
XFILLER_23_503 VPWR VGND sg13g2_fill_1
XFILLER_35_352 VPWR VGND sg13g2_decap_8
XFILLER_35_374 VPWR VGND sg13g2_fill_2
X_3976_ _1022_ _1023_ _0359_ VPWR VGND sg13g2_nor2_1
X_5715_ VGND VPWR _2664_ _2679_ _2680_ _2607_ sg13g2_a21oi_1
X_5646_ _2618_ _2619_ _0439_ VPWR VGND sg13g2_nor2b_1
X_5577_ net642 _2497_ _0428_ VPWR VGND sg13g2_nor2_1
X_6390__116 VPWR VGND net116 sg13g2_tiehi
X_4528_ net706 videogen.test_lut_thingy.pixel_feeder_inst.row\[24\]\[3\] videogen.test_lut_thingy.pixel_feeder_inst.row\[25\]\[3\]
+ videogen.test_lut_thingy.pixel_feeder_inst.row\[26\]\[3\] videogen.test_lut_thingy.pixel_feeder_inst.row\[27\]\[3\]
+ net702 _1535_ VPWR VGND sg13g2_mux4_1
XFILLER_6_9 VPWR VGND sg13g2_fill_1
Xfanout700 videogen.test_lut_thingy.pixel_feeder_inst.h_pix\[2\] net700 VPWR VGND
+ sg13g2_buf_8
X_4459_ net688 _1462_ _1463_ _1465_ _1466_ VPWR VGND sg13g2_nor4_1
Xfanout733 net745 net733 VPWR VGND sg13g2_buf_8
Xfanout711 videogen.another_shader.video_x\[7\] net711 VPWR VGND sg13g2_buf_8
Xfanout722 net723 net722 VPWR VGND sg13g2_buf_8
Xfanout755 _0712_ net755 VPWR VGND sg13g2_buf_8
Xfanout744 net745 net744 VPWR VGND sg13g2_buf_8
Xfanout766 net767 net766 VPWR VGND sg13g2_buf_8
Xfanout788 net789 net788 VPWR VGND sg13g2_buf_8
Xfanout799 net803 net799 VPWR VGND sg13g2_buf_8
X_6129_ net792 net835 _0189_ VPWR VGND sg13g2_nor2_1
Xfanout777 net797 net777 VPWR VGND sg13g2_buf_8
XFILLER_45_127 VPWR VGND sg13g2_fill_2
XFILLER_45_116 VPWR VGND sg13g2_decap_8
XFILLER_42_845 VPWR VGND sg13g2_decap_8
X_6403__215 VPWR VGND net215 sg13g2_tiehi
XFILLER_42_889 VPWR VGND sg13g2_decap_8
XFILLER_10_731 VPWR VGND sg13g2_fill_1
XFILLER_6_757 VPWR VGND sg13g2_fill_1
XFILLER_5_267 VPWR VGND sg13g2_fill_2
XFILLER_2_930 VPWR VGND sg13g2_decap_8
XFILLER_7_1023 VPWR VGND sg13g2_decap_4
XFILLER_1_484 VPWR VGND sg13g2_fill_2
XFILLER_49_466 VPWR VGND sg13g2_decap_8
XFILLER_37_628 VPWR VGND sg13g2_fill_2
XFILLER_44_182 VPWR VGND sg13g2_decap_4
X_3830_ net842 _0890_ _0934_ _0272_ VPWR VGND sg13g2_nor3_1
X_3761_ net892 net621 _0401_ VPWR VGND sg13g2_and2_1
X_5500_ _2474_ _2481_ _2486_ VPWR VGND sg13g2_nor2_1
X_3692_ videogen.test_lut_thingy.pixel_feeder_inst.row\[16\]\[1\] net872 _0869_ _0441_
+ VPWR VGND sg13g2_mux2_1
X_6480_ net371 VGND VPWR _0535_ videogen.test_lut_thingy.pixel_feeder_inst.row\[55\]\[2\]
+ _0131_ sg13g2_dfrbpq_1
X_5431_ _2420_ _2423_ _2424_ VPWR VGND sg13g2_nor2_1
X_6651__350 VPWR VGND net350 sg13g2_tiehi
X_5362_ _2355_ _1178_ _2354_ VPWR VGND sg13g2_xnor2_1
X_4313_ videogen.test_lut_thingy.pixel_feeder_inst.row\[26\]\[2\] net635 _1320_ VPWR
+ VGND sg13g2_nor2_1
XFILLER_5_790 VPWR VGND sg13g2_fill_2
X_5293_ _2286_ _1182_ _1185_ _2282_ VPWR VGND sg13g2_and3_2
X_4244_ VGND VPWR _1245_ _1247_ _1251_ _1250_ sg13g2_a21oi_1
X_4175_ _1182_ _1163_ _1166_ VPWR VGND sg13g2_xnor2_1
XFILLER_35_28 VPWR VGND sg13g2_decap_8
XFILLER_35_39 VPWR VGND sg13g2_fill_1
XFILLER_24_823 VPWR VGND sg13g2_decap_8
X_3959_ _1012_ net895 _1011_ VPWR VGND sg13g2_nand2_1
X_5629_ _2598_ tmds_green.dc_balancing_reg\[4\] _2605_ _2606_ VPWR VGND sg13g2_a21o_1
XFILLER_47_937 VPWR VGND sg13g2_decap_8
XFILLER_27_672 VPWR VGND sg13g2_fill_1
XFILLER_15_823 VPWR VGND sg13g2_fill_2
XFILLER_27_694 VPWR VGND sg13g2_fill_2
XFILLER_14_333 VPWR VGND sg13g2_decap_4
XFILLER_25_61 VPWR VGND sg13g2_fill_2
XFILLER_49_241 VPWR VGND sg13g2_decap_8
XFILLER_2_32 VPWR VGND sg13g2_decap_8
XFILLER_38_937 VPWR VGND sg13g2_decap_8
XFILLER_49_296 VPWR VGND sg13g2_decap_8
XFILLER_46_981 VPWR VGND sg13g2_decap_8
X_5980_ net779 net822 _0041_ VPWR VGND sg13g2_nor2_1
XFILLER_25_609 VPWR VGND sg13g2_fill_1
X_4931_ _1741_ _1932_ _1937_ _1938_ VPWR VGND sg13g2_nor3_1
XFILLER_33_620 VPWR VGND sg13g2_decap_4
X_4862_ _1869_ _1751_ _1868_ VPWR VGND sg13g2_nand2_1
X_3813_ _0925_ net897 net668 VPWR VGND sg13g2_nand2_1
X_6601_ net82 VGND VPWR _0656_ blue_tmds_par\[2\] net744 sg13g2_dfrbpq_1
XFILLER_32_152 VPWR VGND sg13g2_fill_2
X_4793_ _1799_ VPWR _1800_ VGND _1792_ _1796_ sg13g2_o21ai_1
X_6532_ net129 VGND VPWR _0587_ videogen.test_lut_thingy.pixel_feeder_inst.row\[4\]\[1\]
+ _0174_ sg13g2_dfrbpq_1
X_3744_ VGND VPWR net709 net708 _0880_ videogen.another_shader.video_y\[9\] sg13g2_a21oi_1
XFILLER_21_19 VPWR VGND sg13g2_fill_1
X_6463_ net444 VGND VPWR _0518_ videogen.test_lut_thingy.pixel_feeder_inst.row\[0\]\[1\]
+ _0114_ sg13g2_dfrbpq_1
X_3675_ videogen.test_lut_thingy.pixel_feeder_inst.row\[13\]\[3\] net854 _0866_ _0455_
+ VPWR VGND sg13g2_mux2_1
X_5414_ VGND VPWR _2389_ _2392_ _2407_ _2396_ sg13g2_a21oi_1
X_6532__129 VPWR VGND net129 sg13g2_tiehi
X_6394_ net108 VGND VPWR _0453_ videogen.test_lut_thingy.pixel_feeder_inst.row\[13\]\[1\]
+ _0058_ sg13g2_dfrbpq_1
X_5345_ VGND VPWR _2335_ _2337_ _2338_ _2327_ sg13g2_a21oi_1
X_5276_ _2266_ VPWR _0415_ VGND _2268_ _2269_ sg13g2_o21ai_1
X_4227_ _1223_ _1227_ _1234_ VPWR VGND sg13g2_and2_1
X_4158_ videogen.fancy_shader.shader_counter_reg\[7\] net711 _1164_ _1165_ VPWR VGND
+ sg13g2_a21o_1
X_4089_ net671 net672 net670 _1104_ VPWR VGND _1097_ sg13g2_nand4_1
XFILLER_37_981 VPWR VGND sg13g2_decap_8
XFILLER_15_119 VPWR VGND sg13g2_fill_1
XFILLER_24_631 VPWR VGND sg13g2_fill_2
XFILLER_24_664 VPWR VGND sg13g2_decap_8
XFILLER_23_141 VPWR VGND sg13g2_decap_4
XFILLER_23_185 VPWR VGND sg13g2_fill_1
XFILLER_11_358 VPWR VGND sg13g2_fill_2
XFILLER_3_535 VPWR VGND sg13g2_decap_8
XFILLER_46_200 VPWR VGND sg13g2_fill_2
XFILLER_47_767 VPWR VGND sg13g2_fill_1
XFILLER_43_940 VPWR VGND sg13g2_decap_8
XFILLER_36_93 VPWR VGND sg13g2_fill_2
XFILLER_30_612 VPWR VGND sg13g2_fill_2
X_6551__44 VPWR VGND net44 sg13g2_tiehi
X_3460_ videogen.test_lut_thingy.pixel_feeder_inst.row\[7\]\[0\] net882 _0816_ _0638_
+ VPWR VGND sg13g2_mux2_1
XFILLER_42_4 VPWR VGND sg13g2_fill_2
X_3391_ _0783_ _0781_ VPWR VGND net682 sg13g2_nand2b_2
X_5130_ _2132_ _2129_ _2136_ _2137_ VPWR VGND sg13g2_a21o_1
X_5061_ _2066_ _2049_ _2042_ _2068_ VPWR VGND sg13g2_a21o_1
X_4012_ _1050_ videogen.another_shader.time_cnt\[26\] _1048_ VPWR VGND sg13g2_nand2_1
XFILLER_38_756 VPWR VGND sg13g2_decap_4
XFILLER_38_734 VPWR VGND sg13g2_fill_2
XFILLER_26_918 VPWR VGND sg13g2_fill_1
XFILLER_37_255 VPWR VGND sg13g2_fill_2
X_5963_ net768 net810 _0024_ VPWR VGND sg13g2_nor2_1
XFILLER_37_299 VPWR VGND sg13g2_fill_2
X_4914_ _1919_ _1920_ _1921_ VPWR VGND sg13g2_nor2_1
XFILLER_18_491 VPWR VGND sg13g2_fill_2
X_5894_ _2839_ net749 net516 net754 blue_tmds_par\[0\] VPWR VGND sg13g2_a22oi_1
X_4845_ _1850_ _1754_ _1852_ VPWR VGND sg13g2_xor2_1
X_4776_ _1783_ _1780_ _1782_ VPWR VGND sg13g2_nand2_1
X_6515_ net241 VGND VPWR _0570_ videogen.test_lut_thingy.pixel_feeder_inst.row\[26\]\[0\]
+ _0157_ sg13g2_dfrbpq_1
X_3727_ videogen.test_lut_thingy.pixel_feeder_inst.row\[39\]\[1\] net877 _0876_ _0293_
+ VPWR VGND sg13g2_mux2_1
XFILLER_10_1009 VPWR VGND sg13g2_decap_8
X_6446_ net478 VGND VPWR _0501_ videogen.test_lut_thingy.pixel_feeder_inst.row\[62\]\[0\]
+ _0097_ sg13g2_dfrbpq_1
X_3658_ videogen.test_lut_thingy.pixel_feeder_inst.row\[32\]\[0\] net889 _0862_ _0477_
+ VPWR VGND sg13g2_mux2_1
X_6377_ net138 VGND VPWR _0436_ green_tmds_par\[0\] net738 sg13g2_dfrbpq_1
X_3589_ net872 videogen.test_lut_thingy.pixel_feeder_inst.row\[56\]\[1\] _0846_ _0530_
+ VPWR VGND sg13g2_mux2_1
X_5328_ _2321_ _2314_ _2320_ VPWR VGND sg13g2_nand2_1
X_5259_ _2258_ _2235_ _2244_ VPWR VGND sg13g2_xnor2_1
XFILLER_43_214 VPWR VGND sg13g2_fill_1
XFILLER_19_1023 VPWR VGND sg13g2_fill_2
XFILLER_40_965 VPWR VGND sg13g2_decap_8
XFILLER_11_199 VPWR VGND sg13g2_decap_4
XFILLER_7_159 VPWR VGND sg13g2_fill_1
XFILLER_4_811 VPWR VGND sg13g2_fill_2
XFILLER_0_0 VPWR VGND sg13g2_decap_8
XFILLER_14_8 VPWR VGND sg13g2_fill_1
X_6266__328 VPWR VGND net328 sg13g2_tiehi
XFILLER_35_715 VPWR VGND sg13g2_fill_2
XFILLER_19_299 VPWR VGND sg13g2_decap_8
XFILLER_31_921 VPWR VGND sg13g2_decap_4
X_4630_ net699 VPWR _1637_ VGND _1633_ _1636_ sg13g2_o21ai_1
X_6300_ net260 VGND VPWR _0359_ videogen.another_shader.time_cnt\[15\] net732 sg13g2_dfrbpq_2
XFILLER_7_660 VPWR VGND sg13g2_fill_1
X_4561_ _1511_ _1567_ _1568_ VPWR VGND sg13g2_nor2_1
X_3512_ videogen.test_lut_thingy.pixel_feeder_inst.row\[46\]\[3\] net854 _0831_ _0601_
+ VPWR VGND sg13g2_mux2_1
X_4492_ _1495_ _1496_ _1497_ _1498_ _1499_ VPWR VGND sg13g2_nor4_1
X_6231_ net390 VGND VPWR _0290_ videogen.test_lut_thingy.pixel_feeder_inst.row\[1\]\[2\]
+ _0015_ sg13g2_dfrbpq_1
X_3443_ net853 videogen.test_lut_thingy.pixel_feeder_inst.row\[59\]\[3\] _0810_ _0649_
+ VPWR VGND sg13g2_mux2_1
X_6162_ net762 net804 _0222_ VPWR VGND sg13g2_nor2_1
X_5113_ VPWR VGND _2111_ _2096_ _2105_ _2100_ _2120_ _2101_ sg13g2_a221oi_1
X_3374_ net712 net713 _0766_ VPWR VGND sg13g2_nor2_1
XFILLER_33_0 VPWR VGND sg13g2_decap_8
X_6093_ net775 net818 _0153_ VPWR VGND sg13g2_nor2_1
X_5044_ _1707_ _1705_ _2051_ VPWR VGND sg13g2_xor2_1
XFILLER_38_553 VPWR VGND sg13g2_fill_2
XFILLER_25_269 VPWR VGND sg13g2_decap_4
X_5946_ net791 net835 _0007_ VPWR VGND sg13g2_nor2_1
XFILLER_21_420 VPWR VGND sg13g2_decap_4
XFILLER_21_431 VPWR VGND sg13g2_fill_1
X_5877_ _2818_ _2693_ _2829_ VPWR VGND sg13g2_xor2_1
X_4828_ _1835_ _1803_ _1820_ VPWR VGND sg13g2_xnor2_1
X_4759_ _1766_ _0724_ _1764_ VPWR VGND sg13g2_nand2_1
XFILLER_5_619 VPWR VGND sg13g2_fill_1
X_6319__218 VPWR VGND net218 sg13g2_tiehi
XFILLER_49_1016 VPWR VGND sg13g2_decap_8
XFILLER_49_1027 VPWR VGND sg13g2_fill_2
X_6429_ net55 VGND VPWR _0484_ videogen.test_lut_thingy.pixel_feeder_inst.row\[9\]\[3\]
+ _0080_ sg13g2_dfrbpq_1
XFILLER_1_858 VPWR VGND sg13g2_decap_8
XFILLER_0_357 VPWR VGND sg13g2_decap_8
XFILLER_29_531 VPWR VGND sg13g2_fill_1
XFILLER_29_575 VPWR VGND sg13g2_fill_1
XFILLER_17_62 VPWR VGND sg13g2_decap_8
XFILLER_16_258 VPWR VGND sg13g2_fill_2
XFILLER_24_280 VPWR VGND sg13g2_decap_4
XFILLER_9_925 VPWR VGND sg13g2_fill_1
XFILLER_9_936 VPWR VGND sg13g2_fill_1
XFILLER_12_453 VPWR VGND sg13g2_decap_4
XFILLER_9_969 VPWR VGND sg13g2_decap_8
XFILLER_4_630 VPWR VGND sg13g2_fill_2
Xhold2 _0709_ VPWR VGND net490 sg13g2_dlygate4sd3_1
XFILLER_48_895 VPWR VGND sg13g2_decap_8
X_3992_ _0364_ net896 _1034_ _1035_ VPWR VGND sg13g2_and3_1
X_5800_ VGND VPWR _2733_ _2758_ _0554_ _2759_ sg13g2_a21oi_1
X_5731_ blue\[2\] blue\[3\] _2691_ VPWR VGND sg13g2_xor2_1
X_5662_ VPWR VGND _2629_ net642 _2628_ net612 _0465_ _2623_ sg13g2_a221oi_1
XFILLER_31_773 VPWR VGND sg13g2_fill_2
X_5593_ VGND VPWR green\[6\] _2568_ _2570_ green\[7\] sg13g2_a21oi_1
X_4613_ videogen.test_lut_thingy.pixel_feeder_inst.row\[58\]\[0\] net635 _1620_ VPWR
+ VGND sg13g2_nor2_1
X_4544_ net684 _1549_ _1550_ _1551_ VPWR VGND sg13g2_nor3_1
X_6214_ net413 VGND VPWR _0273_ videogen.another_shader.video_x\[5\] net726 sg13g2_dfrbpq_1
X_4475_ net697 VPWR _1482_ VGND _1478_ _1481_ sg13g2_o21ai_1
X_3426_ _0802_ net666 _0788_ VPWR VGND sg13g2_nand2_2
X_3357_ VPWR _0750_ net1 VGND sg13g2_inv_1
X_6145_ net787 net830 _0205_ VPWR VGND sg13g2_nor2_1
X_6076_ net772 net815 _0137_ VPWR VGND sg13g2_nor2_1
X_5027_ _2019_ _2033_ _2034_ VPWR VGND sg13g2_and2_1
XFILLER_38_372 VPWR VGND sg13g2_decap_8
X_6622__358 VPWR VGND net358 sg13g2_tiehi
XFILLER_26_578 VPWR VGND sg13g2_fill_1
XFILLER_41_559 VPWR VGND sg13g2_decap_8
X_5929_ VPWR _0702_ _2856_ VGND sg13g2_inv_1
XFILLER_22_773 VPWR VGND sg13g2_decap_4
XFILLER_1_622 VPWR VGND sg13g2_decap_8
XFILLER_49_604 VPWR VGND sg13g2_decap_8
XFILLER_48_125 VPWR VGND sg13g2_fill_2
XFILLER_48_114 VPWR VGND sg13g2_decap_8
XFILLER_1_699 VPWR VGND sg13g2_decap_8
XFILLER_45_876 VPWR VGND sg13g2_decap_8
X_6424__65 VPWR VGND net65 sg13g2_tiehi
XFILLER_13_784 VPWR VGND sg13g2_decap_8
X_6493__311 VPWR VGND net311 sg13g2_tiehi
XFILLER_5_994 VPWR VGND sg13g2_decap_8
X_4260_ _1265_ _1266_ _1267_ VPWR VGND sg13g2_nor2_1
X_4191_ net679 net714 _1198_ VPWR VGND sg13g2_xor2_1
XFILLER_48_670 VPWR VGND sg13g2_fill_2
XFILLER_39_169 VPWR VGND sg13g2_decap_4
XFILLER_39_1026 VPWR VGND sg13g2_fill_2
XFILLER_23_537 VPWR VGND sg13g2_decap_4
X_3975_ videogen.another_shader.time_cnt\[14\] _1018_ videogen.another_shader.time_cnt\[15\]
+ _1024_ VPWR VGND sg13g2_nand3_1
XFILLER_10_209 VPWR VGND sg13g2_decap_8
X_5714_ _2679_ _2676_ _2678_ VPWR VGND sg13g2_xnor2_1
X_6498__299 VPWR VGND net299 sg13g2_tiehi
XFILLER_31_581 VPWR VGND sg13g2_decap_4
X_5645_ VPWR VGND _2575_ net642 net613 _2585_ _2619_ net611 sg13g2_a221oi_1
X_5576_ VGND VPWR red\[0\] _2519_ _0427_ _2557_ sg13g2_a21oi_1
X_4527_ net702 videogen.test_lut_thingy.pixel_feeder_inst.row\[16\]\[3\] videogen.test_lut_thingy.pixel_feeder_inst.row\[18\]\[3\]
+ videogen.test_lut_thingy.pixel_feeder_inst.row\[17\]\[3\] videogen.test_lut_thingy.pixel_feeder_inst.row\[19\]\[3\]
+ net706 _1534_ VPWR VGND sg13g2_mux4_1
X_4458_ _1464_ VPWR _1465_ VGND videogen.test_lut_thingy.pixel_feeder_inst.row\[49\]\[1\]
+ net623 sg13g2_o21ai_1
XFILLER_49_49 VPWR VGND sg13g2_decap_8
Xfanout701 net703 net701 VPWR VGND sg13g2_buf_8
X_3409_ _0771_ _0779_ _0793_ VPWR VGND sg13g2_nor2_2
Xfanout712 videogen.another_shader.video_x\[6\] net712 VPWR VGND sg13g2_buf_8
Xfanout723 net724 net723 VPWR VGND sg13g2_buf_1
Xfanout756 net757 net756 VPWR VGND sg13g2_buf_8
Xfanout734 net736 net734 VPWR VGND sg13g2_buf_8
X_4389_ _1392_ _1393_ _1394_ _1395_ _1396_ VPWR VGND sg13g2_nor4_1
X_6128_ net781 net824 _0188_ VPWR VGND sg13g2_nor2_1
Xfanout745 clk_video net745 VPWR VGND sg13g2_buf_8
Xfanout767 net771 net767 VPWR VGND sg13g2_buf_8
Xfanout789 net790 net789 VPWR VGND sg13g2_buf_8
Xfanout778 net779 net778 VPWR VGND sg13g2_buf_8
X_6059_ net773 net816 _0120_ VPWR VGND sg13g2_nor2_1
XFILLER_42_824 VPWR VGND sg13g2_decap_8
XFILLER_41_312 VPWR VGND sg13g2_decap_4
XFILLER_14_526 VPWR VGND sg13g2_fill_2
XFILLER_26_386 VPWR VGND sg13g2_fill_1
XFILLER_42_868 VPWR VGND sg13g2_decap_8
XFILLER_10_743 VPWR VGND sg13g2_decap_8
XFILLER_14_96 VPWR VGND sg13g2_fill_2
XFILLER_22_581 VPWR VGND sg13g2_fill_2
XFILLER_22_592 VPWR VGND sg13g2_decap_4
XFILLER_30_62 VPWR VGND sg13g2_decap_8
XFILLER_7_1002 VPWR VGND sg13g2_decap_8
XFILLER_2_986 VPWR VGND sg13g2_decap_8
XFILLER_1_463 VPWR VGND sg13g2_decap_8
XFILLER_49_445 VPWR VGND sg13g2_decap_8
XFILLER_49_489 VPWR VGND sg13g2_fill_2
XFILLER_49_478 VPWR VGND sg13g2_decap_8
XFILLER_17_331 VPWR VGND sg13g2_fill_2
X_3760_ VGND VPWR net621 _0895_ _0896_ net666 sg13g2_a21oi_1
XFILLER_9_552 VPWR VGND sg13g2_decap_4
X_5430_ _2412_ _2417_ _2423_ VPWR VGND sg13g2_nor2_1
X_3691_ videogen.test_lut_thingy.pixel_feeder_inst.row\[16\]\[2\] net862 _0869_ _0442_
+ VPWR VGND sg13g2_mux2_1
X_5361_ _2354_ _2286_ _2353_ VPWR VGND sg13g2_xnor2_1
X_4312_ _1319_ net703 net707 VPWR VGND sg13g2_nand2b_1
X_5292_ _2285_ _1185_ _2282_ VPWR VGND sg13g2_nand2_1
X_4243_ _1250_ net678 videogen.another_shader.video_x\[0\] VPWR VGND sg13g2_xnor2_1
X_4174_ _1181_ _1171_ _1174_ VPWR VGND sg13g2_xnor2_1
X_3958_ videogen.another_shader.time_cnt\[10\] _1007_ videogen.another_shader.time_cnt\[11\]
+ _1011_ VPWR VGND sg13g2_nand3_1
X_6656__251 VPWR VGND net251 sg13g2_tiehi
X_3889_ VPWR _0967_ _0966_ VGND sg13g2_inv_1
X_5628_ tmds_green.dc_balancing_reg\[4\] _2598_ _2602_ _2603_ _2605_ VPWR VGND sg13g2_nor4_1
X_5559_ _2541_ _2539_ _2543_ VPWR VGND sg13g2_nor2b_1
XFILLER_47_916 VPWR VGND sg13g2_decap_8
X_6448__474 VPWR VGND net474 sg13g2_tiehi
XFILLER_27_651 VPWR VGND sg13g2_fill_1
XFILLER_27_662 VPWR VGND sg13g2_fill_1
XFILLER_41_131 VPWR VGND sg13g2_fill_2
X_6559__469 VPWR VGND net469 sg13g2_tiehi
XFILLER_6_522 VPWR VGND sg13g2_fill_2
XFILLER_41_94 VPWR VGND sg13g2_fill_2
XFILLER_6_555 VPWR VGND sg13g2_fill_1
XFILLER_29_1025 VPWR VGND sg13g2_decap_4
XFILLER_2_11 VPWR VGND sg13g2_decap_8
XFILLER_38_916 VPWR VGND sg13g2_decap_8
XFILLER_2_77 VPWR VGND sg13g2_decap_8
XFILLER_37_404 VPWR VGND sg13g2_fill_1
XFILLER_46_960 VPWR VGND sg13g2_decap_8
X_4930_ _1741_ _1912_ _1927_ _1935_ _1937_ VPWR VGND sg13g2_nor4_1
XFILLER_18_695 VPWR VGND sg13g2_fill_2
XFILLER_24_109 VPWR VGND sg13g2_decap_8
X_4861_ VGND VPWR _1868_ _1746_ videogen.another_shader.time_cnt\[20\] sg13g2_or2_1
X_3812_ net845 _0745_ _0924_ VPWR VGND sg13g2_nor2_2
X_6600_ net95 VGND VPWR _0655_ blue_tmds_par\[1\] net743 sg13g2_dfrbpq_1
XFILLER_33_687 VPWR VGND sg13g2_decap_8
X_4792_ _1799_ _1783_ _1798_ VPWR VGND sg13g2_nand2_1
XFILLER_32_197 VPWR VGND sg13g2_decap_8
X_6276__308 VPWR VGND net308 sg13g2_tiehi
X_6531_ net133 VGND VPWR _0586_ videogen.test_lut_thingy.pixel_feeder_inst.row\[4\]\[0\]
+ _0173_ sg13g2_dfrbpq_1
X_3743_ videogen.test_lut_thingy.pixel_feeder_inst.row\[34\]\[0\] net889 _0879_ _0264_
+ VPWR VGND sg13g2_mux2_1
X_6462_ net446 VGND VPWR _0517_ videogen.test_lut_thingy.pixel_feeder_inst.row\[0\]\[0\]
+ _0113_ sg13g2_dfrbpq_1
X_3674_ _0778_ _0854_ _0866_ VPWR VGND sg13g2_nor2_2
X_5413_ _2406_ _2402_ _2405_ VPWR VGND sg13g2_nand2_1
X_6393_ net110 VGND VPWR _0452_ videogen.test_lut_thingy.pixel_feeder_inst.row\[13\]\[0\]
+ _0057_ sg13g2_dfrbpq_1
X_5344_ _2337_ _1250_ _2336_ VPWR VGND sg13g2_nand2b_1
X_5275_ _2182_ _2178_ _1566_ _2269_ VPWR VGND sg13g2_a21o_1
X_4226_ _1232_ _1215_ _1233_ VPWR VGND sg13g2_xor2_1
X_4157_ _1148_ _1140_ _1139_ _1164_ VPWR VGND sg13g2_a21o_1
XFILLER_28_426 VPWR VGND sg13g2_decap_4
XFILLER_44_919 VPWR VGND sg13g2_decap_8
XFILLER_37_960 VPWR VGND sg13g2_decap_8
X_4088_ _1103_ _1102_ net670 VPWR VGND sg13g2_nand2b_1
XFILLER_12_838 VPWR VGND sg13g2_fill_2
XFILLER_11_315 VPWR VGND sg13g2_fill_2
XFILLER_11_326 VPWR VGND sg13g2_fill_1
XFILLER_11_337 VPWR VGND sg13g2_decap_8
XFILLER_2_4 VPWR VGND sg13g2_decap_8
XFILLER_19_404 VPWR VGND sg13g2_decap_8
XFILLER_35_919 VPWR VGND sg13g2_decap_8
XFILLER_27_492 VPWR VGND sg13g2_fill_1
XFILLER_43_996 VPWR VGND sg13g2_decap_8
XFILLER_30_646 VPWR VGND sg13g2_decap_4
XFILLER_7_831 VPWR VGND sg13g2_decap_8
XFILLER_11_871 VPWR VGND sg13g2_fill_2
X_3390_ _0782_ net685 _0780_ VPWR VGND sg13g2_xnor2_1
X_5060_ _2049_ _2066_ _2042_ _2067_ VPWR VGND sg13g2_nand3_1
XFILLER_42_1022 VPWR VGND sg13g2_decap_8
X_4011_ VGND VPWR _1049_ _1048_ videogen.another_shader.time_cnt\[26\] sg13g2_or2_1
XFILLER_37_201 VPWR VGND sg13g2_decap_8
XFILLER_38_768 VPWR VGND sg13g2_fill_2
X_5962_ net770 net812 _0023_ VPWR VGND sg13g2_nor2_1
XFILLER_18_470 VPWR VGND sg13g2_decap_8
X_6620__401 VPWR VGND net401 sg13g2_tiehi
X_4913_ VGND VPWR _1896_ _1918_ _1920_ _1888_ sg13g2_a21oi_1
X_5893_ _2838_ VPWR _0664_ VGND net525 _0944_ sg13g2_o21ai_1
XFILLER_33_440 VPWR VGND sg13g2_fill_2
X_4844_ _1754_ _1850_ _1851_ VPWR VGND sg13g2_nor2_1
X_4775_ _1777_ _1781_ _1782_ VPWR VGND _1776_ sg13g2_nand3b_1
XFILLER_20_134 VPWR VGND sg13g2_decap_8
X_6514_ net245 VGND VPWR _0569_ videogen.test_lut_thingy.pixel_feeder_inst.row\[27\]\[3\]
+ _0156_ sg13g2_dfrbpq_1
X_3726_ videogen.test_lut_thingy.pixel_feeder_inst.row\[39\]\[2\] net865 _0876_ _0294_
+ VPWR VGND sg13g2_mux2_1
X_6445_ net480 VGND VPWR _0500_ videogen.test_lut_thingy.pixel_feeder_inst.row\[8\]\[3\]
+ _0096_ sg13g2_dfrbpq_1
X_3657_ videogen.test_lut_thingy.pixel_feeder_inst.row\[32\]\[1\] net878 _0862_ _0478_
+ VPWR VGND sg13g2_mux2_1
X_6376_ net140 VGND VPWR _0435_ videogen.test_lut_thingy.pixel_feeder_inst.row\[12\]\[3\]
+ _0044_ sg13g2_dfrbpq_1
X_3588_ net862 videogen.test_lut_thingy.pixel_feeder_inst.row\[56\]\[2\] _0846_ _0531_
+ VPWR VGND sg13g2_mux2_1
X_5327_ _2320_ _2185_ _2274_ VPWR VGND sg13g2_xnor2_1
XFILLER_0_539 VPWR VGND sg13g2_decap_8
X_5258_ VGND VPWR _2257_ _2255_ _2247_ sg13g2_or2_1
X_5189_ VPWR _2188_ _2187_ VGND sg13g2_inv_1
X_4209_ _1195_ _1215_ _1216_ VPWR VGND sg13g2_nor2_1
XFILLER_28_256 VPWR VGND sg13g2_fill_1
XFILLER_24_440 VPWR VGND sg13g2_fill_2
XFILLER_40_944 VPWR VGND sg13g2_decap_8
XFILLER_7_105 VPWR VGND sg13g2_fill_1
X_6643__467 VPWR VGND net467 sg13g2_tiehi
XFILLER_42_281 VPWR VGND sg13g2_fill_1
XFILLER_8_10 VPWR VGND sg13g2_fill_1
XFILLER_30_454 VPWR VGND sg13g2_decap_8
XFILLER_8_76 VPWR VGND sg13g2_decap_8
XFILLER_8_54 VPWR VGND sg13g2_fill_2
X_4560_ _1567_ _1565_ VPWR VGND _1566_ sg13g2_nand2b_2
XFILLER_7_694 VPWR VGND sg13g2_fill_2
X_3511_ _0817_ _0821_ _0831_ VPWR VGND sg13g2_nor2_2
X_4491_ videogen.test_lut_thingy.pixel_feeder_inst.row\[40\]\[1\] net650 _1498_ VPWR
+ VGND sg13g2_nor2_1
X_6230_ net392 VGND VPWR _0289_ videogen.test_lut_thingy.pixel_feeder_inst.row\[1\]\[1\]
+ _0014_ sg13g2_dfrbpq_1
X_3442_ _0810_ _0809_ VPWR VGND _0794_ sg13g2_nand2b_2
X_6161_ net762 net804 _0221_ VPWR VGND sg13g2_nor2_1
X_3373_ VPWR _0765_ _0764_ VGND sg13g2_inv_1
X_5112_ _2097_ _2113_ _1676_ _2119_ VPWR VGND _2114_ sg13g2_nand4_1
X_6092_ net793 net838 _0152_ VPWR VGND sg13g2_nor2_1
XFILLER_26_0 VPWR VGND sg13g2_fill_1
X_5043_ _2050_ _1713_ _2048_ VPWR VGND sg13g2_xnor2_1
XFILLER_26_727 VPWR VGND sg13g2_fill_1
X_5945_ net792 net835 _0006_ VPWR VGND sg13g2_nor2_1
X_5876_ VGND VPWR _2826_ _2828_ _0657_ _2817_ sg13g2_a21oi_1
X_4827_ _1834_ _1830_ _1833_ VPWR VGND sg13g2_nand2_1
X_4758_ VGND VPWR _1765_ _1764_ _0724_ sg13g2_or2_1
X_4689_ _1696_ _1694_ _1695_ VPWR VGND sg13g2_nand2_1
X_3709_ _0873_ _0824_ VPWR VGND _0790_ sg13g2_nand2b_2
X_6428_ net57 VGND VPWR _0483_ videogen.test_lut_thingy.pixel_feeder_inst.row\[9\]\[2\]
+ _0079_ sg13g2_dfrbpq_1
X_6359_ net160 VGND VPWR _0418_ red\[4\] net727 sg13g2_dfrbpq_2
XFILLER_0_336 VPWR VGND sg13g2_decap_8
XFILLER_1_837 VPWR VGND sg13g2_decap_8
X_6436__41 VPWR VGND net41 sg13g2_tiehi
XFILLER_44_524 VPWR VGND sg13g2_fill_1
XFILLER_1_1019 VPWR VGND sg13g2_decap_8
XFILLER_17_727 VPWR VGND sg13g2_fill_2
XFILLER_25_782 VPWR VGND sg13g2_decap_8
XFILLER_9_904 VPWR VGND sg13g2_fill_2
X_6302__256 VPWR VGND net256 sg13g2_tiehi
XFILLER_9_948 VPWR VGND sg13g2_decap_8
XFILLER_4_686 VPWR VGND sg13g2_decap_8
Xhold3 serialize.bit_cnt\[0\] VPWR VGND net491 sg13g2_dlygate4sd3_1
XFILLER_48_874 VPWR VGND sg13g2_decap_8
XFILLER_47_373 VPWR VGND sg13g2_decap_8
XFILLER_47_384 VPWR VGND sg13g2_fill_1
XFILLER_35_524 VPWR VGND sg13g2_fill_1
XFILLER_35_546 VPWR VGND sg13g2_fill_1
X_3991_ _1035_ videogen.another_shader.time_cnt\[20\] _1033_ VPWR VGND sg13g2_nand2_1
XFILLER_22_207 VPWR VGND sg13g2_decap_8
X_5730_ _2690_ blue\[3\] blue\[2\] VPWR VGND sg13g2_nand2_1
XFILLER_31_730 VPWR VGND sg13g2_decap_8
XFILLER_30_240 VPWR VGND sg13g2_fill_2
XFILLER_31_741 VPWR VGND sg13g2_fill_1
X_5661_ VGND VPWR net610 _2627_ _2629_ net612 sg13g2_a21oi_1
X_4612_ videogen.test_lut_thingy.pixel_feeder_inst.row\[59\]\[0\] net655 _1619_ VPWR
+ VGND sg13g2_nor2_1
X_5592_ green\[6\] _2568_ _2569_ VPWR VGND sg13g2_nor2_1
XFILLER_30_295 VPWR VGND sg13g2_decap_8
XFILLER_8_992 VPWR VGND sg13g2_decap_8
X_4543_ VGND VPWR _1521_ _1526_ _1550_ net693 sg13g2_a21oi_1
X_4474_ _1480_ VPWR _1481_ VGND videogen.test_lut_thingy.pixel_feeder_inst.row\[61\]\[1\]
+ net626 sg13g2_o21ai_1
X_6213_ net414 VGND VPWR _0272_ videogen.another_shader.video_x\[4\] net726 sg13g2_dfrbpq_2
X_3425_ _0801_ net704 _0800_ VPWR VGND sg13g2_nand2_2
X_3356_ VPWR _0749_ videogen.fancy_shader.shader_counter_reg\[8\] VGND sg13g2_inv_1
X_6144_ net786 net829 _0204_ VPWR VGND sg13g2_nor2_1
XFILLER_39_830 VPWR VGND sg13g2_decap_8
X_6075_ net760 net802 _0136_ VPWR VGND sg13g2_nor2_1
X_5026_ _2018_ _2009_ _2008_ _2033_ VPWR VGND sg13g2_a21o_1
XFILLER_38_362 VPWR VGND sg13g2_fill_1
X_5928_ _2856_ net749 net512 net754 red_tmds_par\[1\] VPWR VGND sg13g2_a22oi_1
X_5859_ VPWR VGND _2757_ _2814_ _2815_ _2781_ _2816_ _2807_ sg13g2_a221oi_1
XFILLER_6_929 VPWR VGND sg13g2_decap_8
XFILLER_1_601 VPWR VGND sg13g2_decap_8
XFILLER_0_133 VPWR VGND sg13g2_fill_1
XFILLER_1_678 VPWR VGND sg13g2_decap_8
XFILLER_49_638 VPWR VGND sg13g2_decap_8
XFILLER_0_177 VPWR VGND sg13g2_decap_4
XFILLER_48_137 VPWR VGND sg13g2_decap_8
X_6627__259 VPWR VGND net259 sg13g2_tiehi
XFILLER_0_199 VPWR VGND sg13g2_fill_2
X_6369__150 VPWR VGND net150 sg13g2_tiehi
XFILLER_45_855 VPWR VGND sg13g2_decap_8
XFILLER_44_72 VPWR VGND sg13g2_fill_1
XFILLER_9_701 VPWR VGND sg13g2_fill_2
XFILLER_13_741 VPWR VGND sg13g2_decap_8
XFILLER_12_251 VPWR VGND sg13g2_decap_4
X_6458__454 VPWR VGND net454 sg13g2_tiehi
XFILLER_8_288 VPWR VGND sg13g2_fill_1
XFILLER_5_11 VPWR VGND sg13g2_fill_2
XFILLER_5_973 VPWR VGND sg13g2_decap_8
XFILLER_4_461 VPWR VGND sg13g2_fill_2
X_4190_ _1197_ _1157_ _1196_ VPWR VGND sg13g2_xnor2_1
XFILLER_48_660 VPWR VGND sg13g2_fill_2
XFILLER_36_822 VPWR VGND sg13g2_decap_4
XFILLER_35_310 VPWR VGND sg13g2_decap_4
XFILLER_35_332 VPWR VGND sg13g2_fill_2
XFILLER_39_1005 VPWR VGND sg13g2_decap_8
XFILLER_35_376 VPWR VGND sg13g2_fill_1
X_3974_ net895 VPWR _1023_ VGND videogen.another_shader.time_cnt\[15\] _1019_ sg13g2_o21ai_1
X_6621__381 VPWR VGND net381 sg13g2_tiehi
X_5713_ _2677_ tmds_green.dc_balancing_reg\[4\] _2678_ VPWR VGND sg13g2_xor2_1
X_5644_ _2585_ net611 net613 _2618_ VPWR VGND sg13g2_nor3_1
X_6535__117 VPWR VGND net117 sg13g2_tiehi
X_5575_ net632 VPWR _2557_ VGND red\[0\] _2519_ sg13g2_o21ai_1
X_4526_ net685 _1532_ _1533_ VPWR VGND sg13g2_nor2_1
XFILLER_49_28 VPWR VGND sg13g2_decap_8
XFILLER_46_1009 VPWR VGND sg13g2_decap_8
X_4457_ _1464_ net652 videogen.test_lut_thingy.pixel_feeder_inst.row\[48\]\[1\] VPWR
+ VGND sg13g2_nand2b_1
X_3408_ videogen.test_lut_thingy.pixel_feeder_inst.row\[22\]\[0\] net888 _0792_ _0677_
+ VPWR VGND sg13g2_mux2_1
Xfanout713 videogen.another_shader.video_x\[5\] net713 VPWR VGND sg13g2_buf_8
Xfanout702 net703 net702 VPWR VGND sg13g2_buf_8
Xfanout724 clk_video net724 VPWR VGND sg13g2_buf_8
Xfanout757 net761 net757 VPWR VGND sg13g2_buf_8
X_4388_ videogen.test_lut_thingy.pixel_feeder_inst.row\[47\]\[2\] net658 _1395_ VPWR
+ VGND sg13g2_nor2_1
X_6127_ net784 net827 _0187_ VPWR VGND sg13g2_nor2_1
Xfanout735 net736 net735 VPWR VGND sg13g2_buf_1
Xfanout746 net750 net746 VPWR VGND sg13g2_buf_8
Xfanout768 net770 net768 VPWR VGND sg13g2_buf_8
X_3339_ VPWR _0732_ videogen.another_shader.time_cnt\[11\] VGND sg13g2_inv_1
Xfanout779 net782 net779 VPWR VGND sg13g2_buf_8
XFILLER_22_1020 VPWR VGND sg13g2_decap_8
X_6058_ net774 net817 _0119_ VPWR VGND sg13g2_nor2_1
XFILLER_39_693 VPWR VGND sg13g2_decap_4
X_5009_ _1998_ VPWR _2016_ VGND _1993_ _2002_ sg13g2_o21ai_1
XFILLER_42_803 VPWR VGND sg13g2_decap_8
XFILLER_10_722 VPWR VGND sg13g2_decap_4
XFILLER_5_269 VPWR VGND sg13g2_fill_1
XFILLER_2_965 VPWR VGND sg13g2_decap_8
XFILLER_1_442 VPWR VGND sg13g2_decap_8
XFILLER_49_424 VPWR VGND sg13g2_decap_8
XFILLER_17_310 VPWR VGND sg13g2_fill_2
XFILLER_32_335 VPWR VGND sg13g2_fill_2
XFILLER_40_390 VPWR VGND sg13g2_decap_8
X_3690_ videogen.test_lut_thingy.pixel_feeder_inst.row\[16\]\[3\] net851 _0869_ _0443_
+ VPWR VGND sg13g2_mux2_1
X_5360_ _1181_ _2352_ _2353_ VPWR VGND sg13g2_nor2b_1
X_4311_ videogen.test_lut_thingy.pixel_feeder_inst.row\[27\]\[2\] net656 _1318_ VPWR
+ VGND sg13g2_nor2_1
X_5291_ VPWR _2284_ _2283_ VGND sg13g2_inv_1
X_4242_ videogen.fancy_shader.shader_counter_reg\[0\] net678 _1249_ VPWR VGND sg13g2_xor2_1
X_4173_ _1180_ _1160_ _1178_ VPWR VGND sg13g2_nand2_1
XFILLER_27_107 VPWR VGND sg13g2_decap_4
XFILLER_36_685 VPWR VGND sg13g2_fill_2
X_3957_ VGND VPWR videogen.another_shader.time_cnt\[10\] _1007_ _1010_ videogen.another_shader.time_cnt\[11\]
+ sg13g2_a21oi_1
Xclkbuf_0_clk_regs clk_regs clknet_0_clk_regs VPWR VGND sg13g2_buf_8
X_3888_ net621 _0965_ videogen.test_lut_thingy.pixel_feeder_inst.h_counter\[3\] _0966_
+ VPWR VGND sg13g2_nand3_1
XFILLER_13_1008 VPWR VGND sg13g2_decap_8
X_6359__160 VPWR VGND net160 sg13g2_tiehi
X_5627_ VPWR _2604_ _2603_ VGND sg13g2_inv_1
XFILLER_3_707 VPWR VGND sg13g2_fill_2
X_5558_ _2539_ _2541_ _2542_ VPWR VGND sg13g2_nor2b_1
X_4509_ _1515_ VPWR _1516_ VGND videogen.test_lut_thingy.pixel_feeder_inst.row\[54\]\[3\]
+ net634 sg13g2_o21ai_1
X_5489_ VGND VPWR red\[2\] _2460_ _2475_ _2459_ sg13g2_a21oi_1
XFILLER_2_239 VPWR VGND sg13g2_decap_8
X_6366__153 VPWR VGND net153 sg13g2_tiehi
XFILLER_42_622 VPWR VGND sg13g2_fill_2
XFILLER_15_825 VPWR VGND sg13g2_fill_1
XFILLER_26_151 VPWR VGND sg13g2_fill_2
XFILLER_26_173 VPWR VGND sg13g2_fill_2
XFILLER_41_176 VPWR VGND sg13g2_fill_2
X_6373__146 VPWR VGND net146 sg13g2_tiehi
X_6646__443 VPWR VGND net443 sg13g2_tiehi
XFILLER_37_449 VPWR VGND sg13g2_fill_2
X_4860_ VGND VPWR _1867_ _1865_ _1864_ sg13g2_or2_1
XFILLER_36_1008 VPWR VGND sg13g2_decap_8
X_3811_ VGND VPWR _0886_ _0893_ _0000_ _0899_ sg13g2_a21oi_1
XFILLER_32_154 VPWR VGND sg13g2_fill_1
X_4791_ _1784_ _1782_ _1780_ _1798_ VPWR VGND sg13g2_a21o_1
X_6530_ net141 VGND VPWR _0585_ videogen.test_lut_thingy.pixel_feeder_inst.row\[50\]\[3\]
+ _0172_ sg13g2_dfrbpq_1
XFILLER_33_699 VPWR VGND sg13g2_decap_4
X_6554__32 VPWR VGND net32 sg13g2_tiehi
X_3742_ videogen.test_lut_thingy.pixel_feeder_inst.row\[34\]\[1\] net878 _0879_ _0265_
+ VPWR VGND sg13g2_mux2_1
X_3673_ videogen.test_lut_thingy.pixel_feeder_inst.row\[14\]\[0\] net886 _0865_ _0456_
+ VPWR VGND sg13g2_mux2_1
X_6461_ net448 VGND VPWR _0516_ videogen.test_lut_thingy.pixel_feeder_inst.row\[5\]\[3\]
+ _0112_ sg13g2_dfrbpq_1
X_5412_ _2405_ _2403_ _2404_ VPWR VGND sg13g2_xnor2_1
X_6392_ net112 VGND VPWR _0451_ videogen.test_lut_thingy.pixel_feeder_inst.row\[11\]\[3\]
+ _0056_ sg13g2_dfrbpq_1
X_5343_ VGND VPWR _2319_ _2332_ _2336_ _2330_ sg13g2_a21oi_1
X_5274_ _1413_ _1510_ _1565_ _2268_ VPWR VGND sg13g2_nor3_1
X_4225_ _1222_ VPWR _1232_ VGND _1219_ _1226_ sg13g2_o21ai_1
X_4156_ videogen.fancy_shader.shader_counter_reg\[8\] net709 _1163_ VPWR VGND sg13g2_xor2_1
X_4087_ _0392_ net893 _1101_ _1102_ VPWR VGND sg13g2_and3_1
XFILLER_24_600 VPWR VGND sg13g2_fill_2
XFILLER_36_460 VPWR VGND sg13g2_fill_2
X_6224__400 VPWR VGND net400 sg13g2_tiehi
XFILLER_23_121 VPWR VGND sg13g2_fill_1
XFILLER_11_305 VPWR VGND sg13g2_decap_4
X_4989_ _1965_ _1979_ _1995_ _1996_ VPWR VGND sg13g2_or3_1
XFILLER_11_43 VPWR VGND sg13g2_decap_4
XFILLER_47_714 VPWR VGND sg13g2_fill_2
XFILLER_4_1028 VPWR VGND sg13g2_fill_1
XFILLER_4_1017 VPWR VGND sg13g2_decap_8
XFILLER_15_633 VPWR VGND sg13g2_decap_8
XFILLER_43_975 VPWR VGND sg13g2_decap_8
XFILLER_15_655 VPWR VGND sg13g2_fill_2
XFILLER_7_810 VPWR VGND sg13g2_fill_1
XFILLER_30_669 VPWR VGND sg13g2_fill_2
XFILLER_42_1001 VPWR VGND sg13g2_decap_8
X_6312__236 VPWR VGND net236 sg13g2_tiehi
X_4010_ net847 _1047_ _1048_ _0369_ VPWR VGND sg13g2_nor3_1
XFILLER_38_736 VPWR VGND sg13g2_fill_1
X_6349__170 VPWR VGND net170 sg13g2_tiehi
X_5961_ net769 net812 _0022_ VPWR VGND sg13g2_nor2_1
X_4912_ _1919_ _1888_ _1896_ _1918_ VPWR VGND sg13g2_and3_1
XFILLER_21_603 VPWR VGND sg13g2_fill_2
X_5892_ VGND VPWR net525 _0945_ _2838_ net845 sg13g2_a21oi_1
XFILLER_33_463 VPWR VGND sg13g2_decap_8
XFILLER_34_986 VPWR VGND sg13g2_decap_8
X_4843_ VGND VPWR _1843_ _1850_ _1849_ _1847_ sg13g2_a21oi_2
XFILLER_21_647 VPWR VGND sg13g2_fill_1
X_4774_ VGND VPWR _1768_ _1771_ _1781_ _1779_ sg13g2_a21oi_1
X_6513_ net249 VGND VPWR _0568_ videogen.test_lut_thingy.pixel_feeder_inst.row\[27\]\[2\]
+ _0155_ sg13g2_dfrbpq_1
X_3725_ videogen.test_lut_thingy.pixel_feeder_inst.row\[39\]\[3\] net855 _0876_ _0295_
+ VPWR VGND sg13g2_mux2_1
X_6444_ net482 VGND VPWR _0499_ videogen.test_lut_thingy.pixel_feeder_inst.row\[8\]\[2\]
+ _0095_ sg13g2_dfrbpq_1
X_6356__163 VPWR VGND net163 sg13g2_tiehi
X_3656_ videogen.test_lut_thingy.pixel_feeder_inst.row\[32\]\[2\] net867 _0862_ _0479_
+ VPWR VGND sg13g2_mux2_1
X_6375_ net142 VGND VPWR _0434_ videogen.test_lut_thingy.pixel_feeder_inst.row\[12\]\[2\]
+ _0043_ sg13g2_dfrbpq_1
X_3587_ net851 videogen.test_lut_thingy.pixel_feeder_inst.row\[56\]\[3\] _0846_ _0532_
+ VPWR VGND sg13g2_mux2_1
XFILLER_0_518 VPWR VGND sg13g2_decap_8
X_5326_ _2319_ _2276_ _2317_ VPWR VGND sg13g2_xnor2_1
X_5257_ _2255_ _2247_ _2245_ _2256_ VPWR VGND sg13g2_a21o_1
X_4208_ _1207_ VPWR _1215_ VGND _1200_ _1205_ sg13g2_o21ai_1
X_5188_ _2187_ _1137_ _2186_ VPWR VGND sg13g2_xnor2_1
X_4139_ _1123_ _1143_ _1144_ _1146_ VPWR VGND sg13g2_nor3_1
XFILLER_28_224 VPWR VGND sg13g2_decap_4
X_6363__156 VPWR VGND net156 sg13g2_tiehi
XFILLER_40_923 VPWR VGND sg13g2_decap_8
XFILLER_11_135 VPWR VGND sg13g2_decap_8
XFILLER_7_128 VPWR VGND sg13g2_decap_8
XFILLER_22_42 VPWR VGND sg13g2_fill_2
X_6370__149 VPWR VGND net149 sg13g2_tiehi
XFILLER_3_389 VPWR VGND sg13g2_decap_4
XFILLER_19_235 VPWR VGND sg13g2_fill_2
XFILLER_19_268 VPWR VGND sg13g2_fill_1
XFILLER_28_791 VPWR VGND sg13g2_fill_1
XFILLER_43_761 VPWR VGND sg13g2_fill_2
XFILLER_16_975 VPWR VGND sg13g2_fill_1
X_3510_ videogen.test_lut_thingy.pixel_feeder_inst.row\[45\]\[0\] net887 _0830_ _0602_
+ VPWR VGND sg13g2_mux2_1
XFILLER_30_499 VPWR VGND sg13g2_decap_4
X_4490_ videogen.test_lut_thingy.pixel_feeder_inst.row\[43\]\[1\] net660 _1497_ VPWR
+ VGND sg13g2_nor2_1
X_3441_ _0802_ _0806_ _0809_ VPWR VGND sg13g2_nor2_2
X_6160_ net783 net826 _0220_ VPWR VGND sg13g2_nor2_1
X_3372_ _0764_ net711 _0763_ VPWR VGND sg13g2_nand2_1
X_5111_ _1676_ _2097_ _2113_ _2114_ _2118_ VPWR VGND sg13g2_and4_1
XFILLER_3_890 VPWR VGND sg13g2_fill_1
X_6091_ net793 net838 _0151_ VPWR VGND sg13g2_nor2_1
X_6468__434 VPWR VGND net434 sg13g2_tiehi
X_5042_ VGND VPWR _2049_ _2048_ _1713_ sg13g2_or2_1
XFILLER_19_0 VPWR VGND sg13g2_fill_2
XFILLER_26_706 VPWR VGND sg13g2_decap_8
X_5944_ net524 net898 net752 _0711_ VPWR VGND sg13g2_a21o_1
X_5875_ _2827_ VPWR _2828_ VGND _2731_ _2752_ sg13g2_o21ai_1
XFILLER_33_271 VPWR VGND sg13g2_fill_2
X_4826_ _1824_ _1832_ _1833_ VPWR VGND sg13g2_and2_1
X_4757_ _1021_ _1053_ _1729_ _1756_ _1764_ VPWR VGND sg13g2_or4_1
X_4688_ _1695_ net673 _1693_ VPWR VGND sg13g2_nand2_1
X_3708_ videogen.test_lut_thingy.pixel_feeder_inst.row\[37\]\[0\] net887 _0872_ _0336_
+ VPWR VGND sg13g2_mux2_1
X_3639_ videogen.test_lut_thingy.pixel_feeder_inst.row\[30\]\[2\] net867 _0857_ _0491_
+ VPWR VGND sg13g2_mux2_1
X_6427_ net59 VGND VPWR _0482_ videogen.test_lut_thingy.pixel_feeder_inst.row\[9\]\[1\]
+ _0078_ sg13g2_dfrbpq_1
XFILLER_1_816 VPWR VGND sg13g2_decap_8
X_6358_ net161 VGND VPWR _0417_ red\[0\] net735 sg13g2_dfrbpq_2
XFILLER_0_315 VPWR VGND sg13g2_decap_8
X_5309_ _2302_ _2291_ _2298_ VPWR VGND sg13g2_nand2_1
X_6289_ net282 VGND VPWR _0348_ videogen.another_shader.time_cnt\[4\] net734 sg13g2_dfrbpq_2
XFILLER_29_544 VPWR VGND sg13g2_decap_8
XFILLER_29_555 VPWR VGND sg13g2_fill_2
XFILLER_44_503 VPWR VGND sg13g2_fill_1
X_6265__330 VPWR VGND net330 sg13g2_tiehi
XFILLER_40_786 VPWR VGND sg13g2_decap_8
XFILLER_4_610 VPWR VGND sg13g2_decap_8
X_6339__180 VPWR VGND net180 sg13g2_tiehi
XFILLER_4_665 VPWR VGND sg13g2_decap_8
XFILLER_0_893 VPWR VGND sg13g2_decap_8
Xhold4 serialize.shift_reg_c\[4\] VPWR VGND net492 sg13g2_dlygate4sd3_1
XFILLER_48_853 VPWR VGND sg13g2_decap_8
XFILLER_47_352 VPWR VGND sg13g2_decap_8
XFILLER_35_514 VPWR VGND sg13g2_fill_1
X_3990_ VGND VPWR _1034_ _1033_ videogen.another_shader.time_cnt\[20\] sg13g2_or2_1
X_6346__173 VPWR VGND net173 sg13g2_tiehi
XFILLER_15_260 VPWR VGND sg13g2_decap_8
X_5660_ VGND VPWR _2628_ _2627_ net610 sg13g2_or2_1
XFILLER_30_252 VPWR VGND sg13g2_fill_2
X_4611_ videogen.test_lut_thingy.pixel_feeder_inst.row\[57\]\[0\] net624 _1618_ VPWR
+ VGND sg13g2_nor2_1
X_5591_ _2568_ green\[3\] _2566_ VPWR VGND sg13g2_xnor2_1
XFILLER_8_971 VPWR VGND sg13g2_decap_8
X_4542_ VGND VPWR net699 _1546_ _1549_ _1548_ sg13g2_a21oi_1
X_6318__220 VPWR VGND net220 sg13g2_tiehi
X_4473_ VGND VPWR _0713_ net662 _1480_ _1479_ sg13g2_a21oi_1
X_3424_ net696 _0771_ net661 net653 _0800_ VPWR VGND sg13g2_nor4_1
X_6212_ net415 VGND VPWR _0271_ videogen.another_shader.video_x\[3\] net725 sg13g2_dfrbpq_1
X_6353__166 VPWR VGND net166 sg13g2_tiehi
X_3355_ VPWR _0748_ videogen.fancy_shader.shader_counter_reg\[9\] VGND sg13g2_inv_1
X_6143_ net788 net831 _0203_ VPWR VGND sg13g2_nor2_1
X_6074_ net760 net802 _0135_ VPWR VGND sg13g2_nor2_1
X_5025_ _2021_ _2026_ _2032_ VPWR VGND _1725_ sg13g2_nand3b_1
XFILLER_26_569 VPWR VGND sg13g2_decap_8
X_5927_ VPWR _0701_ _2855_ VGND sg13g2_inv_1
X_6360__159 VPWR VGND net159 sg13g2_tiehi
X_5858_ _2815_ _2792_ _2813_ VPWR VGND sg13g2_nand2_1
XFILLER_16_1028 VPWR VGND sg13g2_fill_1
X_4809_ _1796_ VPWR _1816_ VGND _1792_ _1799_ sg13g2_o21ai_1
X_5789_ _2749_ _2747_ _2748_ VPWR VGND sg13g2_nand2_1
XFILLER_0_112 VPWR VGND sg13g2_decap_8
XFILLER_1_657 VPWR VGND sg13g2_decap_8
XFILLER_0_167 VPWR VGND sg13g2_decap_4
XFILLER_48_149 VPWR VGND sg13g2_decap_4
XFILLER_45_834 VPWR VGND sg13g2_decap_8
XFILLER_44_311 VPWR VGND sg13g2_fill_1
XFILLER_17_525 VPWR VGND sg13g2_fill_2
XFILLER_44_51 VPWR VGND sg13g2_fill_1
XFILLER_13_720 VPWR VGND sg13g2_fill_1
XFILLER_13_753 VPWR VGND sg13g2_fill_2
XFILLER_8_245 VPWR VGND sg13g2_decap_8
XFILLER_8_234 VPWR VGND sg13g2_decap_4
XFILLER_5_952 VPWR VGND sg13g2_decap_8
XFILLER_5_45 VPWR VGND sg13g2_decap_8
XFILLER_5_23 VPWR VGND sg13g2_fill_1
XFILLER_5_89 VPWR VGND sg13g2_decap_4
XFILLER_39_127 VPWR VGND sg13g2_fill_2
XFILLER_48_694 VPWR VGND sg13g2_fill_2
XFILLER_39_1028 VPWR VGND sg13g2_fill_1
X_3973_ _1011_ _1021_ _1022_ VPWR VGND sg13g2_nor2_1
X_5712_ VGND VPWR _0742_ _2650_ _2677_ _2599_ sg13g2_a21oi_1
XFILLER_16_580 VPWR VGND sg13g2_fill_2
X_5643_ _2605_ net613 _2617_ VPWR VGND sg13g2_nor2_1
XFILLER_31_594 VPWR VGND sg13g2_fill_2
X_5574_ net642 _2556_ _0426_ VPWR VGND sg13g2_nor2_1
X_6472__419 VPWR VGND net419 sg13g2_tiehi
X_4525_ net696 _1531_ _1530_ _1528_ _1529_ net687 _1532_ VPWR VGND sg13g2_mux4_1
X_4456_ videogen.test_lut_thingy.pixel_feeder_inst.row\[50\]\[1\] net634 _1463_ VPWR
+ VGND sg13g2_nor2_1
X_3407_ videogen.test_lut_thingy.pixel_feeder_inst.row\[22\]\[1\] net879 _0792_ _0678_
+ VPWR VGND sg13g2_mux2_1
Xfanout703 videogen.test_lut_thingy.pixel_feeder_inst.h_pix\[1\] net703 VPWR VGND
+ sg13g2_buf_8
Xfanout714 videogen.another_shader.video_x\[5\] net714 VPWR VGND sg13g2_buf_1
X_4387_ videogen.test_lut_thingy.pixel_feeder_inst.row\[45\]\[2\] net627 _1394_ VPWR
+ VGND sg13g2_nor2_1
X_6639__42 VPWR VGND net42 sg13g2_tiehi
X_3338_ VPWR _0731_ videogen.another_shader.time_cnt\[12\] VGND sg13g2_inv_1
Xfanout725 net733 net725 VPWR VGND sg13g2_buf_8
X_6126_ net784 net827 _0186_ VPWR VGND sg13g2_nor2_1
Xfanout736 net737 net736 VPWR VGND sg13g2_buf_8
Xfanout758 net760 net758 VPWR VGND sg13g2_buf_8
Xfanout747 net750 net747 VPWR VGND sg13g2_buf_1
Xfanout769 net770 net769 VPWR VGND sg13g2_buf_8
X_6057_ net767 net809 _0118_ VPWR VGND sg13g2_nor2_1
X_5008_ _2007_ _2013_ _2004_ _2015_ VPWR VGND sg13g2_nand3_1
XFILLER_14_528 VPWR VGND sg13g2_fill_1
XFILLER_26_366 VPWR VGND sg13g2_fill_2
XFILLER_42_859 VPWR VGND sg13g2_decap_4
XFILLER_41_336 VPWR VGND sg13g2_decap_4
XFILLER_14_21 VPWR VGND sg13g2_decap_4
XFILLER_14_43 VPWR VGND sg13g2_fill_2
XFILLER_14_76 VPWR VGND sg13g2_fill_2
XFILLER_14_98 VPWR VGND sg13g2_fill_1
XFILLER_2_944 VPWR VGND sg13g2_decap_8
XFILLER_1_421 VPWR VGND sg13g2_decap_8
XFILLER_49_403 VPWR VGND sg13g2_decap_8
XFILLER_17_333 VPWR VGND sg13g2_fill_1
XFILLER_45_675 VPWR VGND sg13g2_decap_8
XFILLER_17_388 VPWR VGND sg13g2_decap_4
XFILLER_32_347 VPWR VGND sg13g2_fill_2
X_6343__176 VPWR VGND net176 sg13g2_tiehi
XFILLER_9_587 VPWR VGND sg13g2_decap_8
X_4310_ videogen.test_lut_thingy.pixel_feeder_inst.row\[24\]\[2\] net647 _1317_ VPWR
+ VGND sg13g2_nor2_1
XFILLER_5_760 VPWR VGND sg13g2_fill_1
X_5290_ _2283_ _2193_ _2282_ VPWR VGND sg13g2_xnor2_1
X_4241_ _1248_ videogen.fancy_shader.shader_counter_reg\[0\] videogen.another_shader.video_x\[0\]
+ VPWR VGND sg13g2_xnor2_1
X_6350__169 VPWR VGND net169 sg13g2_tiehi
X_4172_ VPWR _1179_ _1178_ VGND sg13g2_inv_1
XFILLER_49_981 VPWR VGND sg13g2_decap_8
XFILLER_23_303 VPWR VGND sg13g2_fill_2
XFILLER_35_174 VPWR VGND sg13g2_decap_4
X_3956_ net843 _1009_ _0354_ VPWR VGND sg13g2_nor2_1
XFILLER_32_892 VPWR VGND sg13g2_fill_1
X_5626_ tmds_green.dc_balancing_reg\[0\] tmds_green.dc_balancing_reg\[1\] tmds_green.dc_balancing_reg\[3\]
+ tmds_green.dc_balancing_reg\[2\] _2603_ VPWR VGND sg13g2_nor4_1
X_3887_ _0965_ _0885_ videogen.test_lut_thingy.pixel_feeder_inst.h_counter\[0\] VPWR
+ VGND sg13g2_nand2b_1
X_5557_ _2514_ _2516_ _2541_ VPWR VGND sg13g2_and2_1
X_5488_ red\[0\] red\[4\] red\[2\] _2474_ VPWR VGND _2458_ sg13g2_nand4_1
X_4508_ _1515_ net653 videogen.test_lut_thingy.pixel_feeder_inst.row\[52\]\[3\] VPWR
+ VGND sg13g2_nand2b_1
X_4439_ _1442_ _1443_ _1444_ _1445_ _1446_ VPWR VGND sg13g2_nor4_1
X_6109_ net767 net809 _0169_ VPWR VGND sg13g2_nor2_1
X_6520__217 VPWR VGND net217 sg13g2_tiehi
XFILLER_41_100 VPWR VGND sg13g2_fill_1
XFILLER_26_185 VPWR VGND sg13g2_decap_8
XFILLER_26_196 VPWR VGND sg13g2_fill_1
XFILLER_41_144 VPWR VGND sg13g2_decap_4
XFILLER_41_133 VPWR VGND sg13g2_fill_1
XFILLER_6_535 VPWR VGND sg13g2_decap_8
XFILLER_10_564 VPWR VGND sg13g2_decap_8
XFILLER_1_240 VPWR VGND sg13g2_decap_8
XFILLER_49_211 VPWR VGND sg13g2_fill_2
XFILLER_49_255 VPWR VGND sg13g2_fill_1
XFILLER_2_46 VPWR VGND sg13g2_decap_8
XFILLER_2_57 VPWR VGND sg13g2_fill_2
XFILLER_49_277 VPWR VGND sg13g2_decap_8
XFILLER_18_631 VPWR VGND sg13g2_decap_8
XFILLER_18_642 VPWR VGND sg13g2_fill_2
XFILLER_46_995 VPWR VGND sg13g2_decap_8
XFILLER_33_645 VPWR VGND sg13g2_fill_2
X_4790_ _1795_ _1786_ _1794_ _1797_ VPWR VGND sg13g2_a21o_1
X_3810_ net842 _0744_ net621 _0894_ _0001_ VPWR VGND sg13g2_nor4_1
XFILLER_21_829 VPWR VGND sg13g2_decap_8
XFILLER_33_667 VPWR VGND sg13g2_fill_1
XFILLER_14_881 VPWR VGND sg13g2_decap_8
X_3741_ videogen.test_lut_thingy.pixel_feeder_inst.row\[34\]\[2\] net867 _0879_ _0266_
+ VPWR VGND sg13g2_mux2_1
X_6460_ net450 VGND VPWR _0515_ videogen.test_lut_thingy.pixel_feeder_inst.row\[5\]\[2\]
+ _0111_ sg13g2_dfrbpq_1
X_3672_ videogen.test_lut_thingy.pixel_feeder_inst.row\[14\]\[1\] net876 _0865_ _0457_
+ VPWR VGND sg13g2_mux2_1
X_5411_ _2404_ _2379_ _2390_ VPWR VGND sg13g2_xnor2_1
X_6391_ net114 VGND VPWR _0450_ videogen.test_lut_thingy.pixel_feeder_inst.row\[11\]\[2\]
+ _0055_ sg13g2_dfrbpq_1
X_5342_ _2335_ _2330_ _2332_ VPWR VGND sg13g2_nand2_1
XFILLER_49_0 VPWR VGND sg13g2_decap_8
X_5273_ VGND VPWR _0412_ _0413_ _2173_ sg13g2_or2_1
X_4224_ _1230_ _1228_ _1231_ VPWR VGND sg13g2_xor2_1
X_4155_ net709 videogen.fancy_shader.shader_counter_reg\[8\] _1162_ VPWR VGND sg13g2_nor2_1
X_4086_ net672 net673 net671 _1102_ VPWR VGND _1096_ sg13g2_nand4_1
XFILLER_37_995 VPWR VGND sg13g2_decap_8
XFILLER_24_689 VPWR VGND sg13g2_fill_2
X_4988_ VPWR VGND _1986_ _1980_ _1978_ _1730_ _1995_ _1731_ sg13g2_a221oi_1
XFILLER_11_317 VPWR VGND sg13g2_fill_1
XFILLER_23_177 VPWR VGND sg13g2_decap_4
X_3939_ _0999_ videogen.another_shader.time_cnt\[4\] _0997_ VPWR VGND sg13g2_xnor2_1
XFILLER_11_11 VPWR VGND sg13g2_fill_2
XFILLER_11_22 VPWR VGND sg13g2_fill_2
X_5609_ _2586_ _2584_ _2585_ VPWR VGND sg13g2_nand2_1
XFILLER_3_505 VPWR VGND sg13g2_fill_2
XFILLER_11_66 VPWR VGND sg13g2_fill_2
X_6589_ net219 VGND VPWR _0644_ videogen.test_lut_thingy.pixel_feeder_inst.row\[63\]\[2\]
+ _0231_ sg13g2_dfrbpq_1
XFILLER_3_549 VPWR VGND sg13g2_decap_8
XFILLER_27_461 VPWR VGND sg13g2_decap_8
XFILLER_34_409 VPWR VGND sg13g2_decap_8
XFILLER_43_954 VPWR VGND sg13g2_decap_8
XFILLER_42_464 VPWR VGND sg13g2_decap_4
XFILLER_14_155 VPWR VGND sg13g2_decap_8
X_6340__179 VPWR VGND net179 sg13g2_tiehi
X_6201__231 VPWR VGND net231 sg13g2_tiehi
XFILLER_11_873 VPWR VGND sg13g2_fill_1
XFILLER_7_877 VPWR VGND sg13g2_fill_2
X_6275__310 VPWR VGND net310 sg13g2_tiehi
XFILLER_2_593 VPWR VGND sg13g2_decap_8
X_5960_ net768 net810 _0021_ VPWR VGND sg13g2_nor2_1
XFILLER_19_973 VPWR VGND sg13g2_fill_2
X_4911_ _1901_ _1903_ _1745_ _1918_ VPWR VGND _1907_ sg13g2_nand4_1
XFILLER_46_792 VPWR VGND sg13g2_decap_8
X_5891_ _0663_ _2837_ net643 _2818_ net668 VPWR VGND sg13g2_a22oi_1
XFILLER_34_965 VPWR VGND sg13g2_decap_8
X_4842_ _1849_ _1824_ _1848_ VPWR VGND sg13g2_xnor2_1
X_6503__289 VPWR VGND net289 sg13g2_tiehi
X_4773_ VGND VPWR videogen.another_shader.time_cnt\[31\] _1773_ _1780_ _1770_ sg13g2_a21oi_1
X_6512_ net253 VGND VPWR _0567_ videogen.test_lut_thingy.pixel_feeder_inst.row\[27\]\[1\]
+ _0154_ sg13g2_dfrbpq_1
X_3724_ net616 _0797_ _0876_ VPWR VGND sg13g2_nor2_2
X_6443_ net484 VGND VPWR _0498_ videogen.test_lut_thingy.pixel_feeder_inst.row\[8\]\[1\]
+ _0094_ sg13g2_dfrbpq_1
X_3655_ videogen.test_lut_thingy.pixel_feeder_inst.row\[32\]\[3\] net856 _0862_ _0480_
+ VPWR VGND sg13g2_mux2_1
X_6374_ net144 VGND VPWR _0433_ videogen.test_lut_thingy.pixel_feeder_inst.row\[12\]\[1\]
+ _0042_ sg13g2_dfrbpq_1
X_3586_ _0846_ _0809_ VPWR VGND _0801_ sg13g2_nand2b_2
X_5325_ VGND VPWR _2318_ _2317_ _2276_ sg13g2_or2_1
X_5256_ _2252_ _2254_ _2255_ VPWR VGND sg13g2_nor2_1
X_4207_ _1214_ _1212_ _1213_ VPWR VGND sg13g2_xnor2_1
X_5187_ _1130_ _2184_ _2186_ VPWR VGND sg13g2_nor2_1
X_6328__200 VPWR VGND net200 sg13g2_tiehi
X_4138_ _1123_ _1144_ _1145_ VPWR VGND sg13g2_nor2_1
XFILLER_44_718 VPWR VGND sg13g2_fill_1
XFILLER_44_707 VPWR VGND sg13g2_fill_2
X_4069_ VGND VPWR _0904_ _0928_ _1089_ net675 sg13g2_a21oi_1
XFILLER_16_409 VPWR VGND sg13g2_fill_1
XFILLER_28_269 VPWR VGND sg13g2_decap_8
XFILLER_40_902 VPWR VGND sg13g2_decap_8
XFILLER_24_442 VPWR VGND sg13g2_fill_1
XFILLER_40_979 VPWR VGND sg13g2_decap_8
XFILLER_3_302 VPWR VGND sg13g2_decap_8
X_6235__382 VPWR VGND net382 sg13g2_tiehi
XFILLER_47_567 VPWR VGND sg13g2_fill_2
XFILLER_16_943 VPWR VGND sg13g2_fill_2
XFILLER_42_272 VPWR VGND sg13g2_decap_8
XFILLER_31_968 VPWR VGND sg13g2_fill_1
XFILLER_8_56 VPWR VGND sg13g2_fill_1
XFILLER_7_630 VPWR VGND sg13g2_fill_2
X_3440_ net883 videogen.test_lut_thingy.pixel_feeder_inst.row\[49\]\[0\] _0808_ _0650_
+ VPWR VGND sg13g2_mux2_1
X_3371_ net709 net708 _0763_ VPWR VGND sg13g2_nor2b_1
X_6090_ net793 net838 _0150_ VPWR VGND sg13g2_nor2_1
X_5110_ _2113_ _2114_ _1676_ _2117_ VPWR VGND sg13g2_nand3_1
X_5041_ VGND VPWR _2041_ _2048_ _2047_ _2044_ sg13g2_a21oi_2
X_6386__124 VPWR VGND net124 sg13g2_tiehi
X_5943_ net498 net898 net755 _0710_ VPWR VGND sg13g2_a21o_1
XFILLER_33_250 VPWR VGND sg13g2_decap_8
X_5874_ _2827_ _2731_ _2756_ VPWR VGND sg13g2_nand2_1
X_4825_ _1753_ videogen.another_shader.time_cnt\[23\] _1832_ VPWR VGND sg13g2_xor2_1
X_6538__105 VPWR VGND net105 sg13g2_tiehi
XFILLER_21_467 VPWR VGND sg13g2_decap_8
X_4756_ VPWR _1763_ _1762_ VGND sg13g2_inv_1
X_4687_ VGND VPWR _1694_ _1693_ net673 sg13g2_or2_1
X_3707_ videogen.test_lut_thingy.pixel_feeder_inst.row\[37\]\[1\] net877 _0872_ _0337_
+ VPWR VGND sg13g2_mux2_1
X_6555__485 VPWR VGND net485 sg13g2_tiehi
X_3638_ videogen.test_lut_thingy.pixel_feeder_inst.row\[30\]\[3\] net856 _0857_ _0492_
+ VPWR VGND sg13g2_mux2_1
X_6426_ net61 VGND VPWR _0481_ videogen.test_lut_thingy.pixel_feeder_inst.row\[9\]\[0\]
+ _0077_ sg13g2_dfrbpq_1
X_6357_ net162 VGND VPWR _0416_ red\[2\] net734 sg13g2_dfrbpq_2
X_3569_ videogen.test_lut_thingy.pixel_feeder_inst.row\[54\]\[1\] net874 _0842_ _0546_
+ VPWR VGND sg13g2_mux2_1
X_5308_ _2300_ _2293_ _2294_ _2301_ VPWR VGND sg13g2_a21o_1
X_6288_ net284 VGND VPWR _0347_ videogen.another_shader.time_cnt\[3\] net728 sg13g2_dfrbpq_2
X_5239_ _2238_ _2216_ _2226_ VPWR VGND sg13g2_xnor2_1
XFILLER_16_228 VPWR VGND sg13g2_fill_2
XFILLER_25_740 VPWR VGND sg13g2_fill_1
XFILLER_12_401 VPWR VGND sg13g2_fill_2
XFILLER_12_412 VPWR VGND sg13g2_fill_1
XFILLER_12_423 VPWR VGND sg13g2_decap_8
XFILLER_32_1001 VPWR VGND sg13g2_fill_1
XFILLER_32_1012 VPWR VGND sg13g2_decap_8
XFILLER_32_1023 VPWR VGND sg13g2_fill_2
XFILLER_4_644 VPWR VGND sg13g2_decap_8
XFILLER_3_154 VPWR VGND sg13g2_fill_1
XFILLER_3_176 VPWR VGND sg13g2_decap_8
XFILLER_39_309 VPWR VGND sg13g2_fill_1
XFILLER_0_872 VPWR VGND sg13g2_decap_8
XFILLER_48_832 VPWR VGND sg13g2_decap_8
Xhold5 _0304_ VPWR VGND net493 sg13g2_dlygate4sd3_1
XFILLER_35_537 VPWR VGND sg13g2_decap_8
XFILLER_16_795 VPWR VGND sg13g2_decap_4
X_4610_ net688 VPWR _1617_ VGND videogen.test_lut_thingy.pixel_feeder_inst.row\[56\]\[0\]
+ net646 sg13g2_o21ai_1
X_5590_ _2567_ _2566_ VPWR VGND sg13g2_inv_2
XFILLER_7_460 VPWR VGND sg13g2_fill_1
X_4541_ net693 VPWR _1548_ VGND net699 _1547_ sg13g2_o21ai_1
X_4472_ videogen.test_lut_thingy.pixel_feeder_inst.row\[62\]\[1\] net637 _1479_ VPWR
+ VGND sg13g2_nor2_1
X_3423_ videogen.test_lut_thingy.pixel_feeder_inst.row\[23\]\[0\] net888 _0799_ _0669_
+ VPWR VGND sg13g2_mux2_1
X_6211_ net416 VGND VPWR _0270_ videogen.another_shader.video_x\[2\] net725 sg13g2_dfrbpq_1
X_6142_ net787 net830 _0202_ VPWR VGND sg13g2_nor2_1
XFILLER_31_0 VPWR VGND sg13g2_fill_1
X_3354_ VPWR _0747_ videogen.test_lut_thingy.gol_counter_reg\[2\] VGND sg13g2_inv_1
X_6073_ net764 net806 _0134_ VPWR VGND sg13g2_nor2_1
X_5024_ _2031_ _2021_ _2028_ _2030_ VPWR VGND sg13g2_and3_1
XFILLER_39_865 VPWR VGND sg13g2_fill_1
XFILLER_13_209 VPWR VGND sg13g2_fill_1
X_5926_ _2855_ net748 net511 net753 red_tmds_par\[0\] VPWR VGND sg13g2_a22oi_1
XFILLER_16_1007 VPWR VGND sg13g2_decap_8
XFILLER_22_732 VPWR VGND sg13g2_fill_1
X_5857_ _2779_ _2813_ _2814_ VPWR VGND sg13g2_nor2_1
X_4808_ _1811_ VPWR _1815_ VGND _1812_ _1813_ sg13g2_o21ai_1
X_5788_ tmds_blue.dc_balancing_reg\[3\] tmds_blue.dc_balancing_reg\[2\] tmds_blue.dc_balancing_reg\[1\]
+ _2748_ VPWR VGND sg13g2_or3_1
X_4739_ _1032_ _1742_ _1746_ VPWR VGND sg13g2_nor2_1
X_6409_ net90 VGND VPWR _0464_ red_tmds_par\[9\] net736 sg13g2_dfrbpq_1
XFILLER_1_636 VPWR VGND sg13g2_decap_8
XFILLER_0_146 VPWR VGND sg13g2_fill_1
XFILLER_28_31 VPWR VGND sg13g2_fill_2
XFILLER_45_813 VPWR VGND sg13g2_decap_8
XFILLER_28_42 VPWR VGND sg13g2_fill_2
XFILLER_44_323 VPWR VGND sg13g2_fill_2
XFILLER_40_540 VPWR VGND sg13g2_decap_8
XFILLER_9_758 VPWR VGND sg13g2_decap_8
XFILLER_9_769 VPWR VGND sg13g2_fill_1
XFILLER_13_798 VPWR VGND sg13g2_fill_2
XFILLER_5_931 VPWR VGND sg13g2_decap_8
XFILLER_5_13 VPWR VGND sg13g2_fill_1
XFILLER_5_35 VPWR VGND sg13g2_decap_4
XFILLER_4_463 VPWR VGND sg13g2_fill_1
XFILLER_39_106 VPWR VGND sg13g2_fill_2
XFILLER_48_651 VPWR VGND sg13g2_fill_2
XFILLER_35_334 VPWR VGND sg13g2_fill_1
XFILLER_35_345 VPWR VGND sg13g2_decap_8
XFILLER_23_529 VPWR VGND sg13g2_decap_4
X_3972_ videogen.another_shader.time_cnt\[14\] videogen.another_shader.time_cnt\[13\]
+ videogen.another_shader.time_cnt\[15\] _1021_ VPWR VGND videogen.another_shader.time_cnt\[12\]
+ sg13g2_nand4_1
X_6283__294 VPWR VGND net294 sg13g2_tiehi
X_5711_ _2661_ VPWR _2676_ VGND _2659_ _2662_ sg13g2_o21ai_1
X_5642_ net643 _2605_ _2616_ _0438_ VPWR VGND sg13g2_nor3_1
X_5573_ _2556_ _2555_ _2535_ _2551_ _2520_ VPWR VGND sg13g2_a22oi_1
XFILLER_8_780 VPWR VGND sg13g2_decap_4
X_4524_ net704 videogen.test_lut_thingy.pixel_feeder_inst.row\[0\]\[3\] videogen.test_lut_thingy.pixel_feeder_inst.row\[1\]\[3\]
+ videogen.test_lut_thingy.pixel_feeder_inst.row\[2\]\[3\] videogen.test_lut_thingy.pixel_feeder_inst.row\[3\]\[3\]
+ net701 _1531_ VPWR VGND sg13g2_mux4_1
X_4455_ videogen.test_lut_thingy.pixel_feeder_inst.row\[51\]\[1\] net655 _1462_ VPWR
+ VGND sg13g2_nor2_1
X_3406_ videogen.test_lut_thingy.pixel_feeder_inst.row\[22\]\[2\] net868 _0792_ _0679_
+ VPWR VGND sg13g2_mux2_1
Xfanout704 net707 net704 VPWR VGND sg13g2_buf_8
Xfanout715 videogen.another_shader.video_x\[4\] net715 VPWR VGND sg13g2_buf_8
X_4386_ videogen.test_lut_thingy.pixel_feeder_inst.row\[46\]\[2\] net637 _1393_ VPWR
+ VGND sg13g2_nor2_1
X_3337_ VPWR _0730_ videogen.another_shader.time_cnt\[13\] VGND sg13g2_inv_1
Xfanout726 net733 net726 VPWR VGND sg13g2_buf_1
Xfanout748 net749 net748 VPWR VGND sg13g2_buf_8
Xfanout737 net745 net737 VPWR VGND sg13g2_buf_8
X_6125_ net784 net827 _0185_ VPWR VGND sg13g2_nor2_1
Xfanout759 net760 net759 VPWR VGND sg13g2_buf_1
X_6056_ net774 net817 _0117_ VPWR VGND sg13g2_nor2_1
XFILLER_45_109 VPWR VGND sg13g2_decap_8
X_5007_ _2008_ _2013_ _2014_ VPWR VGND sg13g2_and2_1
XFILLER_26_334 VPWR VGND sg13g2_decap_4
XFILLER_42_838 VPWR VGND sg13g2_decap_8
X_5909_ VPWR _0692_ _2846_ VGND sg13g2_inv_1
XFILLER_6_706 VPWR VGND sg13g2_decap_4
XFILLER_10_757 VPWR VGND sg13g2_decap_4
XFILLER_14_88 VPWR VGND sg13g2_fill_2
XFILLER_2_923 VPWR VGND sg13g2_decap_8
XFILLER_1_400 VPWR VGND sg13g2_decap_8
X_6336__184 VPWR VGND net184 sg13g2_tiehi
XFILLER_7_1016 VPWR VGND sg13g2_decap_8
XFILLER_1_477 VPWR VGND sg13g2_decap_8
XFILLER_7_1027 VPWR VGND sg13g2_fill_2
XFILLER_49_459 VPWR VGND sg13g2_decap_8
XFILLER_29_172 VPWR VGND sg13g2_fill_1
XFILLER_17_345 VPWR VGND sg13g2_decap_4
XFILLER_44_164 VPWR VGND sg13g2_fill_1
XFILLER_17_378 VPWR VGND sg13g2_decap_4
XFILLER_44_186 VPWR VGND sg13g2_fill_1
XFILLER_44_175 VPWR VGND sg13g2_decap_8
XFILLER_32_337 VPWR VGND sg13g2_fill_1
XFILLER_5_783 VPWR VGND sg13g2_fill_2
X_4240_ _1247_ _1239_ _1244_ VPWR VGND sg13g2_nand2_1
X_4171_ _1178_ _1169_ _1177_ VPWR VGND sg13g2_xnor2_1
XFILLER_49_960 VPWR VGND sg13g2_decap_8
XFILLER_36_610 VPWR VGND sg13g2_fill_1
XFILLER_24_816 VPWR VGND sg13g2_decap_8
XFILLER_36_665 VPWR VGND sg13g2_fill_1
X_3955_ _1009_ videogen.another_shader.time_cnt\[10\] _1007_ VPWR VGND sg13g2_xnor2_1
X_3886_ VGND VPWR videogen.test_lut_thingy.pixel_feeder_inst.v_pix\[5\] _0962_ _0321_
+ _0964_ sg13g2_a21oi_1
X_5625_ VPWR _2602_ _2601_ VGND sg13g2_inv_1
X_5556_ _2522_ _2539_ _2495_ _2540_ VPWR VGND sg13g2_nand3_1
X_5487_ VGND VPWR _2445_ _2465_ _2473_ _2464_ sg13g2_a21oi_1
X_4507_ _1514_ net661 videogen.test_lut_thingy.pixel_feeder_inst.row\[55\]\[3\] VPWR
+ VGND sg13g2_nand2b_1
X_6218__409 VPWR VGND net409 sg13g2_tiehi
X_4438_ videogen.test_lut_thingy.pixel_feeder_inst.row\[15\]\[1\] net659 _1445_ VPWR
+ VGND sg13g2_nor2_1
X_4369_ videogen.test_lut_thingy.pixel_feeder_inst.row\[62\]\[2\] net633 _1376_ VPWR
+ VGND sg13g2_nor2_1
X_6108_ net759 net800 _0168_ VPWR VGND sg13g2_nor2_1
X_6039_ net765 net807 _0100_ VPWR VGND sg13g2_nor2_1
XFILLER_27_632 VPWR VGND sg13g2_fill_1
XFILLER_27_687 VPWR VGND sg13g2_decap_8
XFILLER_14_337 VPWR VGND sg13g2_fill_2
XFILLER_23_871 VPWR VGND sg13g2_fill_2
XFILLER_25_98 VPWR VGND sg13g2_decap_8
XFILLER_41_86 VPWR VGND sg13g2_decap_4
XFILLER_2_775 VPWR VGND sg13g2_decap_8
XFILLER_2_25 VPWR VGND sg13g2_decap_8
XFILLER_49_234 VPWR VGND sg13g2_decap_8
XFILLER_46_974 VPWR VGND sg13g2_decap_8
XFILLER_17_186 VPWR VGND sg13g2_fill_1
XFILLER_33_624 VPWR VGND sg13g2_fill_1
XFILLER_21_808 VPWR VGND sg13g2_fill_2
XFILLER_32_145 VPWR VGND sg13g2_fill_2
X_3740_ videogen.test_lut_thingy.pixel_feeder_inst.row\[34\]\[3\] net856 _0879_ _0267_
+ VPWR VGND sg13g2_mux2_1
X_3671_ videogen.test_lut_thingy.pixel_feeder_inst.row\[14\]\[2\] net865 _0865_ _0458_
+ VPWR VGND sg13g2_mux2_1
X_5410_ _2403_ _2391_ _2398_ VPWR VGND sg13g2_nand2_1
X_6390_ net116 VGND VPWR _0449_ videogen.test_lut_thingy.pixel_feeder_inst.row\[11\]\[1\]
+ _0054_ sg13g2_dfrbpq_1
X_5341_ _2319_ _2327_ _2334_ VPWR VGND sg13g2_nor2_1
X_5272_ _0411_ _2166_ _0413_ VPWR VGND sg13g2_nand2b_1
X_6252__355 VPWR VGND net355 sg13g2_tiehi
X_4223_ _1230_ _1229_ _1131_ VPWR VGND sg13g2_nand2b_1
X_4154_ _1161_ net709 videogen.fancy_shader.shader_counter_reg\[8\] VPWR VGND sg13g2_nand2_1
X_4085_ _1101_ _1100_ net671 VPWR VGND sg13g2_nand2b_1
XFILLER_37_974 VPWR VGND sg13g2_decap_8
XFILLER_36_462 VPWR VGND sg13g2_fill_1
XFILLER_24_646 VPWR VGND sg13g2_fill_2
XFILLER_12_808 VPWR VGND sg13g2_fill_2
XFILLER_23_134 VPWR VGND sg13g2_decap_8
X_4987_ _1988_ _1992_ _1987_ _1994_ VPWR VGND sg13g2_nand3_1
X_6396__104 VPWR VGND net104 sg13g2_tiehi
XFILLER_23_167 VPWR VGND sg13g2_fill_2
X_3938_ _0997_ _0998_ _0347_ VPWR VGND sg13g2_nor2_1
XFILLER_32_690 VPWR VGND sg13g2_fill_1
X_3869_ net892 VPWR _0953_ VGND _0762_ net620 sg13g2_o21ai_1
X_6657_ net235 VGND VPWR net752 serialize.shift_reg_c\[8\] clknet_3_3__leaf_clk_regs
+ sg13g2_dfrbpq_1
X_5608_ _2579_ _2575_ _2585_ VPWR VGND sg13g2_xor2_1
X_6588_ net227 VGND VPWR _0643_ videogen.test_lut_thingy.pixel_feeder_inst.row\[63\]\[1\]
+ _0230_ sg13g2_dfrbpq_1
X_5539_ VGND VPWR _2510_ _2523_ _0424_ net642 sg13g2_a21oi_1
XFILLER_46_215 VPWR VGND sg13g2_decap_4
XFILLER_27_451 VPWR VGND sg13g2_decap_4
XFILLER_43_933 VPWR VGND sg13g2_decap_8
XFILLER_14_178 VPWR VGND sg13g2_fill_2
XFILLER_35_1021 VPWR VGND sg13g2_decap_8
XFILLER_23_690 VPWR VGND sg13g2_fill_1
X_6531__133 VPWR VGND net133 sg13g2_tiehi
XFILLER_2_572 VPWR VGND sg13g2_decap_8
XFILLER_35_7 VPWR VGND sg13g2_fill_2
XFILLER_38_727 VPWR VGND sg13g2_decap_8
XFILLER_38_749 VPWR VGND sg13g2_decap_8
XFILLER_18_451 VPWR VGND sg13g2_fill_1
X_4910_ _1911_ _1915_ _1910_ _1917_ VPWR VGND sg13g2_nand3_1
XFILLER_18_484 VPWR VGND sg13g2_decap_8
X_5890_ _2837_ net898 _2836_ VPWR VGND sg13g2_nand2_1
XFILLER_34_922 VPWR VGND sg13g2_fill_2
X_4841_ _1829_ VPWR _1848_ VGND _1831_ _1844_ sg13g2_o21ai_1
X_4772_ _1779_ _1761_ _0725_ _1757_ _1052_ VPWR VGND sg13g2_a22oi_1
X_6511_ net257 VGND VPWR _0566_ videogen.test_lut_thingy.pixel_feeder_inst.row\[27\]\[0\]
+ _0153_ sg13g2_dfrbpq_1
X_3723_ videogen.test_lut_thingy.pixel_feeder_inst.row\[17\]\[0\] net885 _0875_ _0296_
+ VPWR VGND sg13g2_mux2_1
X_6442_ net486 VGND VPWR _0497_ videogen.test_lut_thingy.pixel_feeder_inst.row\[8\]\[0\]
+ _0093_ sg13g2_dfrbpq_1
X_3654_ _0797_ _0801_ _0862_ VPWR VGND sg13g2_nor2_2
X_6373_ net146 VGND VPWR _0432_ videogen.test_lut_thingy.pixel_feeder_inst.row\[12\]\[0\]
+ _0041_ sg13g2_dfrbpq_1
X_3585_ videogen.test_lut_thingy.pixel_feeder_inst.row\[55\]\[0\] net884 _0845_ _0533_
+ VPWR VGND sg13g2_mux2_1
X_5324_ _2313_ _2316_ _2317_ VPWR VGND sg13g2_nor2_1
X_5255_ VGND VPWR _2240_ _2253_ _2254_ _2241_ sg13g2_a21oi_1
X_4206_ _1213_ _1194_ _1204_ VPWR VGND sg13g2_xnor2_1
X_5186_ _2184_ _1231_ _2185_ VPWR VGND sg13g2_xor2_1
X_4137_ VPWR VGND videogen.another_shader.video_x\[2\] _1121_ videogen.fancy_shader.shader_counter_reg\[2\]
+ videogen.another_shader.video_x\[3\] _1144_ videogen.fancy_shader.shader_counter_reg\[3\]
+ sg13g2_a221oi_1
X_4068_ _1087_ _1088_ _0387_ VPWR VGND sg13g2_nor2_1
XFILLER_40_958 VPWR VGND sg13g2_decap_8
XFILLER_7_119 VPWR VGND sg13g2_decap_4
XFILLER_20_671 VPWR VGND sg13g2_decap_4
XFILLER_22_44 VPWR VGND sg13g2_fill_1
XFILLER_3_347 VPWR VGND sg13g2_fill_2
XFILLER_15_454 VPWR VGND sg13g2_decap_4
XFILLER_31_914 VPWR VGND sg13g2_decap_8
XFILLER_8_46 VPWR VGND sg13g2_decap_4
XFILLER_30_468 VPWR VGND sg13g2_fill_2
XFILLER_6_174 VPWR VGND sg13g2_fill_2
X_3370_ _0762_ _0761_ VPWR VGND sg13g2_inv_2
X_5040_ _2047_ _2045_ _2046_ VPWR VGND sg13g2_xnor2_1
XFILLER_19_2 VPWR VGND sg13g2_fill_1
X_5942_ net843 clockdiv.q0 net489 _0709_ VPWR VGND sg13g2_nor3_1
XFILLER_25_229 VPWR VGND sg13g2_decap_4
XFILLER_21_413 VPWR VGND sg13g2_fill_2
X_5873_ VGND VPWR _2692_ _2754_ _2826_ _0745_ sg13g2_a21oi_1
X_4824_ _1831_ _1758_ _1828_ VPWR VGND sg13g2_xnor2_1
XFILLER_21_424 VPWR VGND sg13g2_fill_1
XFILLER_33_273 VPWR VGND sg13g2_fill_1
X_4755_ _1760_ videogen.another_shader.time_cnt\[26\] _1762_ VPWR VGND sg13g2_xor2_1
X_3706_ videogen.test_lut_thingy.pixel_feeder_inst.row\[37\]\[2\] net866 _0872_ _0338_
+ VPWR VGND sg13g2_mux2_1
XFILLER_30_991 VPWR VGND sg13g2_fill_1
X_4686_ _1693_ _1688_ _1690_ VPWR VGND sg13g2_xnor2_1
XFILLER_49_1009 VPWR VGND sg13g2_decap_8
X_6425_ net63 VGND VPWR _0480_ videogen.test_lut_thingy.pixel_feeder_inst.row\[32\]\[3\]
+ _0076_ sg13g2_dfrbpq_1
X_3637_ _0803_ _0817_ _0857_ VPWR VGND sg13g2_nor2_2
X_6356_ net163 VGND VPWR _0415_ green\[7\] net737 sg13g2_dfrbpq_2
X_3568_ videogen.test_lut_thingy.pixel_feeder_inst.row\[54\]\[2\] net861 _0842_ _0547_
+ VPWR VGND sg13g2_mux2_1
X_6293__274 VPWR VGND net274 sg13g2_tiehi
X_5307_ _2300_ _2295_ _2292_ VPWR VGND sg13g2_nand2b_1
X_6287_ net286 VGND VPWR _0346_ videogen.another_shader.time_cnt\[2\] net728 sg13g2_dfrbpq_2
X_3499_ videogen.test_lut_thingy.pixel_feeder_inst.row\[43\]\[0\] net888 _0827_ _0610_
+ VPWR VGND sg13g2_mux2_1
X_5238_ _2185_ _2236_ _2237_ VPWR VGND sg13g2_and2_1
X_5169_ _2169_ VPWR _2174_ VGND _2145_ _2173_ sg13g2_o21ai_1
XFILLER_17_55 VPWR VGND sg13g2_decap_8
X_6562__457 VPWR VGND net457 sg13g2_tiehi
XFILLER_24_284 VPWR VGND sg13g2_fill_1
XFILLER_12_457 VPWR VGND sg13g2_fill_1
XFILLER_12_479 VPWR VGND sg13g2_decap_4
XFILLER_20_490 VPWR VGND sg13g2_decap_8
XFILLER_48_811 VPWR VGND sg13g2_decap_8
XFILLER_0_851 VPWR VGND sg13g2_decap_8
Xhold6 serialize.shift_reg_c\[3\] VPWR VGND net494 sg13g2_dlygate4sd3_1
XFILLER_48_888 VPWR VGND sg13g2_decap_8
XFILLER_47_398 VPWR VGND sg13g2_decap_4
XFILLER_16_763 VPWR VGND sg13g2_decap_4
XFILLER_31_711 VPWR VGND sg13g2_fill_2
XFILLER_43_593 VPWR VGND sg13g2_fill_1
XFILLER_43_582 VPWR VGND sg13g2_fill_2
XFILLER_30_254 VPWR VGND sg13g2_fill_1
XFILLER_12_991 VPWR VGND sg13g2_decap_8
XFILLER_30_265 VPWR VGND sg13g2_fill_1
XFILLER_30_276 VPWR VGND sg13g2_fill_1
XFILLER_30_287 VPWR VGND sg13g2_fill_2
X_4540_ net706 videogen.test_lut_thingy.pixel_feeder_inst.row\[40\]\[3\] videogen.test_lut_thingy.pixel_feeder_inst.row\[41\]\[3\]
+ videogen.test_lut_thingy.pixel_feeder_inst.row\[42\]\[3\] videogen.test_lut_thingy.pixel_feeder_inst.row\[43\]\[3\]
+ net702 _1547_ VPWR VGND sg13g2_mux4_1
X_4471_ net686 VPWR _1478_ VGND videogen.test_lut_thingy.pixel_feeder_inst.row\[60\]\[1\]
+ net644 sg13g2_o21ai_1
X_3422_ videogen.test_lut_thingy.pixel_feeder_inst.row\[23\]\[1\] net879 _0799_ _0670_
+ VPWR VGND sg13g2_mux2_1
X_6210_ net417 VGND VPWR _0269_ videogen.another_shader.video_x\[1\] net727 sg13g2_dfrbpq_2
X_6141_ net786 net829 _0201_ VPWR VGND sg13g2_nor2_1
X_3353_ VPWR _0746_ videogen.test_lut_thingy.gol_counter_reg\[1\] VGND sg13g2_inv_1
X_6072_ net764 net806 _0133_ VPWR VGND sg13g2_nor2_1
X_5023_ _2030_ videogen.another_shader.video_y\[8\] _2029_ VPWR VGND sg13g2_xnor2_1
X_6418__77 VPWR VGND net77 sg13g2_tiehi
X_6433__47 VPWR VGND net47 sg13g2_tiehi
XFILLER_0_91 VPWR VGND sg13g2_decap_8
X_5925_ VPWR _0700_ _2854_ VGND sg13g2_inv_1
X_5856_ _2813_ _2810_ _2812_ VPWR VGND sg13g2_xnor2_1
X_4807_ _1812_ _1813_ _1814_ VPWR VGND sg13g2_nor2_1
XFILLER_22_777 VPWR VGND sg13g2_fill_2
X_5787_ _2745_ _2743_ _2747_ VPWR VGND _2744_ sg13g2_nand3b_1
X_4738_ _1742_ videogen.another_shader.time_cnt\[18\] _1745_ VPWR VGND sg13g2_xor2_1
XFILLER_21_298 VPWR VGND sg13g2_decap_4
X_4669_ _1676_ net676 _1675_ VPWR VGND sg13g2_xnor2_1
X_6408_ net91 VGND VPWR _0463_ red_tmds_par\[8\] net736 sg13g2_dfrbpq_1
XFILLER_1_615 VPWR VGND sg13g2_decap_8
Xclkbuf_1_1__f_clk clknet_0_clk clknet_1_1__leaf_clk VPWR VGND sg13g2_buf_8
X_6339_ net180 VGND VPWR _0398_ videogen.test_lut_thingy.gol_counter_reg\[2\] net729
+ sg13g2_dfrbpq_1
XFILLER_17_527 VPWR VGND sg13g2_fill_1
XFILLER_29_376 VPWR VGND sg13g2_fill_2
X_6523__205 VPWR VGND net205 sg13g2_tiehi
XFILLER_45_869 VPWR VGND sg13g2_decap_8
XFILLER_44_335 VPWR VGND sg13g2_fill_2
XFILLER_13_733 VPWR VGND sg13g2_fill_2
XFILLER_13_755 VPWR VGND sg13g2_fill_1
XFILLER_12_265 VPWR VGND sg13g2_fill_2
XFILLER_4_431 VPWR VGND sg13g2_fill_1
XFILLER_5_987 VPWR VGND sg13g2_decap_8
XFILLER_4_497 VPWR VGND sg13g2_fill_1
XFILLER_48_696 VPWR VGND sg13g2_fill_1
XFILLER_39_1019 VPWR VGND sg13g2_decap_8
XFILLER_35_324 VPWR VGND sg13g2_fill_2
X_3971_ _1019_ _1020_ _0358_ VPWR VGND sg13g2_nor2_1
XFILLER_44_891 VPWR VGND sg13g2_decap_8
X_5710_ VGND VPWR _2658_ _2673_ _2675_ _2674_ sg13g2_a21oi_1
X_5641_ VGND VPWR _2568_ net613 _2616_ _2615_ sg13g2_a21oi_1
XFILLER_31_574 VPWR VGND sg13g2_decap_8
XFILLER_31_585 VPWR VGND sg13g2_fill_1
X_5572_ _2555_ _2552_ _2554_ VPWR VGND sg13g2_xnor2_1
X_4523_ net704 videogen.test_lut_thingy.pixel_feeder_inst.row\[4\]\[3\] videogen.test_lut_thingy.pixel_feeder_inst.row\[5\]\[3\]
+ videogen.test_lut_thingy.pixel_feeder_inst.row\[6\]\[3\] videogen.test_lut_thingy.pixel_feeder_inst.row\[7\]\[3\]
+ net701 _1530_ VPWR VGND sg13g2_mux4_1
X_4454_ _1460_ VPWR _1461_ VGND _1424_ _1436_ sg13g2_o21ai_1
X_3405_ videogen.test_lut_thingy.pixel_feeder_inst.row\[22\]\[3\] net857 _0792_ _0680_
+ VPWR VGND sg13g2_mux2_1
Xfanout705 net707 net705 VPWR VGND sg13g2_buf_8
X_4385_ net691 VPWR _1392_ VGND videogen.test_lut_thingy.pixel_feeder_inst.row\[44\]\[2\]
+ net648 sg13g2_o21ai_1
X_3336_ VPWR _0729_ videogen.another_shader.time_cnt\[14\] VGND sg13g2_inv_1
Xfanout727 net728 net727 VPWR VGND sg13g2_buf_8
Xfanout738 net740 net738 VPWR VGND sg13g2_buf_8
Xfanout716 videogen.another_shader.video_x\[3\] net716 VPWR VGND sg13g2_buf_8
X_6124_ net781 net824 _0184_ VPWR VGND sg13g2_nor2_1
Xfanout749 net750 net749 VPWR VGND sg13g2_buf_8
X_6055_ net756 net798 _0116_ VPWR VGND sg13g2_nor2_1
X_5006_ _1989_ _2009_ _2013_ VPWR VGND sg13g2_nor2b_1
XFILLER_27_803 VPWR VGND sg13g2_decap_8
XFILLER_27_814 VPWR VGND sg13g2_decap_4
XFILLER_42_817 VPWR VGND sg13g2_decap_8
XFILLER_41_305 VPWR VGND sg13g2_decap_8
XFILLER_14_519 VPWR VGND sg13g2_decap_8
XFILLER_26_368 VPWR VGND sg13g2_fill_1
XFILLER_41_316 VPWR VGND sg13g2_fill_1
XFILLER_35_880 VPWR VGND sg13g2_decap_4
X_5908_ _2846_ net747 net520 net752 blue_tmds_par\[7\] VPWR VGND sg13g2_a22oi_1
X_5839_ _2797_ _2786_ _2796_ VPWR VGND sg13g2_nand2_1
XFILLER_30_44 VPWR VGND sg13g2_fill_2
XFILLER_2_902 VPWR VGND sg13g2_decap_8
XFILLER_39_31 VPWR VGND sg13g2_decap_8
XFILLER_2_979 VPWR VGND sg13g2_decap_8
XFILLER_1_456 VPWR VGND sg13g2_decap_8
XFILLER_49_438 VPWR VGND sg13g2_decap_8
XFILLER_45_611 VPWR VGND sg13g2_decap_4
XFILLER_29_140 VPWR VGND sg13g2_fill_2
XFILLER_45_655 VPWR VGND sg13g2_fill_1
XFILLER_29_184 VPWR VGND sg13g2_decap_8
XFILLER_32_316 VPWR VGND sg13g2_decap_4
XFILLER_32_349 VPWR VGND sg13g2_fill_1
XFILLER_9_545 VPWR VGND sg13g2_decap_8
XFILLER_9_556 VPWR VGND sg13g2_fill_1
XFILLER_4_272 VPWR VGND sg13g2_fill_1
XFILLER_45_1023 VPWR VGND sg13g2_fill_2
X_4170_ _1177_ _1175_ _1176_ VPWR VGND sg13g2_xnor2_1
XFILLER_36_644 VPWR VGND sg13g2_fill_2
X_6506__277 VPWR VGND net277 sg13g2_tiehi
XFILLER_24_839 VPWR VGND sg13g2_fill_1
X_3954_ _1007_ _1008_ _0353_ VPWR VGND sg13g2_nor2_1
X_3885_ _0954_ VPWR _0964_ VGND videogen.test_lut_thingy.pixel_feeder_inst.v_pix\[5\]
+ _0962_ sg13g2_o21ai_1
XFILLER_31_371 VPWR VGND sg13g2_decap_4
X_5624_ _2601_ _2596_ _2600_ VPWR VGND sg13g2_nand2_1
X_6476__387 VPWR VGND net387 sg13g2_tiehi
X_5555_ _2538_ _2527_ _2539_ VPWR VGND sg13g2_xor2_1
X_4506_ _1513_ net662 videogen.test_lut_thingy.pixel_feeder_inst.row\[31\]\[3\] VPWR
+ VGND sg13g2_nand2b_1
X_5486_ _2472_ tmds_red.dc_balancing_reg\[1\] _2471_ VPWR VGND sg13g2_xnor2_1
X_4437_ videogen.test_lut_thingy.pixel_feeder_inst.row\[13\]\[1\] net626 _1444_ VPWR
+ VGND sg13g2_nor2_1
X_4368_ net692 VPWR _1375_ VGND videogen.test_lut_thingy.pixel_feeder_inst.row\[63\]\[2\]
+ net654 sg13g2_o21ai_1
X_6107_ net771 net814 _0167_ VPWR VGND sg13g2_nor2_1
XFILLER_47_909 VPWR VGND sg13g2_decap_8
X_4299_ _1290_ _1289_ _1306_ VPWR VGND sg13g2_nor2b_1
X_6038_ net764 net806 _0099_ VPWR VGND sg13g2_nor2_1
XFILLER_27_600 VPWR VGND sg13g2_decap_8
XFILLER_27_677 VPWR VGND sg13g2_fill_2
XFILLER_25_33 VPWR VGND sg13g2_decap_8
XFILLER_41_124 VPWR VGND sg13g2_fill_2
XFILLER_6_548 VPWR VGND sg13g2_decap_8
XFILLER_49_224 VPWR VGND sg13g2_fill_2
XFILLER_49_213 VPWR VGND sg13g2_fill_1
XFILLER_2_787 VPWR VGND sg13g2_fill_2
XFILLER_38_909 VPWR VGND sg13g2_decap_8
XFILLER_18_600 VPWR VGND sg13g2_fill_2
XFILLER_46_953 VPWR VGND sg13g2_decap_8
XFILLER_17_154 VPWR VGND sg13g2_fill_1
XFILLER_33_647 VPWR VGND sg13g2_fill_1
XFILLER_40_190 VPWR VGND sg13g2_fill_1
X_3670_ videogen.test_lut_thingy.pixel_feeder_inst.row\[14\]\[3\] net854 _0865_ _0459_
+ VPWR VGND sg13g2_mux2_1
X_5340_ _2326_ _2319_ _2333_ VPWR VGND sg13g2_xor2_1
X_5271_ _0410_ _2149_ _0413_ VPWR VGND sg13g2_nand2b_1
X_6217__410 VPWR VGND net410 sg13g2_tiehi
X_4222_ _1129_ _1130_ _1126_ _1229_ VPWR VGND sg13g2_nand3_1
X_4153_ _1160_ _1149_ _1159_ VPWR VGND sg13g2_xnor2_1
X_4084_ _0391_ net893 _1099_ _1100_ VPWR VGND sg13g2_and3_1
XFILLER_37_953 VPWR VGND sg13g2_decap_8
X_6582__279 VPWR VGND net279 sg13g2_tiehi
XFILLER_24_625 VPWR VGND sg13g2_fill_2
X_4986_ _1989_ _1992_ _1993_ VPWR VGND sg13g2_nor2b_1
X_3937_ net897 VPWR _0998_ VGND videogen.another_shader.time_cnt\[3\] _0996_ sg13g2_o21ai_1
X_3868_ _0762_ net620 _0952_ VPWR VGND sg13g2_nor2_1
X_6656_ net251 VGND VPWR _0711_ serialize.shift_reg_c\[6\] clknet_3_6__leaf_clk_regs
+ sg13g2_dfrbpq_1
X_6558__473 VPWR VGND net473 sg13g2_tiehi
X_3799_ _0921_ _0919_ _0920_ VPWR VGND sg13g2_nand2_1
XFILLER_11_13 VPWR VGND sg13g2_fill_1
XFILLER_11_24 VPWR VGND sg13g2_fill_1
X_5607_ _2584_ green\[1\] _2579_ VPWR VGND sg13g2_xnor2_1
X_6587_ net239 VGND VPWR _0642_ videogen.test_lut_thingy.pixel_feeder_inst.row\[63\]\[0\]
+ _0229_ sg13g2_dfrbpq_1
X_6545__68 VPWR VGND net68 sg13g2_tiehi
X_5538_ VPWR VGND _2495_ _2521_ _2522_ _2507_ _2523_ _2512_ sg13g2_a221oi_1
XFILLER_3_507 VPWR VGND sg13g2_fill_1
XFILLER_11_35 VPWR VGND sg13g2_fill_2
X_5469_ _2452_ VPWR _2455_ VGND _2441_ _2447_ sg13g2_o21ai_1
XFILLER_43_912 VPWR VGND sg13g2_decap_8
XFILLER_36_54 VPWR VGND sg13g2_decap_4
XFILLER_36_87 VPWR VGND sg13g2_fill_1
XFILLER_43_989 VPWR VGND sg13g2_decap_8
XFILLER_30_617 VPWR VGND sg13g2_decap_4
XFILLER_35_1000 VPWR VGND sg13g2_decap_8
XFILLER_42_499 VPWR VGND sg13g2_decap_8
XFILLER_23_680 VPWR VGND sg13g2_fill_2
XFILLER_30_639 VPWR VGND sg13g2_decap_8
XFILLER_10_341 VPWR VGND sg13g2_fill_1
XFILLER_6_367 VPWR VGND sg13g2_fill_2
XFILLER_10_396 VPWR VGND sg13g2_decap_8
XFILLER_2_551 VPWR VGND sg13g2_decap_8
XFILLER_42_1015 VPWR VGND sg13g2_decap_8
XFILLER_34_901 VPWR VGND sg13g2_fill_1
XFILLER_18_463 VPWR VGND sg13g2_decap_8
X_4840_ _1754_ _1831_ _1846_ _1847_ VPWR VGND sg13g2_or3_1
X_6577__337 VPWR VGND net337 sg13g2_tiehi
X_6510_ net261 VGND VPWR _0565_ videogen.test_lut_thingy.pixel_feeder_inst.row\[28\]\[3\]
+ _0152_ sg13g2_dfrbpq_1
X_4771_ _1778_ _1777_ _1776_ VPWR VGND sg13g2_nand2b_1
X_3722_ videogen.test_lut_thingy.pixel_feeder_inst.row\[17\]\[1\] net873 _0875_ _0297_
+ VPWR VGND sg13g2_mux2_1
X_6441_ net31 VGND VPWR _0496_ videogen.test_lut_thingy.pixel_feeder_inst.row\[10\]\[3\]
+ _0092_ sg13g2_dfrbpq_1
X_3653_ videogen.test_lut_thingy.pixel_feeder_inst.row\[9\]\[0\] net881 _0861_ _0481_
+ VPWR VGND sg13g2_mux2_1
X_6372_ net147 VGND VPWR _0431_ red_tmds_par\[7\] net738 sg13g2_dfrbpq_1
X_5323_ _2276_ _2304_ _2315_ _2316_ VPWR VGND sg13g2_nor3_1
X_3584_ videogen.test_lut_thingy.pixel_feeder_inst.row\[55\]\[1\] net875 _0845_ _0534_
+ VPWR VGND sg13g2_mux2_1
X_5254_ _2253_ _2242_ _2237_ VPWR VGND sg13g2_nand2b_1
X_5185_ _2184_ _1128_ _1249_ VPWR VGND sg13g2_nand2_2
X_4205_ _1195_ _1207_ _1212_ VPWR VGND sg13g2_nor2_1
X_4136_ _1143_ videogen.another_shader.video_x\[4\] videogen.fancy_shader.shader_counter_reg\[4\]
+ VPWR VGND sg13g2_xnor2_1
XFILLER_44_709 VPWR VGND sg13g2_fill_1
X_4067_ net894 VPWR _1088_ VGND _0905_ _0929_ sg13g2_o21ai_1
XFILLER_28_249 VPWR VGND sg13g2_decap_8
XFILLER_43_219 VPWR VGND sg13g2_decap_8
XFILLER_24_400 VPWR VGND sg13g2_fill_2
XFILLER_40_937 VPWR VGND sg13g2_decap_8
X_4969_ _1971_ VPWR _1976_ VGND _1968_ _1974_ sg13g2_o21ai_1
X_6519__221 VPWR VGND net221 sg13g2_tiehi
X_6639_ net42 VGND VPWR _0694_ serialize.shift_reg_g\[1\] clknet_3_7__leaf_clk_regs
+ sg13g2_dfrbpq_1
XFILLER_22_56 VPWR VGND sg13g2_decap_8
X_6589__219 VPWR VGND net219 sg13g2_tiehi
XFILLER_27_282 VPWR VGND sg13g2_decap_8
XFILLER_15_466 VPWR VGND sg13g2_decap_4
XFILLER_30_403 VPWR VGND sg13g2_fill_1
XFILLER_31_959 VPWR VGND sg13g2_fill_1
XFILLER_11_650 VPWR VGND sg13g2_fill_1
X_6502__291 VPWR VGND net291 sg13g2_tiehi
XFILLER_7_632 VPWR VGND sg13g2_fill_1
XFILLER_6_186 VPWR VGND sg13g2_fill_2
X_6214__413 VPWR VGND net413 sg13g2_tiehi
X_5941_ VPWR _0708_ _2862_ VGND sg13g2_inv_1
XFILLER_46_580 VPWR VGND sg13g2_fill_2
XFILLER_18_282 VPWR VGND sg13g2_fill_2
XFILLER_34_731 VPWR VGND sg13g2_decap_8
XFILLER_34_742 VPWR VGND sg13g2_fill_2
X_5872_ VGND VPWR net668 _2825_ _0656_ _2824_ sg13g2_a21oi_1
XFILLER_34_786 VPWR VGND sg13g2_fill_2
X_4823_ _1830_ _1759_ _1828_ VPWR VGND sg13g2_xnor2_1
X_6221__406 VPWR VGND net406 sg13g2_tiehi
X_4754_ videogen.another_shader.time_cnt\[25\] videogen.another_shader.time_cnt\[24\]
+ videogen.another_shader.time_cnt\[26\] _1761_ VPWR VGND _1757_ sg13g2_nand4_1
X_3705_ videogen.test_lut_thingy.pixel_feeder_inst.row\[37\]\[3\] net855 _0872_ _0339_
+ VPWR VGND sg13g2_mux2_1
X_4685_ _1692_ _1690_ _1688_ VPWR VGND sg13g2_nand2b_1
X_3636_ videogen.test_lut_thingy.pixel_feeder_inst.row\[10\]\[0\] net881 _0856_ _0493_
+ VPWR VGND sg13g2_mux2_1
X_6424_ net65 VGND VPWR _0479_ videogen.test_lut_thingy.pixel_feeder_inst.row\[32\]\[2\]
+ _0075_ sg13g2_dfrbpq_1
X_6355_ net164 VGND VPWR _0414_ green\[6\] net736 sg13g2_dfrbpq_1
X_3567_ videogen.test_lut_thingy.pixel_feeder_inst.row\[54\]\[3\] net852 _0842_ _0548_
+ VPWR VGND sg13g2_mux2_1
X_6286_ net288 VGND VPWR _0345_ videogen.another_shader.time_cnt\[1\] net727 sg13g2_dfrbpq_1
X_5306_ _2299_ _2207_ _2278_ VPWR VGND sg13g2_xnor2_1
XFILLER_0_329 VPWR VGND sg13g2_decap_8
X_3498_ videogen.test_lut_thingy.pixel_feeder_inst.row\[43\]\[1\] net878 _0827_ _0611_
+ VPWR VGND sg13g2_mux2_1
X_5237_ _2227_ _2235_ _2236_ VPWR VGND sg13g2_nor2b_1
XFILLER_25_1021 VPWR VGND sg13g2_decap_8
X_5168_ _1671_ _2172_ _2173_ VPWR VGND sg13g2_nor2_1
X_5099_ _2088_ _2096_ _2103_ _2106_ VPWR VGND sg13g2_nor3_1
X_4119_ _1126_ net676 videogen.fancy_shader.shader_counter_reg\[1\] VPWR VGND sg13g2_nand2_1
XFILLER_17_12 VPWR VGND sg13g2_fill_2
XFILLER_17_709 VPWR VGND sg13g2_fill_1
XFILLER_16_208 VPWR VGND sg13g2_fill_2
XFILLER_17_45 VPWR VGND sg13g2_decap_4
XFILLER_37_580 VPWR VGND sg13g2_decap_4
XFILLER_17_89 VPWR VGND sg13g2_decap_8
XFILLER_12_403 VPWR VGND sg13g2_fill_1
XFILLER_13_915 VPWR VGND sg13g2_fill_2
XFILLER_24_230 VPWR VGND sg13g2_decap_8
XFILLER_25_775 VPWR VGND sg13g2_decap_8
XFILLER_40_723 VPWR VGND sg13g2_decap_4
XFILLER_12_469 VPWR VGND sg13g2_decap_4
XFILLER_8_429 VPWR VGND sg13g2_decap_4
XFILLER_4_679 VPWR VGND sg13g2_decap_8
XFILLER_0_830 VPWR VGND sg13g2_decap_8
Xhold7 serialize.shift_reg_c\[5\] VPWR VGND net495 sg13g2_dlygate4sd3_1
XFILLER_48_867 VPWR VGND sg13g2_decap_8
XFILLER_47_366 VPWR VGND sg13g2_decap_8
XFILLER_15_274 VPWR VGND sg13g2_fill_2
XFILLER_31_723 VPWR VGND sg13g2_decap_8
XFILLER_7_440 VPWR VGND sg13g2_fill_1
XFILLER_8_985 VPWR VGND sg13g2_decap_8
X_4470_ net689 _1473_ _1474_ _1476_ _1477_ VPWR VGND sg13g2_nor4_1
X_3421_ videogen.test_lut_thingy.pixel_feeder_inst.row\[23\]\[2\] net868 _0799_ _0671_
+ VPWR VGND sg13g2_mux2_1
XFILLER_48_1021 VPWR VGND sg13g2_decap_8
X_3352_ net667 _0745_ VPWR VGND sg13g2_inv_4
X_6140_ net787 net830 _0200_ VPWR VGND sg13g2_nor2_1
X_6071_ net772 net815 _0132_ VPWR VGND sg13g2_nor2_1
X_5022_ _1720_ _1719_ _2029_ VPWR VGND sg13g2_xor2_1
XFILLER_38_388 VPWR VGND sg13g2_fill_1
XFILLER_0_70 VPWR VGND sg13g2_decap_8
XFILLER_0_1012 VPWR VGND sg13g2_decap_8
X_5924_ _2854_ net746 net505 net751 green_tmds_par\[7\] VPWR VGND sg13g2_a22oi_1
X_5855_ _2812_ tmds_blue.dc_balancing_reg\[4\] _2811_ VPWR VGND sg13g2_xnor2_1
X_4806_ _1813_ _1788_ _1791_ _1800_ VPWR VGND sg13g2_and3_1
X_5786_ _2746_ _2745_ _2744_ VPWR VGND sg13g2_nand2b_1
X_4737_ VPWR _1744_ _1743_ VGND sg13g2_inv_1
X_4668_ _1674_ _1672_ _1675_ VPWR VGND sg13g2_xor2_1
X_6407_ net92 VGND VPWR _0462_ red_tmds_par\[6\] net736 sg13g2_dfrbpq_1
X_3619_ net876 videogen.test_lut_thingy.pixel_feeder_inst.row\[61\]\[1\] _0852_ _0506_
+ VPWR VGND sg13g2_mux2_1
X_4599_ videogen.test_lut_thingy.pixel_feeder_inst.row\[8\]\[0\] net645 _1606_ VPWR
+ VGND sg13g2_nor2_1
XFILLER_0_126 VPWR VGND sg13g2_decap_8
X_6338_ net181 VGND VPWR _0397_ videogen.test_lut_thingy.gol_counter_reg\[1\] net729
+ sg13g2_dfrbpq_2
X_6269_ net322 VGND VPWR _0328_ videogen.test_lut_thingy.pixel_feeder_inst.v_counter\[0\]
+ net719 sg13g2_dfrbpq_2
XFILLER_29_300 VPWR VGND sg13g2_decap_8
XFILLER_28_33 VPWR VGND sg13g2_fill_1
XFILLER_28_44 VPWR VGND sg13g2_fill_1
XFILLER_45_848 VPWR VGND sg13g2_decap_8
XFILLER_44_32 VPWR VGND sg13g2_fill_2
XFILLER_25_561 VPWR VGND sg13g2_decap_4
XFILLER_44_87 VPWR VGND sg13g2_decap_4
XFILLER_25_583 VPWR VGND sg13g2_decap_4
XFILLER_8_204 VPWR VGND sg13g2_fill_2
XFILLER_12_255 VPWR VGND sg13g2_fill_1
XFILLER_12_277 VPWR VGND sg13g2_fill_1
XFILLER_5_966 VPWR VGND sg13g2_decap_8
XFILLER_4_454 VPWR VGND sg13g2_decap_8
X_6211__416 VPWR VGND net416 sg13g2_tiehi
XFILLER_0_693 VPWR VGND sg13g2_decap_8
XFILLER_36_815 VPWR VGND sg13g2_decap_8
XFILLER_36_826 VPWR VGND sg13g2_fill_1
XFILLER_44_870 VPWR VGND sg13g2_decap_8
X_3970_ net895 VPWR _1020_ VGND videogen.another_shader.time_cnt\[14\] _1016_ sg13g2_o21ai_1
XFILLER_31_520 VPWR VGND sg13g2_decap_4
X_5640_ _2607_ VPWR _2615_ VGND _2592_ net612 sg13g2_o21ai_1
X_5571_ _2554_ tmds_red.dc_balancing_reg\[4\] _2553_ VPWR VGND sg13g2_xnor2_1
X_4522_ net705 videogen.test_lut_thingy.pixel_feeder_inst.row\[12\]\[3\] videogen.test_lut_thingy.pixel_feeder_inst.row\[13\]\[3\]
+ videogen.test_lut_thingy.pixel_feeder_inst.row\[14\]\[3\] videogen.test_lut_thingy.pixel_feeder_inst.row\[15\]\[3\]
+ net701 _1529_ VPWR VGND sg13g2_mux4_1
X_4453_ net682 _1459_ _1460_ VPWR VGND sg13g2_nor2_1
X_3404_ net665 _0774_ _0790_ _0792_ VPWR VGND sg13g2_nor3_2
X_4384_ net691 _1387_ _1388_ _1390_ _1391_ VPWR VGND sg13g2_nor4_1
Xfanout706 net707 net706 VPWR VGND sg13g2_buf_8
X_3335_ VPWR _0728_ net680 VGND sg13g2_inv_1
Xfanout739 net740 net739 VPWR VGND sg13g2_buf_1
Xfanout717 videogen.another_shader.video_x\[2\] net717 VPWR VGND sg13g2_buf_8
Xfanout728 net733 net728 VPWR VGND sg13g2_buf_8
X_6123_ net784 net828 _0183_ VPWR VGND sg13g2_nor2_1
XFILLER_39_620 VPWR VGND sg13g2_decap_4
X_6054_ net757 net799 _0115_ VPWR VGND sg13g2_nor2_1
X_6585__255 VPWR VGND net255 sg13g2_tiehi
X_5005_ _2011_ VPWR _2012_ VGND _2005_ _2010_ sg13g2_o21ai_1
X_6262__336 VPWR VGND net336 sg13g2_tiehi
X_5907_ VPWR _0691_ _2845_ VGND sg13g2_inv_1
X_5838_ _2746_ tmds_blue.dc_balancing_reg\[2\] _2743_ _2796_ VPWR VGND sg13g2_mux2_1
X_5769_ _2729_ _2726_ _2727_ VPWR VGND sg13g2_xnor2_1
XFILLER_2_958 VPWR VGND sg13g2_decap_8
XFILLER_1_435 VPWR VGND sg13g2_decap_8
XFILLER_49_417 VPWR VGND sg13g2_decap_8
XFILLER_39_76 VPWR VGND sg13g2_fill_2
XFILLER_45_645 VPWR VGND sg13g2_fill_2
XFILLER_45_689 VPWR VGND sg13g2_fill_2
X_6308__244 VPWR VGND net244 sg13g2_tiehi
X_6597__115 VPWR VGND net115 sg13g2_tiehi
XFILLER_9_502 VPWR VGND sg13g2_fill_2
X_6420__73 VPWR VGND net73 sg13g2_tiehi
X_6534__121 VPWR VGND net121 sg13g2_tiehi
XFILLER_4_251 VPWR VGND sg13g2_fill_2
XFILLER_4_240 VPWR VGND sg13g2_fill_2
XFILLER_45_1002 VPWR VGND sg13g2_decap_8
X_6315__226 VPWR VGND net226 sg13g2_tiehi
XFILLER_0_490 VPWR VGND sg13g2_decap_8
XFILLER_1_991 VPWR VGND sg13g2_decap_8
XFILLER_49_995 VPWR VGND sg13g2_decap_8
XFILLER_35_111 VPWR VGND sg13g2_fill_2
XFILLER_36_678 VPWR VGND sg13g2_decap_8
XFILLER_32_851 VPWR VGND sg13g2_decap_8
X_3953_ net895 VPWR _1008_ VGND videogen.another_shader.time_cnt\[9\] _1006_ sg13g2_o21ai_1
X_3884_ _0962_ _0963_ _0320_ VPWR VGND sg13g2_nor2_1
X_5623_ _2598_ _2599_ _2600_ VPWR VGND sg13g2_nor2_1
X_5554_ _2538_ _2500_ _2528_ VPWR VGND sg13g2_nand2_1
X_4505_ VGND VPWR _1512_ net639 videogen.test_lut_thingy.pixel_feeder_inst.row\[30\]\[3\]
+ sg13g2_or2_1
X_5485_ _2471_ _2461_ _2469_ VPWR VGND sg13g2_xnor2_1
X_6513__249 VPWR VGND net249 sg13g2_tiehi
X_4436_ videogen.test_lut_thingy.pixel_feeder_inst.row\[14\]\[1\] net637 _1443_ VPWR
+ VGND sg13g2_nor2_1
X_4367_ net698 _1368_ _1373_ _1374_ VPWR VGND sg13g2_nor3_1
X_6106_ net771 net809 _0166_ VPWR VGND sg13g2_nor2_1
X_4298_ _1305_ _1299_ _1304_ VPWR VGND sg13g2_nand2_1
X_6037_ net780 net823 _0098_ VPWR VGND sg13g2_nor2_1
XFILLER_42_615 VPWR VGND sg13g2_decap_8
XFILLER_41_114 VPWR VGND sg13g2_decap_4
XFILLER_23_873 VPWR VGND sg13g2_fill_1
XFILLER_10_512 VPWR VGND sg13g2_fill_2
XFILLER_46_932 VPWR VGND sg13g2_decap_8
XFILLER_45_497 VPWR VGND sg13g2_fill_2
XFILLER_32_147 VPWR VGND sg13g2_fill_1
XFILLER_9_321 VPWR VGND sg13g2_fill_1
XFILLER_12_1012 VPWR VGND sg13g2_decap_8
X_5270_ VGND VPWR _0413_ _0414_ _2183_ sg13g2_or2_1
X_4221_ _1228_ _1119_ _1120_ VPWR VGND sg13g2_xnor2_1
X_4152_ _1158_ _1151_ _1159_ VPWR VGND sg13g2_xor2_1
X_4083_ _1100_ net672 _1097_ VPWR VGND sg13g2_nand2_1
XFILLER_49_792 VPWR VGND sg13g2_decap_8
XFILLER_37_932 VPWR VGND sg13g2_decap_8
XFILLER_24_637 VPWR VGND sg13g2_fill_1
X_4985_ _1980_ _1991_ _1992_ VPWR VGND sg13g2_nor2b_1
XFILLER_11_309 VPWR VGND sg13g2_fill_2
X_3936_ videogen.another_shader.time_cnt\[3\] _0996_ _0997_ VPWR VGND sg13g2_and2_1
XFILLER_20_832 VPWR VGND sg13g2_fill_2
X_3867_ videogen.test_lut_thingy.pixel_feeder_inst.v_pix\[0\] _0950_ _0951_ VPWR VGND
+ sg13g2_and2_1
X_6655_ net267 VGND VPWR _0710_ serialize.shift_reg_c\[5\] clknet_3_3__leaf_clk_regs
+ sg13g2_dfrbpq_1
X_3798_ _0915_ videogen.test_lut_thingy.pixel_feeder_inst.v_pix\[3\] videogen.test_lut_thingy.pixel_feeder_inst.v_pix\[4\]
+ _0920_ VPWR VGND sg13g2_a21o_1
X_6586_ net247 VGND VPWR _0641_ videogen.test_lut_thingy.pixel_feeder_inst.row\[7\]\[3\]
+ _0228_ sg13g2_dfrbpq_1
X_5606_ _2583_ green\[0\] _2582_ VPWR VGND sg13g2_nand2_2
X_5537_ _2457_ _2516_ _2522_ VPWR VGND sg13g2_nor2_1
X_5468_ _2453_ VPWR _2454_ VGND red\[6\] red\[4\] sg13g2_o21ai_1
X_5399_ _2379_ _2391_ _2392_ VPWR VGND _2345_ sg13g2_nand3b_1
X_4419_ videogen.test_lut_thingy.pixel_feeder_inst.row\[29\]\[1\] net629 _1426_ VPWR
+ VGND sg13g2_nor2_1
XFILLER_46_206 VPWR VGND sg13g2_decap_4
X_6565__445 VPWR VGND net445 sg13g2_tiehi
XFILLER_46_239 VPWR VGND sg13g2_decap_4
XFILLER_43_968 VPWR VGND sg13g2_decap_8
XFILLER_14_169 VPWR VGND sg13g2_decap_4
XFILLER_30_629 VPWR VGND sg13g2_fill_1
XFILLER_11_821 VPWR VGND sg13g2_fill_1
X_6613__479 VPWR VGND net479 sg13g2_tiehi
XFILLER_2_530 VPWR VGND sg13g2_decap_8
XFILLER_45_250 VPWR VGND sg13g2_fill_2
XFILLER_34_924 VPWR VGND sg13g2_fill_1
XFILLER_45_283 VPWR VGND sg13g2_fill_2
XFILLER_34_979 VPWR VGND sg13g2_decap_8
XFILLER_33_456 VPWR VGND sg13g2_decap_8
X_4770_ _1777_ _1767_ _1775_ VPWR VGND sg13g2_nand2_1
X_3721_ videogen.test_lut_thingy.pixel_feeder_inst.row\[17\]\[2\] net863 _0875_ _0298_
+ VPWR VGND sg13g2_mux2_1
XFILLER_9_173 VPWR VGND sg13g2_decap_4
X_3652_ videogen.test_lut_thingy.pixel_feeder_inst.row\[9\]\[1\] net870 _0861_ _0482_
+ VPWR VGND sg13g2_mux2_1
X_6440_ net33 VGND VPWR _0495_ videogen.test_lut_thingy.pixel_feeder_inst.row\[10\]\[2\]
+ _0091_ sg13g2_dfrbpq_1
X_6371_ net148 VGND VPWR _0430_ red_tmds_par\[5\] net739 sg13g2_dfrbpq_1
X_3583_ videogen.test_lut_thingy.pixel_feeder_inst.row\[55\]\[2\] net864 _0845_ _0535_
+ VPWR VGND sg13g2_mux2_1
X_5322_ VPWR _2315_ _2314_ VGND sg13g2_inv_1
XFILLER_47_0 VPWR VGND sg13g2_decap_8
X_5253_ _2249_ _2251_ _2252_ VPWR VGND sg13g2_nor2_1
X_5184_ _1566_ _2181_ _2182_ _2183_ VPWR VGND sg13g2_nor3_1
X_4204_ _1211_ _1210_ VPWR VGND sg13g2_inv_2
X_4135_ net714 net679 _1142_ VPWR VGND sg13g2_nor2_1
XFILLER_28_217 VPWR VGND sg13g2_decap_8
XFILLER_28_228 VPWR VGND sg13g2_fill_1
X_4066_ VGND VPWR net677 _0928_ _1087_ net676 sg13g2_a21oi_1
XFILLER_37_762 VPWR VGND sg13g2_decap_8
XFILLER_36_250 VPWR VGND sg13g2_fill_2
XFILLER_40_916 VPWR VGND sg13g2_decap_8
XFILLER_24_456 VPWR VGND sg13g2_decap_8
X_4968_ _1974_ VPWR _1975_ VGND _1968_ _1971_ sg13g2_o21ai_1
X_4899_ _1895_ _1902_ _1905_ _1906_ VPWR VGND sg13g2_nor3_1
X_3919_ videogen.test_lut_thingy.pixel_feeder_inst.h_counter\[0\] net621 _0987_ VPWR
+ VGND sg13g2_nor2_1
XFILLER_22_35 VPWR VGND sg13g2_decap_8
X_6638_ net103 VGND VPWR _0693_ serialize.shift_reg_g\[0\] clknet_3_6__leaf_clk_regs
+ sg13g2_dfrbpq_1
X_6569_ net425 VGND VPWR _0624_ videogen.test_lut_thingy.pixel_feeder_inst.row\[40\]\[2\]
+ _0211_ sg13g2_dfrbpq_1
XFILLER_47_21 VPWR VGND sg13g2_decap_4
XFILLER_19_228 VPWR VGND sg13g2_decap_8
XFILLER_42_231 VPWR VGND sg13g2_decap_8
X_6496__303 VPWR VGND net303 sg13g2_tiehi
XFILLER_31_905 VPWR VGND sg13g2_decap_4
XFILLER_24_990 VPWR VGND sg13g2_decap_8
XFILLER_30_448 VPWR VGND sg13g2_fill_2
XFILLER_7_622 VPWR VGND sg13g2_decap_4
XFILLER_6_165 VPWR VGND sg13g2_fill_1
XFILLER_40_7 VPWR VGND sg13g2_fill_2
XFILLER_2_371 VPWR VGND sg13g2_decap_4
X_5940_ _2862_ net746 net515 net751 red_tmds_par\[7\] VPWR VGND sg13g2_a22oi_1
X_6444__482 VPWR VGND net482 sg13g2_tiehi
X_5871_ _2825_ _2688_ _2818_ VPWR VGND sg13g2_xnor2_1
X_4822_ VGND VPWR _1829_ _1828_ _1758_ sg13g2_or2_1
XFILLER_15_990 VPWR VGND sg13g2_decap_8
XFILLER_21_415 VPWR VGND sg13g2_fill_1
XFILLER_33_264 VPWR VGND sg13g2_decap_8
X_4753_ videogen.another_shader.time_cnt\[24\] _1757_ videogen.another_shader.time_cnt\[25\]
+ _1760_ VPWR VGND sg13g2_nand3_1
X_3704_ _0778_ _0797_ _0872_ VPWR VGND sg13g2_nor2_2
X_4684_ _1691_ videogen.another_shader.time_cnt\[4\] net715 VPWR VGND sg13g2_xnor2_1
X_6423_ net67 VGND VPWR _0478_ videogen.test_lut_thingy.pixel_feeder_inst.row\[32\]\[1\]
+ _0074_ sg13g2_dfrbpq_1
X_3635_ videogen.test_lut_thingy.pixel_feeder_inst.row\[10\]\[1\] net870 _0856_ _0494_
+ VPWR VGND sg13g2_mux2_1
XFILLER_1_809 VPWR VGND sg13g2_decap_8
X_6354_ net165 VGND VPWR _0413_ green\[3\] net737 sg13g2_dfrbpq_2
X_3566_ _0807_ _0817_ _0842_ VPWR VGND sg13g2_nor2_2
XFILLER_0_308 VPWR VGND sg13g2_decap_8
X_6285_ net290 VGND VPWR _0344_ videogen.another_shader.time_cnt\[0\] net728 sg13g2_dfrbpq_2
X_5305_ _2298_ _2280_ _2296_ VPWR VGND sg13g2_xnor2_1
X_3497_ videogen.test_lut_thingy.pixel_feeder_inst.row\[43\]\[2\] net867 _0827_ _0612_
+ VPWR VGND sg13g2_mux2_1
X_5236_ _2235_ _2187_ _2233_ VPWR VGND sg13g2_xnor2_1
X_5167_ _2172_ _2170_ _2171_ VPWR VGND sg13g2_xnor2_1
X_5098_ _2092_ _2089_ _2104_ _2105_ VPWR VGND sg13g2_a21o_2
X_4118_ _1125_ _1122_ _1124_ VPWR VGND sg13g2_xnor2_1
X_4049_ net679 _1074_ _1076_ VPWR VGND sg13g2_nor2_1
XFILLER_13_949 VPWR VGND sg13g2_fill_1
XFILLER_4_658 VPWR VGND sg13g2_decap_8
X_6272__316 VPWR VGND net316 sg13g2_tiehi
XFILLER_48_846 VPWR VGND sg13g2_decap_8
XFILLER_0_886 VPWR VGND sg13g2_decap_8
Xhold8 _0305_ VPWR VGND net496 sg13g2_dlygate4sd3_1
XFILLER_47_345 VPWR VGND sg13g2_decap_8
XFILLER_28_592 VPWR VGND sg13g2_decap_8
XFILLER_8_931 VPWR VGND sg13g2_decap_8
XFILLER_8_942 VPWR VGND sg13g2_fill_2
XFILLER_48_1000 VPWR VGND sg13g2_decap_8
X_3420_ videogen.test_lut_thingy.pixel_feeder_inst.row\[23\]\[3\] net857 _0799_ _0672_
+ VPWR VGND sg13g2_mux2_1
X_3351_ VPWR _0744_ videogen.test_lut_thingy.pixel_feeder_inst.state\[1\] VGND sg13g2_inv_1
XFILLER_39_802 VPWR VGND sg13g2_fill_2
X_6070_ net772 net815 _0131_ VPWR VGND sg13g2_nor2_1
X_5021_ _2028_ _1725_ _2026_ VPWR VGND sg13g2_xnor2_1
X_6509__265 VPWR VGND net265 sg13g2_tiehi
XFILLER_38_356 VPWR VGND sg13g2_fill_1
X_6325__206 VPWR VGND net206 sg13g2_tiehi
X_5923_ VPWR _0699_ _2853_ VGND sg13g2_inv_1
X_5854_ _2811_ _2784_ _0755_ _2744_ _2743_ VPWR VGND sg13g2_a22oi_1
XFILLER_34_573 VPWR VGND sg13g2_fill_1
X_4805_ VGND VPWR _1791_ _1800_ _1812_ _1788_ sg13g2_a21oi_1
X_6479__375 VPWR VGND net375 sg13g2_tiehi
X_5785_ _2745_ _2736_ _2741_ VPWR VGND sg13g2_nand2_2
X_4736_ videogen.another_shader.time_cnt\[17\] net680 videogen.another_shader.time_cnt\[18\]
+ _1743_ VPWR VGND _1737_ sg13g2_nand4_1
X_4667_ _1674_ net681 videogen.another_shader.video_x\[1\] VPWR VGND sg13g2_xnor2_1
X_6406_ net93 VGND VPWR _0461_ red_tmds_par\[4\] net738 sg13g2_dfrbpq_1
X_3618_ net865 videogen.test_lut_thingy.pixel_feeder_inst.row\[61\]\[2\] _0852_ _0507_
+ VPWR VGND sg13g2_mux2_1
X_6337_ net182 VGND VPWR _0396_ videogen.test_lut_thingy.gol_counter_reg\[0\] net729
+ sg13g2_dfrbpq_2
X_4598_ videogen.test_lut_thingy.pixel_feeder_inst.row\[11\]\[0\] net654 _1605_ VPWR
+ VGND sg13g2_nor2_1
X_3549_ videogen.test_lut_thingy.pixel_feeder_inst.row\[26\]\[1\] net874 _0838_ _0571_
+ VPWR VGND sg13g2_mux2_1
XFILLER_0_105 VPWR VGND sg13g2_decap_8
XFILLER_0_138 VPWR VGND sg13g2_decap_4
X_6268_ net324 VGND VPWR _0327_ videogen.test_lut_thingy.pixel_feeder_inst.h_pix\[5\]
+ net722 sg13g2_dfrbpq_2
X_6199_ net788 net831 _0259_ VPWR VGND sg13g2_nor2_1
X_5219_ VPWR _2218_ _2217_ VGND sg13g2_inv_1
X_6232__388 VPWR VGND net388 sg13g2_tiehi
XFILLER_45_827 VPWR VGND sg13g2_decap_8
XFILLER_29_378 VPWR VGND sg13g2_fill_1
XFILLER_44_337 VPWR VGND sg13g2_fill_1
XFILLER_13_735 VPWR VGND sg13g2_fill_1
XFILLER_25_595 VPWR VGND sg13g2_decap_8
XFILLER_9_728 VPWR VGND sg13g2_fill_2
XFILLER_8_238 VPWR VGND sg13g2_fill_2
XFILLER_5_945 VPWR VGND sg13g2_decap_8
XFILLER_0_672 VPWR VGND sg13g2_decap_8
XFILLER_35_326 VPWR VGND sg13g2_fill_1
XFILLER_35_359 VPWR VGND sg13g2_fill_2
X_5570_ VGND VPWR tmds_red.dc_balancing_reg\[3\] _2526_ _2553_ _2547_ sg13g2_a21oi_1
XFILLER_12_790 VPWR VGND sg13g2_fill_2
XFILLER_8_761 VPWR VGND sg13g2_fill_2
X_4521_ net701 videogen.test_lut_thingy.pixel_feeder_inst.row\[8\]\[3\] videogen.test_lut_thingy.pixel_feeder_inst.row\[10\]\[3\]
+ videogen.test_lut_thingy.pixel_feeder_inst.row\[9\]\[3\] videogen.test_lut_thingy.pixel_feeder_inst.row\[11\]\[3\]
+ net704 _1528_ VPWR VGND sg13g2_mux4_1
X_4452_ net685 _1447_ _1458_ _1459_ VPWR VGND sg13g2_nor3_1
X_3403_ videogen.test_lut_thingy.pixel_feeder_inst.row\[21\]\[0\] net888 _0791_ _0681_
+ VPWR VGND sg13g2_mux2_1
X_4383_ _1389_ VPWR _1390_ VGND videogen.test_lut_thingy.pixel_feeder_inst.row\[36\]\[2\]
+ net648 sg13g2_o21ai_1
X_3334_ _0727_ videogen.another_shader.time_cnt\[17\] VPWR VGND sg13g2_inv_2
Xfanout729 net730 net729 VPWR VGND sg13g2_buf_8
Xfanout718 net719 net718 VPWR VGND sg13g2_buf_8
Xfanout707 videogen.test_lut_thingy.pixel_feeder_inst.h_pix\[0\] net707 VPWR VGND
+ sg13g2_buf_8
X_6122_ net784 net827 _0182_ VPWR VGND sg13g2_nor2_1
X_6053_ net757 net799 _0114_ VPWR VGND sg13g2_nor2_1
XFILLER_39_654 VPWR VGND sg13g2_fill_2
X_5004_ _2011_ _1993_ _2003_ VPWR VGND sg13g2_nand2_1
XFILLER_38_142 VPWR VGND sg13g2_fill_1
X_6626__275 VPWR VGND net275 sg13g2_tiehi
X_5906_ _2845_ net747 net519 net752 blue_tmds_par\[6\] VPWR VGND sg13g2_a22oi_1
XFILLER_35_893 VPWR VGND sg13g2_decap_8
XFILLER_14_25 VPWR VGND sg13g2_fill_1
XFILLER_14_36 VPWR VGND sg13g2_decap_8
X_5837_ VGND VPWR _2733_ _2774_ _2795_ _2773_ sg13g2_a21oi_1
X_5768_ _2726_ _2727_ _2728_ VPWR VGND sg13g2_nor2_1
X_4719_ VPWR VGND _1720_ _1714_ _1719_ videogen.another_shader.time_cnt\[9\] _1726_
+ videogen.another_shader.video_x\[9\] sg13g2_a221oi_1
X_5699_ _2665_ _2645_ _2663_ VPWR VGND sg13g2_xnor2_1
XFILLER_30_46 VPWR VGND sg13g2_fill_1
XFILLER_30_57 VPWR VGND sg13g2_fill_1
XFILLER_2_937 VPWR VGND sg13g2_decap_8
XFILLER_1_414 VPWR VGND sg13g2_decap_8
XFILLER_17_304 VPWR VGND sg13g2_fill_2
XFILLER_18_816 VPWR VGND sg13g2_fill_2
XFILLER_17_315 VPWR VGND sg13g2_fill_2
XFILLER_45_668 VPWR VGND sg13g2_decap_8
XFILLER_38_1021 VPWR VGND sg13g2_decap_8
XFILLER_9_525 VPWR VGND sg13g2_decap_4
XFILLER_41_896 VPWR VGND sg13g2_decap_8
X_6616__455 VPWR VGND net455 sg13g2_tiehi
X_6471__423 VPWR VGND net423 sg13g2_tiehi
XFILLER_5_742 VPWR VGND sg13g2_fill_2
XFILLER_1_970 VPWR VGND sg13g2_decap_8
XFILLER_49_974 VPWR VGND sg13g2_decap_8
XFILLER_36_646 VPWR VGND sg13g2_fill_1
XFILLER_35_178 VPWR VGND sg13g2_fill_2
X_3952_ videogen.another_shader.time_cnt\[9\] _1006_ _1007_ VPWR VGND sg13g2_and2_1
X_3883_ _0954_ VPWR _0963_ VGND videogen.test_lut_thingy.pixel_feeder_inst.v_pix\[4\]
+ _0960_ sg13g2_o21ai_1
X_5622_ _2566_ _2583_ _2593_ _2599_ VPWR VGND sg13g2_nor3_2
X_5553_ _2537_ _2535_ _2536_ VPWR VGND sg13g2_nand2_1
X_4504_ _1413_ _1510_ _1511_ VPWR VGND sg13g2_nor2_1
X_5484_ VPWR _2470_ _2469_ VGND sg13g2_inv_1
X_4435_ net692 VPWR _1442_ VGND videogen.test_lut_thingy.pixel_feeder_inst.row\[12\]\[1\]
+ net648 sg13g2_o21ai_1
XFILLER_6_81 VPWR VGND sg13g2_fill_1
X_4366_ net688 _1369_ _1370_ _1372_ _1373_ VPWR VGND sg13g2_nor4_1
X_6105_ net767 net814 _0165_ VPWR VGND sg13g2_nor2_1
X_4297_ _1304_ _1303_ _1302_ VPWR VGND sg13g2_nand2b_1
X_6036_ net780 net823 _0097_ VPWR VGND sg13g2_nor2_1
XFILLER_41_148 VPWR VGND sg13g2_fill_1
XFILLER_41_126 VPWR VGND sg13g2_fill_1
XFILLER_23_841 VPWR VGND sg13g2_fill_2
X_6548__56 VPWR VGND net56 sg13g2_tiehi
XFILLER_10_557 VPWR VGND sg13g2_decap_8
XFILLER_6_528 VPWR VGND sg13g2_decap_8
XFILLER_2_712 VPWR VGND sg13g2_fill_2
XFILLER_1_233 VPWR VGND sg13g2_decap_8
XFILLER_49_204 VPWR VGND sg13g2_decap_8
XFILLER_49_248 VPWR VGND sg13g2_decap_8
XFILLER_2_39 VPWR VGND sg13g2_decap_8
XFILLER_46_911 VPWR VGND sg13g2_decap_8
XFILLER_18_624 VPWR VGND sg13g2_decap_8
XFILLER_46_988 VPWR VGND sg13g2_decap_8
XFILLER_14_874 VPWR VGND sg13g2_decap_8
XFILLER_32_159 VPWR VGND sg13g2_decap_8
XFILLER_41_682 VPWR VGND sg13g2_decap_4
XFILLER_13_373 VPWR VGND sg13g2_decap_4
XFILLER_9_377 VPWR VGND sg13g2_fill_2
X_4220_ _1227_ _1137_ _1225_ VPWR VGND sg13g2_xnor2_1
X_4151_ VGND VPWR _1152_ _1157_ _1158_ _1153_ sg13g2_a21oi_1
X_4082_ VGND VPWR _1099_ _1097_ net672 sg13g2_or2_1
XFILLER_49_771 VPWR VGND sg13g2_decap_8
XFILLER_37_911 VPWR VGND sg13g2_decap_8
XFILLER_36_443 VPWR VGND sg13g2_decap_4
XFILLER_37_988 VPWR VGND sg13g2_decap_8
X_4984_ _1991_ _1729_ _1990_ VPWR VGND sg13g2_nand2_1
X_3935_ net846 _0995_ _0996_ _0346_ VPWR VGND sg13g2_nor3_1
X_6654_ net283 VGND VPWR net490 clockdiv.q0 clknet_3_2__leaf_clk_regs sg13g2_dfrbpq_1
XFILLER_31_170 VPWR VGND sg13g2_fill_2
X_3866_ VPWR VGND net618 _0736_ _0948_ _0737_ _0950_ _0883_ sg13g2_a221oi_1
X_5605_ VPWR _2582_ _2581_ VGND sg13g2_inv_1
X_3797_ videogen.test_lut_thingy.pixel_feeder_inst.v_pix\[3\] _0915_ videogen.test_lut_thingy.pixel_feeder_inst.v_pix\[4\]
+ _0919_ VPWR VGND sg13g2_nand3_1
X_6585_ net255 VGND VPWR _0640_ videogen.test_lut_thingy.pixel_feeder_inst.row\[7\]\[2\]
+ _0227_ sg13g2_dfrbpq_1
X_5536_ _2521_ _2516_ _2518_ _2520_ VPWR VGND sg13g2_and3_1
XFILLER_11_37 VPWR VGND sg13g2_fill_1
X_5467_ _2451_ VPWR _2453_ VGND _2449_ _2452_ sg13g2_o21ai_1
X_6454__462 VPWR VGND net462 sg13g2_tiehi
X_4418_ net693 VPWR _1425_ VGND videogen.test_lut_thingy.pixel_feeder_inst.row\[28\]\[1\]
+ net649 sg13g2_o21ai_1
X_5398_ _2387_ _2381_ _2391_ VPWR VGND sg13g2_xor2_1
XFILLER_28_1020 VPWR VGND sg13g2_decap_8
X_4349_ videogen.test_lut_thingy.pixel_feeder_inst.row\[1\]\[2\] net622 _1356_ VPWR
+ VGND sg13g2_nor2_1
X_6019_ net761 net802 _0080_ VPWR VGND sg13g2_nor2_1
XFILLER_43_947 VPWR VGND sg13g2_decap_8
XFILLER_42_457 VPWR VGND sg13g2_decap_8
XFILLER_14_148 VPWR VGND sg13g2_decap_8
XFILLER_11_844 VPWR VGND sg13g2_decap_4
X_6635__127 VPWR VGND net127 sg13g2_tiehi
XFILLER_6_369 VPWR VGND sg13g2_fill_1
XFILLER_2_586 VPWR VGND sg13g2_decap_8
Xfanout890 ui_in[4] net890 VPWR VGND sg13g2_buf_8
XFILLER_18_443 VPWR VGND sg13g2_decap_4
XFILLER_46_763 VPWR VGND sg13g2_fill_1
XFILLER_34_958 VPWR VGND sg13g2_fill_1
XFILLER_42_980 VPWR VGND sg13g2_decap_8
X_3720_ videogen.test_lut_thingy.pixel_feeder_inst.row\[17\]\[3\] net853 _0875_ _0299_
+ VPWR VGND sg13g2_mux2_1
XFILLER_20_129 VPWR VGND sg13g2_fill_1
X_3651_ videogen.test_lut_thingy.pixel_feeder_inst.row\[9\]\[2\] net860 _0861_ _0483_
+ VPWR VGND sg13g2_mux2_1
X_6370_ net149 VGND VPWR _0429_ red_tmds_par\[3\] net740 sg13g2_dfrbpq_1
X_3582_ videogen.test_lut_thingy.pixel_feeder_inst.row\[55\]\[3\] net852 _0845_ _0536_
+ VPWR VGND sg13g2_mux2_1
XFILLER_6_881 VPWR VGND sg13g2_decap_8
X_5321_ _2309_ _2305_ _2314_ VPWR VGND sg13g2_xor2_1
X_5252_ _2250_ _2227_ _2251_ VPWR VGND sg13g2_xor2_1
X_4203_ _1210_ _1208_ _1209_ VPWR VGND sg13g2_xnor2_1
X_5183_ _1413_ _1565_ _2182_ VPWR VGND sg13g2_and2_1
X_4134_ _1141_ net714 net679 VPWR VGND sg13g2_nand2_1
XFILLER_49_590 VPWR VGND sg13g2_decap_8
XFILLER_3_1022 VPWR VGND sg13g2_decap_8
X_4065_ VGND VPWR net677 _0928_ _0386_ _1086_ sg13g2_a21oi_1
XFILLER_24_402 VPWR VGND sg13g2_fill_1
X_4967_ _1958_ VPWR _1974_ VGND _1957_ _1973_ sg13g2_o21ai_1
XFILLER_11_107 VPWR VGND sg13g2_fill_1
X_4898_ _1905_ _1745_ _1887_ VPWR VGND sg13g2_nand2_1
X_3918_ _0986_ _0966_ VPWR VGND _0897_ sg13g2_nand2b_2
XFILLER_20_663 VPWR VGND sg13g2_decap_4
X_6637_ net111 VGND VPWR _0692_ serialize.shift_reg_b\[7\] clknet_3_3__leaf_clk_regs
+ sg13g2_dfrbpq_1
X_3849_ blue_tmds_par\[8\] net752 _0286_ VPWR VGND sg13g2_and2_1
XFILLER_20_696 VPWR VGND sg13g2_decap_8
X_6568_ net433 VGND VPWR _0623_ videogen.test_lut_thingy.pixel_feeder_inst.row\[40\]\[1\]
+ _0210_ sg13g2_dfrbpq_1
X_5519_ _2503_ VPWR _2504_ VGND tmds_red.dc_balancing_reg\[1\] _2471_ sg13g2_o21ai_1
X_6499_ net297 VGND VPWR _0554_ tmds_blue.dc_balancing_reg\[1\] net742 sg13g2_dfrbpq_2
XFILLER_0_7 VPWR VGND sg13g2_decap_8
X_6541__84 VPWR VGND net84 sg13g2_tiehi
XFILLER_43_733 VPWR VGND sg13g2_decap_4
XFILLER_43_777 VPWR VGND sg13g2_fill_2
X_6207__422 VPWR VGND net422 sg13g2_tiehi
XFILLER_42_265 VPWR VGND sg13g2_decap_8
XFILLER_24_980 VPWR VGND sg13g2_decap_8
XFILLER_6_188 VPWR VGND sg13g2_fill_1
XFILLER_3_895 VPWR VGND sg13g2_fill_2
XFILLER_2_361 VPWR VGND sg13g2_decap_4
XFILLER_33_7 VPWR VGND sg13g2_decap_4
XFILLER_38_505 VPWR VGND sg13g2_fill_2
XFILLER_19_741 VPWR VGND sg13g2_fill_2
XFILLER_34_711 VPWR VGND sg13g2_decap_4
XFILLER_46_593 VPWR VGND sg13g2_decap_4
XFILLER_18_284 VPWR VGND sg13g2_fill_1
X_5870_ hsync _0745_ net847 _2824_ VPWR VGND sg13g2_a21o_2
XFILLER_34_722 VPWR VGND sg13g2_fill_2
X_4821_ VGND VPWR _1819_ _1828_ _1827_ _1822_ sg13g2_a21oi_2
XFILLER_34_788 VPWR VGND sg13g2_fill_1
X_4752_ _1759_ videogen.another_shader.time_cnt\[24\] _1757_ VPWR VGND sg13g2_xnor2_1
X_3703_ videogen.test_lut_thingy.pixel_feeder_inst.row\[19\]\[0\] net883 _0871_ _0340_
+ VPWR VGND sg13g2_mux2_1
X_4683_ net715 videogen.another_shader.time_cnt\[4\] _1690_ VPWR VGND sg13g2_xor2_1
X_3634_ videogen.test_lut_thingy.pixel_feeder_inst.row\[10\]\[2\] net860 _0856_ _0495_
+ VPWR VGND sg13g2_mux2_1
X_6422_ net69 VGND VPWR _0477_ videogen.test_lut_thingy.pixel_feeder_inst.row\[32\]\[0\]
+ _0073_ sg13g2_dfrbpq_1
X_3565_ videogen.test_lut_thingy.pixel_feeder_inst.row\[2\]\[0\] net881 _0841_ _0558_
+ VPWR VGND sg13g2_mux2_1
X_6353_ net166 VGND VPWR _0412_ green\[2\] net734 sg13g2_dfrbpq_2
X_6284_ net292 VGND VPWR _0343_ videogen.test_lut_thingy.pixel_feeder_inst.row\[19\]\[3\]
+ _0040_ sg13g2_dfrbpq_1
X_5304_ _2296_ _2280_ _2297_ VPWR VGND sg13g2_nor2b_1
X_3496_ videogen.test_lut_thingy.pixel_feeder_inst.row\[43\]\[3\] net857 _0827_ _0613_
+ VPWR VGND sg13g2_mux2_1
X_5235_ _2188_ _2233_ _2234_ VPWR VGND sg13g2_nor2_1
X_5166_ videogen.another_shader.time_cnt\[2\] net675 _2171_ VPWR VGND sg13g2_xor2_1
X_5097_ VGND VPWR _2089_ _2093_ _2104_ _2092_ sg13g2_a21oi_1
X_4117_ _1124_ net716 videogen.fancy_shader.shader_counter_reg\[3\] VPWR VGND sg13g2_xnor2_1
X_4048_ _1067_ _1074_ _1075_ _0380_ VPWR VGND sg13g2_nor3_1
XFILLER_17_69 VPWR VGND sg13g2_fill_2
XFILLER_25_722 VPWR VGND sg13g2_fill_1
XFILLER_13_917 VPWR VGND sg13g2_fill_1
X_5999_ net778 net821 _0060_ VPWR VGND sg13g2_nor2_1
XFILLER_21_950 VPWR VGND sg13g2_fill_1
XFILLER_4_637 VPWR VGND sg13g2_decap_8
XFILLER_0_865 VPWR VGND sg13g2_decap_8
XFILLER_48_825 VPWR VGND sg13g2_decap_8
Xhold9 serialize.shift_reg_c\[2\] VPWR VGND net497 sg13g2_dlygate4sd3_1
XFILLER_47_324 VPWR VGND sg13g2_fill_1
XFILLER_43_541 VPWR VGND sg13g2_fill_2
XFILLER_15_232 VPWR VGND sg13g2_fill_2
XFILLER_31_703 VPWR VGND sg13g2_fill_2
XFILLER_12_950 VPWR VGND sg13g2_decap_8
XFILLER_30_246 VPWR VGND sg13g2_fill_2
X_6619__431 VPWR VGND net431 sg13g2_tiehi
XFILLER_11_493 VPWR VGND sg13g2_decap_4
X_3350_ net666 _0743_ VPWR VGND sg13g2_inv_4
X_5020_ _1725_ _2026_ _2027_ VPWR VGND sg13g2_nor2b_1
XFILLER_38_379 VPWR VGND sg13g2_fill_1
XFILLER_46_390 VPWR VGND sg13g2_decap_4
X_5922_ _2853_ net746 net514 net752 green_tmds_par\[6\] VPWR VGND sg13g2_a22oi_1
XFILLER_34_552 VPWR VGND sg13g2_fill_2
X_5853_ _2790_ _2783_ _2789_ _2810_ VPWR VGND sg13g2_a21o_1
XFILLER_22_725 VPWR VGND sg13g2_decap_8
X_4804_ _1807_ VPWR _1811_ VGND _1801_ _1802_ sg13g2_o21ai_1
XFILLER_21_224 VPWR VGND sg13g2_fill_2
X_5784_ _2736_ _2739_ _2741_ _2744_ VPWR VGND sg13g2_nor3_2
X_4735_ net680 _1737_ videogen.another_shader.time_cnt\[17\] _1742_ VPWR VGND sg13g2_nand3_1
XFILLER_9_70 VPWR VGND sg13g2_fill_1
XFILLER_9_92 VPWR VGND sg13g2_decap_4
X_4666_ _1673_ net681 videogen.another_shader.video_x\[1\] VPWR VGND sg13g2_nand2_1
X_6516__237 VPWR VGND net237 sg13g2_tiehi
X_6405_ net94 VGND VPWR _0460_ red_tmds_par\[2\] net739 sg13g2_dfrbpq_1
X_4597_ videogen.test_lut_thingy.pixel_feeder_inst.row\[10\]\[0\] net633 _1604_ VPWR
+ VGND sg13g2_nor2_1
X_3617_ net850 videogen.test_lut_thingy.pixel_feeder_inst.row\[61\]\[3\] _0852_ _0508_
+ VPWR VGND sg13g2_mux2_1
X_3548_ videogen.test_lut_thingy.pixel_feeder_inst.row\[26\]\[2\] net863 _0838_ _0572_
+ VPWR VGND sg13g2_mux2_1
X_6336_ net184 VGND VPWR _0395_ videogen.another_shader.video_y\[9\] net720 sg13g2_dfrbpq_2
XFILLER_1_629 VPWR VGND sg13g2_decap_8
X_6267_ net326 VGND VPWR _0326_ videogen.test_lut_thingy.pixel_feeder_inst.h_pix\[4\]
+ net722 sg13g2_dfrbpq_2
X_3479_ videogen.test_lut_thingy.pixel_feeder_inst.row\[40\]\[3\] net857 _0822_ _0625_
+ VPWR VGND sg13g2_mux2_1
X_6198_ net788 net831 _0258_ VPWR VGND sg13g2_nor2_1
X_5218_ _2217_ _1210_ _2189_ VPWR VGND sg13g2_xnor2_1
XFILLER_28_13 VPWR VGND sg13g2_fill_1
X_5149_ _2115_ _2129_ _2156_ VPWR VGND sg13g2_nor2_1
XFILLER_28_24 VPWR VGND sg13g2_decap_8
XFILLER_45_806 VPWR VGND sg13g2_decap_8
XFILLER_44_316 VPWR VGND sg13g2_decap_8
XFILLER_12_224 VPWR VGND sg13g2_fill_1
XFILLER_8_206 VPWR VGND sg13g2_fill_1
XFILLER_5_924 VPWR VGND sg13g2_decap_8
XFILLER_5_28 VPWR VGND sg13g2_decap_8
XFILLER_5_39 VPWR VGND sg13g2_fill_1
XFILLER_0_651 VPWR VGND sg13g2_decap_8
X_6580__313 VPWR VGND net313 sg13g2_tiehi
X_6408__91 VPWR VGND net91 sg13g2_tiehi
X_6248__363 VPWR VGND net363 sg13g2_tiehi
XFILLER_16_563 VPWR VGND sg13g2_decap_4
XFILLER_15_1011 VPWR VGND sg13g2_decap_8
X_4520_ net891 videogen.test_lut_thingy.gol_counter_reg\[3\] _1527_ VPWR VGND sg13g2_nor2_1
X_4451_ net696 _1452_ _1457_ _1458_ VPWR VGND sg13g2_nor3_1
X_3402_ videogen.test_lut_thingy.pixel_feeder_inst.row\[21\]\[1\] net879 _0791_ _0682_
+ VPWR VGND sg13g2_mux2_1
X_4382_ VGND VPWR _1389_ net638 videogen.test_lut_thingy.pixel_feeder_inst.row\[38\]\[2\]
+ sg13g2_or2_1
X_6121_ net784 net827 _0181_ VPWR VGND sg13g2_nor2_1
X_3333_ VPWR _0726_ videogen.another_shader.time_cnt\[24\] VGND sg13g2_inv_1
Xfanout719 net722 net719 VPWR VGND sg13g2_buf_2
Xfanout708 videogen.another_shader.video_x\[9\] net708 VPWR VGND sg13g2_buf_8
X_6052_ net757 net799 _0113_ VPWR VGND sg13g2_nor2_1
X_5003_ _1987_ _1980_ _2010_ VPWR VGND sg13g2_xor2_1
XFILLER_38_154 VPWR VGND sg13g2_fill_2
X_5905_ VPWR _0690_ _2844_ VGND sg13g2_inv_1
X_5836_ _2794_ _2757_ _2793_ VPWR VGND sg13g2_nand2_1
XFILLER_22_555 VPWR VGND sg13g2_decap_4
X_5767_ _2727_ _2694_ _2716_ VPWR VGND sg13g2_xnor2_1
X_5698_ _2664_ _2645_ _2663_ VPWR VGND sg13g2_nand2_1
X_4718_ _1725_ _1721_ _1724_ VPWR VGND sg13g2_xnor2_1
X_4649_ videogen.test_lut_thingy.pixel_feeder_inst.row\[34\]\[0\] net639 _1656_ VPWR
+ VGND sg13g2_nor2_1
XFILLER_2_916 VPWR VGND sg13g2_decap_8
X_6319_ net218 VGND VPWR _0378_ videogen.fancy_shader.shader_counter_reg\[2\] net725
+ sg13g2_dfrbpq_2
XFILLER_7_1009 VPWR VGND sg13g2_decap_8
X_6568__433 VPWR VGND net433 sg13g2_tiehi
XFILLER_39_89 VPWR VGND sg13g2_fill_2
XFILLER_39_78 VPWR VGND sg13g2_fill_1
XFILLER_29_121 VPWR VGND sg13g2_fill_1
X_6464__442 VPWR VGND net442 sg13g2_tiehi
XFILLER_18_839 VPWR VGND sg13g2_fill_1
XFILLER_29_165 VPWR VGND sg13g2_decap_8
XFILLER_17_338 VPWR VGND sg13g2_decap_8
XFILLER_17_349 VPWR VGND sg13g2_fill_1
XFILLER_38_1000 VPWR VGND sg13g2_decap_8
XFILLER_13_533 VPWR VGND sg13g2_decap_4
X_6405__94 VPWR VGND net94 sg13g2_tiehi
X_6638__103 VPWR VGND net103 sg13g2_tiehi
XFILLER_9_504 VPWR VGND sg13g2_fill_1
XFILLER_5_710 VPWR VGND sg13g2_decap_4
XFILLER_4_242 VPWR VGND sg13g2_fill_1
XFILLER_4_286 VPWR VGND sg13g2_fill_1
XFILLER_20_80 VPWR VGND sg13g2_fill_1
XFILLER_49_953 VPWR VGND sg13g2_decap_8
XFILLER_48_463 VPWR VGND sg13g2_fill_1
XFILLER_17_850 VPWR VGND sg13g2_fill_1
XFILLER_35_157 VPWR VGND sg13g2_decap_4
X_3951_ net843 _1005_ _1006_ _0352_ VPWR VGND sg13g2_nor3_1
X_6402__234 VPWR VGND net234 sg13g2_tiehi
X_3882_ videogen.test_lut_thingy.pixel_feeder_inst.v_pix\[4\] _0960_ _0962_ VPWR VGND
+ sg13g2_and2_1
X_5621_ VGND VPWR _2597_ _2598_ _2589_ _2588_ sg13g2_a21oi_2
X_5552_ _2533_ VPWR _2536_ VGND _2491_ _2508_ sg13g2_o21ai_1
X_4503_ _1509_ VPWR _1510_ VGND _0746_ net891 sg13g2_o21ai_1
X_5483_ _2467_ _2466_ _2469_ VPWR VGND sg13g2_xor2_1
X_4434_ net687 _1437_ _1438_ _1440_ _1441_ VPWR VGND sg13g2_nor4_1
X_4365_ _1371_ VPWR _1372_ VGND videogen.test_lut_thingy.pixel_feeder_inst.row\[49\]\[2\]
+ net623 sg13g2_o21ai_1
X_6104_ net775 net818 _0164_ VPWR VGND sg13g2_nor2_1
XFILLER_6_1020 VPWR VGND sg13g2_decap_4
X_6035_ net758 net800 _0096_ VPWR VGND sg13g2_nor2_1
X_4296_ _1303_ _1301_ _1239_ VPWR VGND sg13g2_nand2b_1
XFILLER_27_625 VPWR VGND sg13g2_decap_8
XFILLER_15_809 VPWR VGND sg13g2_fill_1
XFILLER_41_138 VPWR VGND sg13g2_fill_2
XFILLER_10_514 VPWR VGND sg13g2_fill_1
XFILLER_22_363 VPWR VGND sg13g2_fill_1
X_5819_ _2751_ _2777_ _2778_ VPWR VGND sg13g2_nor2_1
XFILLER_41_79 VPWR VGND sg13g2_decap_8
XFILLER_2_724 VPWR VGND sg13g2_fill_2
XFILLER_9_4 VPWR VGND sg13g2_fill_2
XFILLER_2_757 VPWR VGND sg13g2_fill_2
XFILLER_2_18 VPWR VGND sg13g2_decap_8
XFILLER_46_967 VPWR VGND sg13g2_decap_8
XFILLER_45_455 VPWR VGND sg13g2_fill_1
XFILLER_45_499 VPWR VGND sg13g2_fill_1
X_6245__366 VPWR VGND net366 sg13g2_tiehi
XFILLER_32_138 VPWR VGND sg13g2_decap_8
XFILLER_41_661 VPWR VGND sg13g2_decap_8
XFILLER_13_352 VPWR VGND sg13g2_decap_8
XFILLER_13_363 VPWR VGND sg13g2_decap_4
X_4150_ VGND VPWR videogen.another_shader.video_y\[4\] videogen.fancy_shader.shader_counter_reg\[4\]
+ _1157_ _1156_ sg13g2_a21oi_1
X_4081_ _1097_ _1098_ _0390_ VPWR VGND sg13g2_nor2_1
X_6289__282 VPWR VGND net282 sg13g2_tiehi
XFILLER_37_967 VPWR VGND sg13g2_decap_8
X_4983_ _1727_ videogen.another_shader.time_cnt\[10\] videogen.another_shader.time_cnt\[11\]
+ _1990_ VPWR VGND sg13g2_a21o_1
XFILLER_23_105 VPWR VGND sg13g2_fill_2
X_3934_ _0996_ videogen.another_shader.time_cnt\[2\] videogen.another_shader.time_cnt\[1\]
+ _0992_ VPWR VGND sg13g2_and3_1
X_3865_ _0949_ net618 _0948_ VPWR VGND sg13g2_nand2_2
X_6653_ net317 VGND VPWR _0708_ serialize.shift_reg_r\[7\] clknet_3_4__leaf_clk_regs
+ sg13g2_dfrbpq_1
XFILLER_20_834 VPWR VGND sg13g2_fill_1
X_5604_ _2579_ _2564_ _2581_ VPWR VGND sg13g2_xor2_1
X_3796_ VGND VPWR _0909_ _0918_ net19 _0910_ sg13g2_a21oi_1
X_6584_ net263 VGND VPWR _0639_ videogen.test_lut_thingy.pixel_feeder_inst.row\[7\]\[1\]
+ _0226_ sg13g2_dfrbpq_1
XFILLER_20_889 VPWR VGND sg13g2_fill_1
X_5535_ _2520_ _2519_ VPWR VGND sg13g2_inv_2
X_5466_ VGND VPWR _2452_ _2443_ _0754_ sg13g2_or2_1
X_4417_ net700 _1418_ _1423_ _1424_ VPWR VGND sg13g2_nor3_1
X_5397_ _2381_ _2387_ _2390_ VPWR VGND sg13g2_nor2_1
X_4348_ videogen.test_lut_thingy.pixel_feeder_inst.row\[2\]\[2\] net633 _1355_ VPWR
+ VGND sg13g2_nor2_1
X_4279_ VGND VPWR _1280_ _1283_ _1286_ _1285_ sg13g2_a21oi_1
XFILLER_46_219 VPWR VGND sg13g2_fill_1
X_6018_ net759 net801 _0079_ VPWR VGND sg13g2_nor2_1
XFILLER_27_400 VPWR VGND sg13g2_fill_2
XFILLER_43_926 VPWR VGND sg13g2_decap_8
XFILLER_27_455 VPWR VGND sg13g2_fill_2
XFILLER_42_414 VPWR VGND sg13g2_fill_2
XFILLER_27_488 VPWR VGND sg13g2_decap_4
XFILLER_11_801 VPWR VGND sg13g2_decap_4
XFILLER_35_1014 VPWR VGND sg13g2_decap_8
XFILLER_7_838 VPWR VGND sg13g2_decap_8
XFILLER_10_355 VPWR VGND sg13g2_fill_1
XFILLER_2_565 VPWR VGND sg13g2_decap_8
Xfanout880 ui_in[5] net880 VPWR VGND sg13g2_buf_8
Xfanout891 net2 net891 VPWR VGND sg13g2_buf_8
XFILLER_18_477 VPWR VGND sg13g2_fill_2
XFILLER_34_915 VPWR VGND sg13g2_decap_8
XFILLER_45_285 VPWR VGND sg13g2_fill_1
XFILLER_33_414 VPWR VGND sg13g2_decap_4
XFILLER_13_171 VPWR VGND sg13g2_fill_2
X_3650_ videogen.test_lut_thingy.pixel_feeder_inst.row\[9\]\[3\] net849 _0861_ _0484_
+ VPWR VGND sg13g2_mux2_1
X_3581_ net616 _0807_ _0845_ VPWR VGND sg13g2_nor2_2
X_5320_ _2313_ _2298_ _2312_ VPWR VGND sg13g2_xnor2_1
X_5251_ VGND VPWR _2235_ _2244_ _2250_ _2234_ sg13g2_a21oi_1
X_4202_ _1209_ _1154_ _1155_ VPWR VGND sg13g2_xnor2_1
X_5182_ _2181_ _1510_ _1665_ VPWR VGND sg13g2_nand2_1
X_4133_ videogen.fancy_shader.shader_counter_reg\[6\] net712 _1140_ VPWR VGND sg13g2_xor2_1
XFILLER_3_1001 VPWR VGND sg13g2_decap_8
X_4064_ net894 VPWR _1086_ VGND net677 _0928_ sg13g2_o21ai_1
XFILLER_36_241 VPWR VGND sg13g2_fill_1
XFILLER_24_447 VPWR VGND sg13g2_fill_1
X_4966_ _1953_ _1961_ _1973_ VPWR VGND sg13g2_nor2_1
X_4897_ VPWR _1904_ _1903_ VGND sg13g2_inv_1
X_3917_ VGND VPWR _0736_ _0984_ _0331_ _0978_ sg13g2_a21oi_1
X_3848_ green_tmds_par\[9\] net751 _0285_ VPWR VGND sg13g2_and2_1
X_6636_ net119 VGND VPWR _0691_ serialize.shift_reg_b\[6\] clknet_3_3__leaf_clk_regs
+ sg13g2_dfrbpq_1
X_3779_ _0905_ net676 net677 VPWR VGND sg13g2_nand2_1
X_6567_ net437 VGND VPWR _0622_ videogen.test_lut_thingy.pixel_feeder_inst.row\[40\]\[0\]
+ _0209_ sg13g2_dfrbpq_1
X_5518_ _2503_ _2471_ _2484_ VPWR VGND sg13g2_nand2_1
X_6498_ net299 VGND VPWR _0553_ green_tmds_par\[9\] net736 sg13g2_dfrbpq_1
X_5449_ _2145_ _2431_ _2437_ _0420_ VPWR VGND sg13g2_or3_1
XFILLER_47_539 VPWR VGND sg13g2_decap_4
XFILLER_43_745 VPWR VGND sg13g2_fill_2
XFILLER_15_447 VPWR VGND sg13g2_fill_2
XFILLER_31_929 VPWR VGND sg13g2_fill_2
XFILLER_8_39 VPWR VGND sg13g2_decap_8
X_6379__136 VPWR VGND net136 sg13g2_tiehi
X_6242__369 VPWR VGND net369 sg13g2_tiehi
XFILLER_10_196 VPWR VGND sg13g2_fill_1
XFILLER_3_830 VPWR VGND sg13g2_decap_8
XFILLER_40_9 VPWR VGND sg13g2_fill_1
XFILLER_33_211 VPWR VGND sg13g2_fill_1
X_4820_ _1823_ _1825_ _1827_ VPWR VGND _1820_ sg13g2_nand3b_1
XFILLER_21_406 VPWR VGND sg13g2_decap_8
XFILLER_22_929 VPWR VGND sg13g2_fill_2
X_6602__78 VPWR VGND net78 sg13g2_tiehi
X_4751_ _1758_ _0726_ _1757_ VPWR VGND sg13g2_xnor2_1
XFILLER_14_491 VPWR VGND sg13g2_decap_8
X_3702_ videogen.test_lut_thingy.pixel_feeder_inst.row\[19\]\[1\] net873 _0871_ _0341_
+ VPWR VGND sg13g2_mux2_1
X_4682_ _1689_ videogen.another_shader.time_cnt\[4\] net715 VPWR VGND sg13g2_nand2_1
X_3633_ videogen.test_lut_thingy.pixel_feeder_inst.row\[10\]\[3\] net849 _0856_ _0496_
+ VPWR VGND sg13g2_mux2_1
X_6421_ net71 VGND VPWR _0476_ videogen.test_lut_thingy.pixel_feeder_inst.row\[33\]\[3\]
+ _0072_ sg13g2_dfrbpq_1
X_3564_ videogen.test_lut_thingy.pixel_feeder_inst.row\[2\]\[1\] net870 _0841_ _0559_
+ VPWR VGND sg13g2_mux2_1
X_6352_ net167 VGND VPWR _0411_ green\[1\] net734 sg13g2_dfrbpq_2
X_6283_ net294 VGND VPWR _0342_ videogen.test_lut_thingy.pixel_feeder_inst.row\[19\]\[2\]
+ _0039_ sg13g2_dfrbpq_1
X_5303_ _2294_ _2295_ _2296_ VPWR VGND sg13g2_nor2_1
X_3495_ _0794_ _0821_ _0827_ VPWR VGND sg13g2_nor2_2
X_5234_ VGND VPWR _2229_ _2232_ _2233_ _2225_ sg13g2_a21oi_1
X_5165_ _2163_ VPWR _2170_ VGND _2148_ _2164_ sg13g2_o21ai_1
X_4116_ net716 videogen.fancy_shader.shader_counter_reg\[3\] _1123_ VPWR VGND sg13g2_nor2_1
X_5096_ _2103_ _2102_ VPWR VGND sg13g2_inv_2
XFILLER_44_509 VPWR VGND sg13g2_fill_2
X_4047_ videogen.fancy_shader.shader_counter_reg\[4\] _1073_ _1075_ VPWR VGND sg13g2_nor2_1
X_5998_ net779 net821 _0059_ VPWR VGND sg13g2_nor2_1
X_4949_ _1934_ VPWR _1956_ VGND _1938_ _1954_ sg13g2_o21ai_1
XFILLER_20_483 VPWR VGND sg13g2_fill_2
X_6619_ net431 VGND VPWR _0674_ videogen.test_lut_thingy.pixel_feeder_inst.row\[35\]\[1\]
+ _0250_ sg13g2_dfrbpq_1
XFILLER_0_844 VPWR VGND sg13g2_decap_8
XFILLER_48_804 VPWR VGND sg13g2_decap_8
X_6427__59 VPWR VGND net59 sg13g2_tiehi
XFILLER_16_701 VPWR VGND sg13g2_decap_4
XFILLER_16_734 VPWR VGND sg13g2_fill_1
XFILLER_30_236 VPWR VGND sg13g2_decap_4
XFILLER_31_737 VPWR VGND sg13g2_decap_4
XFILLER_12_984 VPWR VGND sg13g2_decap_8
XFILLER_23_91 VPWR VGND sg13g2_decap_8
XFILLER_8_999 VPWR VGND sg13g2_decap_8
XFILLER_3_682 VPWR VGND sg13g2_decap_8
XFILLER_2_170 VPWR VGND sg13g2_decap_8
XFILLER_47_881 VPWR VGND sg13g2_decap_8
XFILLER_0_1026 VPWR VGND sg13g2_fill_2
X_5921_ VPWR _0698_ _2852_ VGND sg13g2_inv_1
XFILLER_0_84 VPWR VGND sg13g2_decap_8
X_6561__461 VPWR VGND net461 sg13g2_tiehi
X_5852_ _2808_ VPWR _2809_ VGND _2801_ _2807_ sg13g2_o21ai_1
X_4803_ _1803_ _1807_ _1810_ VPWR VGND sg13g2_and2_1
X_5783_ _2732_ _2742_ _2743_ VPWR VGND sg13g2_nor2_2
XFILLER_34_597 VPWR VGND sg13g2_fill_2
X_4734_ _1737_ net680 _1741_ VPWR VGND sg13g2_xor2_1
XFILLER_9_60 VPWR VGND sg13g2_fill_2
X_4665_ _1672_ videogen.another_shader.time_cnt\[0\] videogen.another_shader.video_x\[0\]
+ VPWR VGND sg13g2_nand2_1
X_6404_ net96 VGND VPWR _0001_ videogen.test_lut_thingy.pixel_feeder_inst.state\[3\]
+ net718 sg13g2_dfrbpq_1
X_4596_ net686 VPWR _1603_ VGND videogen.test_lut_thingy.pixel_feeder_inst.row\[9\]\[0\]
+ net622 sg13g2_o21ai_1
X_3616_ _0852_ _0809_ VPWR VGND _0778_ sg13g2_nand2b_2
XFILLER_1_608 VPWR VGND sg13g2_decap_8
X_6335_ net186 VGND VPWR _0394_ videogen.another_shader.video_y\[8\] net720 sg13g2_dfrbpq_2
X_3547_ videogen.test_lut_thingy.pixel_feeder_inst.row\[26\]\[3\] net852 _0838_ _0573_
+ VPWR VGND sg13g2_mux2_1
X_6266_ net328 VGND VPWR _0325_ videogen.test_lut_thingy.pixel_feeder_inst.h_pix\[3\]
+ net722 sg13g2_dfrbpq_1
X_3478_ _0801_ _0821_ _0822_ VPWR VGND sg13g2_nor2_2
X_6197_ net788 net831 _0257_ VPWR VGND sg13g2_nor2_1
X_5217_ _2216_ _2207_ _2212_ VPWR VGND sg13g2_xnor2_1
X_5148_ _2155_ _2154_ _2140_ VPWR VGND sg13g2_nand2b_1
X_5079_ _1696_ _2080_ _2083_ _2086_ VPWR VGND sg13g2_nor3_1
XFILLER_25_553 VPWR VGND sg13g2_fill_1
XFILLER_40_512 VPWR VGND sg13g2_decap_8
XFILLER_40_556 VPWR VGND sg13g2_decap_4
XFILLER_5_18 VPWR VGND sg13g2_fill_1
XFILLER_4_468 VPWR VGND sg13g2_fill_2
XFILLER_4_479 VPWR VGND sg13g2_decap_4
XFILLER_0_630 VPWR VGND sg13g2_decap_8
XFILLER_48_601 VPWR VGND sg13g2_fill_1
XFILLER_48_623 VPWR VGND sg13g2_fill_1
XFILLER_44_884 VPWR VGND sg13g2_decap_8
XFILLER_31_545 VPWR VGND sg13g2_decap_4
XFILLER_34_90 VPWR VGND sg13g2_fill_1
XFILLER_12_792 VPWR VGND sg13g2_fill_1
XFILLER_11_280 VPWR VGND sg13g2_fill_1
XFILLER_11_291 VPWR VGND sg13g2_fill_2
X_4450_ _1453_ _1454_ _1455_ _1456_ _1457_ VPWR VGND sg13g2_nor4_1
X_3401_ videogen.test_lut_thingy.pixel_feeder_inst.row\[21\]\[2\] net868 _0791_ _0683_
+ VPWR VGND sg13g2_mux2_1
X_4381_ videogen.test_lut_thingy.pixel_feeder_inst.row\[39\]\[2\] net658 _1388_ VPWR
+ VGND sg13g2_nor2_1
X_3332_ VPWR _0725_ videogen.another_shader.time_cnt\[27\] VGND sg13g2_inv_1
X_6120_ net759 net801 _0180_ VPWR VGND sg13g2_nor2_1
Xfanout709 net710 net709 VPWR VGND sg13g2_buf_8
X_6051_ net763 net805 _0112_ VPWR VGND sg13g2_nor2_1
X_5002_ _2009_ videogen.another_shader.time_cnt\[10\] _1727_ VPWR VGND sg13g2_xnor2_1
XFILLER_39_656 VPWR VGND sg13g2_fill_1
X_6231__390 VPWR VGND net390 sg13g2_tiehi
XFILLER_22_1027 VPWR VGND sg13g2_fill_2
XFILLER_27_818 VPWR VGND sg13g2_fill_2
XFILLER_35_840 VPWR VGND sg13g2_fill_1
X_5904_ _2844_ net747 net513 net754 blue_tmds_par\[5\] VPWR VGND sg13g2_a22oi_1
XFILLER_35_884 VPWR VGND sg13g2_fill_1
X_5835_ _2792_ VPWR _2793_ VGND _2768_ _2791_ sg13g2_o21ai_1
X_6299__262 VPWR VGND net262 sg13g2_tiehi
X_5766_ _2726_ _2695_ _2725_ VPWR VGND sg13g2_xnor2_1
X_5697_ _2662_ _2659_ _2663_ VPWR VGND sg13g2_xor2_1
X_4717_ _1724_ _0717_ _1723_ VPWR VGND sg13g2_xnor2_1
X_4648_ videogen.test_lut_thingy.pixel_feeder_inst.row\[32\]\[0\] net649 _1655_ VPWR
+ VGND sg13g2_nor2_1
X_4579_ net694 VPWR _1586_ VGND videogen.test_lut_thingy.pixel_feeder_inst.row\[29\]\[0\]
+ net629 sg13g2_o21ai_1
X_6318_ net220 VGND VPWR _0377_ videogen.fancy_shader.shader_counter_reg\[1\] net725
+ sg13g2_dfrbpq_2
XFILLER_1_449 VPWR VGND sg13g2_decap_8
X_6249_ net361 VGND VPWR _0308_ videogen.test_lut_thingy.pixel_feeder_inst.row\[29\]\[1\]
+ _0026_ sg13g2_dfrbpq_1
XFILLER_45_604 VPWR VGND sg13g2_fill_2
XFILLER_17_317 VPWR VGND sg13g2_fill_1
XFILLER_29_177 VPWR VGND sg13g2_decap_8
X_6382__132 VPWR VGND net132 sg13g2_tiehi
XFILLER_44_147 VPWR VGND sg13g2_fill_2
XFILLER_26_884 VPWR VGND sg13g2_decap_4
XFILLER_9_538 VPWR VGND sg13g2_decap_8
XFILLER_5_799 VPWR VGND sg13g2_fill_2
XFILLER_45_1016 VPWR VGND sg13g2_decap_8
XFILLER_49_932 VPWR VGND sg13g2_decap_8
XFILLER_48_442 VPWR VGND sg13g2_decap_8
XFILLER_48_486 VPWR VGND sg13g2_fill_1
XFILLER_36_637 VPWR VGND sg13g2_fill_2
X_3950_ videogen.another_shader.time_cnt\[8\] _1004_ _1006_ VPWR VGND sg13g2_and2_1
XFILLER_16_372 VPWR VGND sg13g2_decap_4
XFILLER_16_394 VPWR VGND sg13g2_decap_4
X_3881_ _0960_ _0961_ _0319_ VPWR VGND sg13g2_nor2_1
X_5620_ _2593_ VPWR _2597_ VGND _2566_ _2583_ sg13g2_o21ai_1
XFILLER_31_364 VPWR VGND sg13g2_decap_8
XFILLER_31_375 VPWR VGND sg13g2_fill_2
X_5551_ _2535_ _2511_ _2534_ VPWR VGND sg13g2_nand2_1
XFILLER_8_560 VPWR VGND sg13g2_decap_4
X_4502_ _1461_ _1508_ net891 _1509_ VPWR VGND sg13g2_nand3_1
X_5482_ _2468_ _2466_ _2467_ VPWR VGND sg13g2_nand2_1
X_4433_ _1439_ VPWR _1440_ VGND videogen.test_lut_thingy.pixel_feeder_inst.row\[7\]\[1\]
+ net654 sg13g2_o21ai_1
X_4364_ VGND VPWR _1371_ net634 videogen.test_lut_thingy.pixel_feeder_inst.row\[50\]\[2\]
+ sg13g2_or2_1
X_6103_ net775 net818 _0163_ VPWR VGND sg13g2_nor2_1
X_4295_ _1301_ _1239_ _1302_ VPWR VGND sg13g2_nor2b_1
X_6034_ net759 net801 _0095_ VPWR VGND sg13g2_nor2_1
XFILLER_26_158 VPWR VGND sg13g2_fill_1
XFILLER_23_843 VPWR VGND sg13g2_fill_1
XFILLER_22_342 VPWR VGND sg13g2_fill_1
XFILLER_34_191 VPWR VGND sg13g2_fill_1
X_5818_ _2770_ _2774_ _2777_ VPWR VGND sg13g2_and2_1
X_5749_ _2709_ _2704_ _2708_ VPWR VGND sg13g2_nand2_1
XFILLER_46_946 VPWR VGND sg13g2_decap_8
XFILLER_17_147 VPWR VGND sg13g2_decap_8
XFILLER_26_692 VPWR VGND sg13g2_fill_1
XFILLER_33_629 VPWR VGND sg13g2_decap_8
X_6505__281 VPWR VGND net281 sg13g2_tiehi
XFILLER_9_379 VPWR VGND sg13g2_fill_1
XFILLER_12_1026 VPWR VGND sg13g2_fill_2
X_6475__391 VPWR VGND net391 sg13g2_tiehi
X_4080_ net893 VPWR _1098_ VGND net673 _1096_ sg13g2_o21ai_1
XFILLER_37_946 VPWR VGND sg13g2_decap_8
XFILLER_24_618 VPWR VGND sg13g2_decap_8
X_4982_ _1989_ _1987_ _1988_ VPWR VGND sg13g2_nand2_2
X_3933_ VGND VPWR net681 _0992_ _0995_ videogen.another_shader.time_cnt\[2\] sg13g2_a21oi_1
X_3864_ _0770_ VPWR _0948_ VGND videogen.test_lut_thingy.pixel_feeder_inst.state\[1\]
+ videogen.test_lut_thingy.pixel_feeder_inst.state\[3\] sg13g2_o21ai_1
X_6652_ net333 VGND VPWR _0707_ serialize.shift_reg_r\[6\] clknet_3_4__leaf_clk_regs
+ sg13g2_dfrbpq_1
X_5603_ _2580_ _2579_ VPWR VGND sg13g2_inv_2
X_6583_ net271 VGND VPWR _0638_ videogen.test_lut_thingy.pixel_feeder_inst.row\[7\]\[0\]
+ _0225_ sg13g2_dfrbpq_1
X_3795_ _0918_ videogen.test_lut_thingy.pixel_feeder_inst.v_pix\[3\] _0915_ VPWR VGND
+ sg13g2_xnor2_1
X_5534_ _2519_ _2491_ _2511_ VPWR VGND sg13g2_nand2_2
X_5465_ _2448_ VPWR _2451_ VGND red\[7\] _2450_ sg13g2_o21ai_1
X_6630__207 VPWR VGND net207 sg13g2_tiehi
X_4416_ net688 _1419_ _1420_ _1422_ _1423_ VPWR VGND sg13g2_nor4_1
X_5396_ _2384_ _2388_ _2389_ VPWR VGND sg13g2_nor2b_1
X_4347_ _1350_ _1351_ _1352_ _1353_ _1354_ VPWR VGND sg13g2_nor4_1
X_4278_ _1284_ _1270_ _1273_ _1285_ VPWR VGND sg13g2_mux2_1
X_6017_ net758 net800 _0078_ VPWR VGND sg13g2_nor2_1
XFILLER_28_946 VPWR VGND sg13g2_fill_1
XFILLER_36_14 VPWR VGND sg13g2_fill_2
XFILLER_43_905 VPWR VGND sg13g2_decap_8
XFILLER_36_58 VPWR VGND sg13g2_fill_2
XFILLER_23_662 VPWR VGND sg13g2_decap_4
XFILLER_11_857 VPWR VGND sg13g2_fill_1
X_6544__72 VPWR VGND net72 sg13g2_tiehi
XFILLER_2_544 VPWR VGND sg13g2_decap_8
XFILLER_42_1008 VPWR VGND sg13g2_decap_8
Xfanout870 net875 net870 VPWR VGND sg13g2_buf_8
Xfanout892 net894 net892 VPWR VGND sg13g2_buf_8
Xfanout881 net890 net881 VPWR VGND sg13g2_buf_8
XFILLER_19_946 VPWR VGND sg13g2_fill_1
XFILLER_18_456 VPWR VGND sg13g2_decap_8
X_3580_ videogen.test_lut_thingy.pixel_feeder_inst.row\[52\]\[0\] net882 _0844_ _0537_
+ VPWR VGND sg13g2_mux2_1
XFILLER_5_360 VPWR VGND sg13g2_fill_1
X_5250_ _2235_ _2248_ _2249_ VPWR VGND sg13g2_and2_1
X_4201_ _1145_ _1143_ _1208_ VPWR VGND sg13g2_xor2_1
X_5181_ _2180_ VPWR _0409_ VGND _1567_ _2179_ sg13g2_o21ai_1
X_4132_ net712 videogen.fancy_shader.shader_counter_reg\[6\] _1139_ VPWR VGND sg13g2_and2_1
X_6625__309 VPWR VGND net309 sg13g2_tiehi
X_4063_ _1085_ VPWR _0385_ VGND _0748_ _1083_ sg13g2_o21ai_1
X_6332__192 VPWR VGND net192 sg13g2_tiehi
XFILLER_37_721 VPWR VGND sg13g2_decap_4
XFILLER_36_220 VPWR VGND sg13g2_decap_4
XFILLER_37_776 VPWR VGND sg13g2_decap_4
XFILLER_25_916 VPWR VGND sg13g2_fill_1
X_4965_ _1968_ _1971_ _1972_ VPWR VGND sg13g2_nor2_1
XFILLER_36_297 VPWR VGND sg13g2_decap_8
X_3916_ _0978_ _0985_ _0330_ VPWR VGND sg13g2_nor2_1
X_6228__395 VPWR VGND net395 sg13g2_tiehi
X_4896_ _1895_ _1902_ _1903_ VPWR VGND sg13g2_nor2_1
XFILLER_22_49 VPWR VGND sg13g2_decap_8
X_3847_ green_tmds_par\[8\] net751 _0284_ VPWR VGND sg13g2_and2_1
X_6635_ net127 VGND VPWR _0690_ serialize.shift_reg_b\[5\] clknet_3_0__leaf_clk_regs
+ sg13g2_dfrbpq_1
X_6593__187 VPWR VGND net187 sg13g2_tiehi
X_3778_ net676 net677 _0904_ VPWR VGND sg13g2_and2_1
X_6566_ net441 VGND VPWR _0621_ videogen.test_lut_thingy.pixel_feeder_inst.row\[41\]\[3\]
+ _0208_ sg13g2_dfrbpq_1
X_5517_ _2502_ tmds_red.dc_balancing_reg\[2\] _2485_ VPWR VGND sg13g2_xnor2_1
X_6497_ net301 VGND VPWR _0552_ green_tmds_par\[8\] net736 sg13g2_dfrbpq_1
X_5448_ net846 _2436_ _2437_ VPWR VGND sg13g2_nor2_1
X_5379_ VGND VPWR _2372_ _2369_ _2351_ sg13g2_or2_1
X_6439__35 VPWR VGND net35 sg13g2_tiehi
XFILLER_27_231 VPWR VGND sg13g2_fill_1
XFILLER_28_787 VPWR VGND sg13g2_decap_4
XFILLER_11_643 VPWR VGND sg13g2_decap_8
XFILLER_6_102 VPWR VGND sg13g2_decap_8
XFILLER_2_341 VPWR VGND sg13g2_decap_8
XFILLER_3_886 VPWR VGND sg13g2_decap_4
XFILLER_2_352 VPWR VGND sg13g2_fill_1
XFILLER_2_396 VPWR VGND sg13g2_decap_8
XFILLER_46_573 VPWR VGND sg13g2_fill_2
XFILLER_46_562 VPWR VGND sg13g2_fill_2
XFILLER_34_724 VPWR VGND sg13g2_fill_1
XFILLER_33_245 VPWR VGND sg13g2_fill_1
XFILLER_34_779 VPWR VGND sg13g2_decap_8
X_4750_ _1021_ _1729_ _1756_ _1757_ VPWR VGND sg13g2_nor3_2
XFILLER_42_790 VPWR VGND sg13g2_decap_4
XFILLER_21_429 VPWR VGND sg13g2_fill_2
X_3701_ videogen.test_lut_thingy.pixel_feeder_inst.row\[19\]\[2\] net862 _0871_ _0342_
+ VPWR VGND sg13g2_mux2_1
X_4681_ VPWR VGND _1686_ _1687_ _1677_ videogen.another_shader.time_cnt\[3\] _1688_
+ net716 sg13g2_a221oi_1
X_3632_ _0825_ _0854_ _0856_ VPWR VGND sg13g2_nor2_2
X_6420_ net73 VGND VPWR _0475_ videogen.test_lut_thingy.pixel_feeder_inst.row\[33\]\[2\]
+ _0071_ sg13g2_dfrbpq_1
X_6258__344 VPWR VGND net344 sg13g2_tiehi
X_6351_ net168 VGND VPWR _0410_ green\[0\] net734 sg13g2_dfrbpq_2
X_3563_ videogen.test_lut_thingy.pixel_feeder_inst.row\[2\]\[2\] net860 _0841_ _0560_
+ VPWR VGND sg13g2_mux2_1
X_5302_ VGND VPWR _2283_ _2290_ _2295_ _2288_ sg13g2_a21oi_1
X_6282_ net296 VGND VPWR _0341_ videogen.test_lut_thingy.pixel_feeder_inst.row\[19\]\[1\]
+ _0038_ sg13g2_dfrbpq_1
XFILLER_45_0 VPWR VGND sg13g2_decap_4
X_3494_ videogen.test_lut_thingy.pixel_feeder_inst.row\[42\]\[0\] net888 _0826_ _0614_
+ VPWR VGND sg13g2_mux2_1
X_5233_ _2232_ _2206_ _2231_ VPWR VGND sg13g2_xnor2_1
X_5164_ _2141_ _2143_ _2169_ VPWR VGND videogen.another_shader.time_cnt\[2\] sg13g2_nand3b_1
X_4115_ VGND VPWR net717 videogen.fancy_shader.shader_counter_reg\[2\] _1122_ _1121_
+ sg13g2_a21oi_1
X_5095_ _2102_ _2100_ _2101_ VPWR VGND sg13g2_nand2_1
XFILLER_37_540 VPWR VGND sg13g2_decap_4
XFILLER_17_38 VPWR VGND sg13g2_decap_8
X_4046_ videogen.fancy_shader.shader_counter_reg\[4\] _1073_ _1074_ VPWR VGND sg13g2_and2_1
XFILLER_37_584 VPWR VGND sg13g2_fill_1
XFILLER_37_573 VPWR VGND sg13g2_decap_8
X_6642__475 VPWR VGND net475 sg13g2_tiehi
XFILLER_13_908 VPWR VGND sg13g2_decap_8
XFILLER_24_223 VPWR VGND sg13g2_decap_8
XFILLER_40_727 VPWR VGND sg13g2_fill_1
X_5997_ net779 net825 _0058_ VPWR VGND sg13g2_nor2_1
X_4948_ _1934_ _1938_ _1954_ _1955_ VPWR VGND sg13g2_or3_1
X_4879_ _1876_ VPWR _1886_ VGND _1875_ _1885_ sg13g2_o21ai_1
XFILLER_20_451 VPWR VGND sg13g2_fill_1
X_6241__370 VPWR VGND net370 sg13g2_tiehi
X_6618_ net439 VGND VPWR _0673_ videogen.test_lut_thingy.pixel_feeder_inst.row\[35\]\[0\]
+ _0249_ sg13g2_dfrbpq_1
XFILLER_4_617 VPWR VGND sg13g2_fill_2
X_6549_ net52 VGND VPWR _0604_ videogen.test_lut_thingy.pixel_feeder_inst.row\[45\]\[2\]
+ _0191_ sg13g2_dfrbpq_1
XFILLER_3_138 VPWR VGND sg13g2_fill_2
XFILLER_0_823 VPWR VGND sg13g2_decap_8
XFILLER_47_359 VPWR VGND sg13g2_decap_8
XFILLER_28_551 VPWR VGND sg13g2_fill_2
XFILLER_28_562 VPWR VGND sg13g2_fill_2
XFILLER_15_223 VPWR VGND sg13g2_fill_2
XFILLER_16_746 VPWR VGND sg13g2_decap_4
XFILLER_15_267 VPWR VGND sg13g2_decap_8
XFILLER_31_705 VPWR VGND sg13g2_fill_1
XFILLER_43_598 VPWR VGND sg13g2_fill_1
XFILLER_7_433 VPWR VGND sg13g2_decap_8
XFILLER_7_411 VPWR VGND sg13g2_decap_8
XFILLER_23_81 VPWR VGND sg13g2_fill_2
XFILLER_8_978 VPWR VGND sg13g2_decap_8
XFILLER_7_466 VPWR VGND sg13g2_decap_4
X_6392__112 VPWR VGND net112 sg13g2_tiehi
XFILLER_48_1014 VPWR VGND sg13g2_decap_8
XFILLER_3_661 VPWR VGND sg13g2_decap_8
XFILLER_47_860 VPWR VGND sg13g2_decap_8
XFILLER_0_1005 VPWR VGND sg13g2_decap_8
XFILLER_19_573 VPWR VGND sg13g2_decap_4
X_5920_ _2852_ net748 net506 net753 green_tmds_par\[3\] VPWR VGND sg13g2_a22oi_1
XFILLER_0_63 VPWR VGND sg13g2_decap_8
XFILLER_34_554 VPWR VGND sg13g2_fill_1
X_5851_ VGND VPWR _2801_ _2807_ _2808_ _2751_ sg13g2_a21oi_1
X_4802_ _1800_ _1791_ _1808_ _1809_ VPWR VGND sg13g2_a21o_1
XFILLER_34_587 VPWR VGND sg13g2_fill_2
X_5782_ _2742_ _2734_ _2740_ VPWR VGND sg13g2_xnor2_1
X_4733_ _1738_ _1739_ _1740_ VPWR VGND sg13g2_and2_1
X_6225__398 VPWR VGND net398 sg13g2_tiehi
X_6403_ net215 VGND VPWR _0000_ videogen.mem_read net719 sg13g2_dfrbpq_1
X_4664_ _1671_ _0401_ _1670_ VPWR VGND sg13g2_nand2_2
X_4595_ net664 _1596_ _1601_ _1602_ VPWR VGND sg13g2_nor3_1
X_3615_ net882 videogen.test_lut_thingy.pixel_feeder_inst.row\[60\]\[0\] _0851_ _0509_
+ VPWR VGND sg13g2_mux2_1
X_6334_ net188 VGND VPWR _0393_ videogen.another_shader.video_y\[7\] net720 sg13g2_dfrbpq_2
X_3546_ _0803_ _0825_ _0838_ VPWR VGND sg13g2_nor2_2
X_6265_ net330 VGND VPWR _0324_ videogen.test_lut_thingy.pixel_feeder_inst.h_pix\[2\]
+ net722 sg13g2_dfrbpq_2
XFILLER_0_119 VPWR VGND sg13g2_decap_8
X_3477_ _0788_ _0796_ net666 _0821_ VPWR VGND sg13g2_nand3_1
X_5216_ _2215_ _2214_ _2205_ _2211_ _2209_ VPWR VGND sg13g2_a22oi_1
X_6196_ net789 net832 _0256_ VPWR VGND sg13g2_nor2_1
X_5147_ _2136_ _2139_ _2131_ _2154_ VPWR VGND sg13g2_nand3_1
X_5078_ VGND VPWR _2081_ _2084_ _2085_ _1697_ sg13g2_a21oi_1
X_4029_ VGND VPWR _0721_ _1059_ _0375_ _1061_ sg13g2_a21oi_1
XFILLER_13_716 VPWR VGND sg13g2_decap_4
XFILLER_25_565 VPWR VGND sg13g2_fill_2
X_6204__427 VPWR VGND net427 sg13g2_tiehi
XFILLER_20_281 VPWR VGND sg13g2_fill_2
X_6573__377 VPWR VGND net377 sg13g2_tiehi
XFILLER_5_959 VPWR VGND sg13g2_decap_8
XFILLER_4_447 VPWR VGND sg13g2_decap_8
Xheichips25_bagel_30 VPWR VGND uio_out[5] sg13g2_tielo
XFILLER_0_686 VPWR VGND sg13g2_decap_8
XFILLER_47_167 VPWR VGND sg13g2_fill_1
XFILLER_35_318 VPWR VGND sg13g2_fill_1
XFILLER_44_863 VPWR VGND sg13g2_decap_8
XFILLER_43_384 VPWR VGND sg13g2_decap_8
XFILLER_31_513 VPWR VGND sg13g2_decap_8
XFILLER_7_230 VPWR VGND sg13g2_fill_1
X_3400_ videogen.test_lut_thingy.pixel_feeder_inst.row\[21\]\[3\] net857 _0791_ _0684_
+ VPWR VGND sg13g2_mux2_1
XFILLER_7_285 VPWR VGND sg13g2_fill_2
X_4380_ videogen.test_lut_thingy.pixel_feeder_inst.row\[37\]\[2\] net626 _1387_ VPWR
+ VGND sg13g2_nor2_1
X_3331_ _0724_ videogen.another_shader.time_cnt\[28\] VPWR VGND sg13g2_inv_2
X_6050_ net762 net804 _0111_ VPWR VGND sg13g2_nor2_1
XFILLER_39_624 VPWR VGND sg13g2_fill_2
XFILLER_39_613 VPWR VGND sg13g2_decap_8
X_5001_ _2004_ _2007_ _2008_ VPWR VGND sg13g2_and2_1
XFILLER_38_156 VPWR VGND sg13g2_fill_1
X_5903_ VPWR _0689_ _2843_ VGND sg13g2_inv_1
XFILLER_35_863 VPWR VGND sg13g2_fill_2
X_5834_ _2792_ _2768_ _2790_ VPWR VGND sg13g2_nand2_1
X_6414__85 VPWR VGND net85 sg13g2_tiehi
X_5765_ _2725_ _2722_ _2723_ VPWR VGND sg13g2_xnor2_1
X_5696_ _2662_ _2651_ _2660_ VPWR VGND sg13g2_xnor2_1
X_4716_ net708 videogen.another_shader.time_cnt\[9\] _1723_ VPWR VGND sg13g2_xor2_1
X_4647_ _1650_ _1651_ _1652_ _1653_ _1654_ VPWR VGND sg13g2_nor4_1
X_4578_ net694 _1581_ _1582_ _1584_ _1585_ VPWR VGND sg13g2_nor4_1
X_6317_ net222 VGND VPWR _0376_ videogen.fancy_shader.shader_counter_reg\[0\] net718
+ sg13g2_dfrbpq_2
X_3529_ videogen.test_lut_thingy.pixel_feeder_inst.row\[4\]\[1\] net871 _0834_ _0587_
+ VPWR VGND sg13g2_mux2_1
XFILLER_1_428 VPWR VGND sg13g2_decap_8
X_6248_ net363 VGND VPWR _0307_ videogen.test_lut_thingy.pixel_feeder_inst.row\[29\]\[0\]
+ _0025_ sg13g2_dfrbpq_1
XFILLER_29_101 VPWR VGND sg13g2_fill_1
X_6179_ net767 net809 _0239_ VPWR VGND sg13g2_nor2_1
XFILLER_45_638 VPWR VGND sg13g2_decap_8
XFILLER_26_841 VPWR VGND sg13g2_fill_1
XFILLER_44_159 VPWR VGND sg13g2_fill_1
XFILLER_4_233 VPWR VGND sg13g2_decap_8
XFILLER_20_71 VPWR VGND sg13g2_fill_2
XFILLER_20_93 VPWR VGND sg13g2_decap_4
XFILLER_49_911 VPWR VGND sg13g2_decap_8
XFILLER_1_984 VPWR VGND sg13g2_decap_8
XFILLER_48_421 VPWR VGND sg13g2_decap_8
XFILLER_0_483 VPWR VGND sg13g2_decap_8
XFILLER_49_988 VPWR VGND sg13g2_decap_8
XFILLER_17_841 VPWR VGND sg13g2_decap_8
XFILLER_45_90 VPWR VGND sg13g2_fill_2
XFILLER_32_811 VPWR VGND sg13g2_decap_4
X_3880_ _0954_ VPWR _0961_ VGND videogen.test_lut_thingy.pixel_feeder_inst.v_pix\[3\]
+ _0958_ sg13g2_o21ai_1
XFILLER_32_877 VPWR VGND sg13g2_decap_4
X_6411__88 VPWR VGND net88 sg13g2_tiehi
XFILLER_31_387 VPWR VGND sg13g2_fill_1
X_5550_ _2492_ VPWR _2534_ VGND _2508_ _2533_ sg13g2_o21ai_1
X_5481_ _2467_ _2444_ _2457_ VPWR VGND sg13g2_xnor2_1
X_4501_ _1507_ VPWR _1508_ VGND _1472_ _1483_ sg13g2_o21ai_1
XFILLER_8_594 VPWR VGND sg13g2_decap_8
X_4432_ VGND VPWR _1439_ net636 videogen.test_lut_thingy.pixel_feeder_inst.row\[6\]\[1\]
+ sg13g2_or2_1
XFILLER_6_95 VPWR VGND sg13g2_fill_2
X_4363_ videogen.test_lut_thingy.pixel_feeder_inst.row\[48\]\[2\] net646 _1370_ VPWR
+ VGND sg13g2_nor2_1
X_6102_ net775 net818 _0162_ VPWR VGND sg13g2_nor2_1
X_4294_ _1301_ _1297_ _1300_ _1295_ _1290_ VPWR VGND sg13g2_a22oi_1
X_6033_ net758 net800 _0094_ VPWR VGND sg13g2_nor2_1
XFILLER_26_137 VPWR VGND sg13g2_decap_4
XFILLER_41_118 VPWR VGND sg13g2_fill_2
XFILLER_22_310 VPWR VGND sg13g2_fill_1
XFILLER_23_822 VPWR VGND sg13g2_fill_2
X_5817_ VGND VPWR _2776_ _2775_ _2770_ sg13g2_or2_1
X_5748_ VGND VPWR _2705_ _2707_ _2708_ _2706_ sg13g2_a21oi_1
X_5679_ VPWR _2646_ _2645_ VGND sg13g2_inv_1
XFILLER_9_6 VPWR VGND sg13g2_fill_1
XFILLER_2_726 VPWR VGND sg13g2_fill_1
XFILLER_1_247 VPWR VGND sg13g2_fill_2
XFILLER_49_218 VPWR VGND sg13g2_fill_2
XFILLER_46_925 VPWR VGND sg13g2_decap_8
XFILLER_18_638 VPWR VGND sg13g2_decap_4
XFILLER_18_649 VPWR VGND sg13g2_decap_4
XFILLER_14_833 VPWR VGND sg13g2_fill_1
XFILLER_41_652 VPWR VGND sg13g2_decap_4
XFILLER_41_630 VPWR VGND sg13g2_decap_8
XFILLER_14_844 VPWR VGND sg13g2_fill_1
XFILLER_14_855 VPWR VGND sg13g2_decap_8
XFILLER_9_314 VPWR VGND sg13g2_decap_8
XFILLER_14_888 VPWR VGND sg13g2_fill_2
XFILLER_12_1005 VPWR VGND sg13g2_decap_8
XFILLER_5_520 VPWR VGND sg13g2_fill_1
XFILLER_31_92 VPWR VGND sg13g2_decap_4
XFILLER_49_7 VPWR VGND sg13g2_decap_8
X_6512__253 VPWR VGND net253 sg13g2_tiehi
XFILLER_1_781 VPWR VGND sg13g2_decap_4
XFILLER_49_785 VPWR VGND sg13g2_decap_8
XFILLER_37_925 VPWR VGND sg13g2_decap_8
X_4981_ _1978_ _1985_ _1732_ _1988_ VPWR VGND sg13g2_nand3_1
XFILLER_23_107 VPWR VGND sg13g2_fill_1
X_3932_ VGND VPWR net681 _0992_ _0345_ _0994_ sg13g2_a21oi_1
X_6651_ net350 VGND VPWR _0706_ serialize.shift_reg_r\[5\] clknet_3_4__leaf_clk_regs
+ sg13g2_dfrbpq_1
X_3863_ net897 _0947_ _0315_ VPWR VGND sg13g2_and2_1
XFILLER_20_803 VPWR VGND sg13g2_fill_2
X_6582_ net279 VGND VPWR _0637_ videogen.test_lut_thingy.pixel_feeder_inst.row\[6\]\[3\]
+ _0224_ sg13g2_dfrbpq_1
X_5602_ _2578_ VPWR _2579_ VGND green\[3\] _2571_ sg13g2_o21ai_1
X_3794_ _0910_ _0917_ net18 VPWR VGND sg13g2_nor2b_1
X_5533_ _2518_ _2515_ _2517_ VPWR VGND sg13g2_nand2_1
X_5464_ _2450_ _2443_ _2449_ VPWR VGND sg13g2_nand2_1
X_4415_ _1421_ VPWR _1422_ VGND videogen.test_lut_thingy.pixel_feeder_inst.row\[17\]\[1\]
+ net623 sg13g2_o21ai_1
X_5395_ _2378_ VPWR _2388_ VGND _2383_ _2386_ sg13g2_o21ai_1
X_4346_ videogen.test_lut_thingy.pixel_feeder_inst.row\[9\]\[2\] net622 _1353_ VPWR
+ VGND sg13g2_nor2_1
X_4277_ _1270_ _1276_ _1284_ VPWR VGND sg13g2_nor2_1
XFILLER_39_251 VPWR VGND sg13g2_decap_8
X_6268__324 VPWR VGND net324 sg13g2_tiehi
X_6645__451 VPWR VGND net451 sg13g2_tiehi
X_6016_ net759 net801 _0077_ VPWR VGND sg13g2_nor2_1
XFILLER_27_402 VPWR VGND sg13g2_fill_1
XFILLER_27_468 VPWR VGND sg13g2_decap_8
XFILLER_36_980 VPWR VGND sg13g2_decap_8
XFILLER_2_523 VPWR VGND sg13g2_decap_8
Xfanout860 net864 net860 VPWR VGND sg13g2_buf_8
Xfanout893 net894 net893 VPWR VGND sg13g2_buf_1
Xfanout871 net875 net871 VPWR VGND sg13g2_buf_8
Xfanout882 net890 net882 VPWR VGND sg13g2_buf_8
XFILLER_46_744 VPWR VGND sg13g2_decap_4
XFILLER_45_243 VPWR VGND sg13g2_decap_8
XFILLER_46_799 VPWR VGND sg13g2_decap_8
XFILLER_18_479 VPWR VGND sg13g2_fill_1
XFILLER_26_70 VPWR VGND sg13g2_decap_8
XFILLER_42_994 VPWR VGND sg13g2_decap_8
XFILLER_13_184 VPWR VGND sg13g2_decap_4
XFILLER_13_195 VPWR VGND sg13g2_decap_8
XFILLER_5_394 VPWR VGND sg13g2_fill_2
X_4200_ _1200_ VPWR _1207_ VGND _1205_ _1206_ sg13g2_o21ai_1
X_5180_ VGND VPWR videogen.another_shader.time_cnt\[7\] _2145_ _2180_ _1314_ sg13g2_a21oi_1
X_4131_ VPWR _1138_ _1137_ VGND sg13g2_inv_1
X_4062_ net842 videogen.fancy_shader.shader_counter_reg\[9\] _1063_ _1082_ _1085_
+ VPWR VGND sg13g2_or4_1
X_6605__66 VPWR VGND net66 sg13g2_tiehi
XFILLER_36_265 VPWR VGND sg13g2_fill_1
X_4964_ _1971_ _1969_ _1970_ VPWR VGND sg13g2_xnor2_1
XFILLER_40_909 VPWR VGND sg13g2_decap_8
X_3915_ _0983_ videogen.test_lut_thingy.pixel_feeder_inst.v_counter\[2\] _0985_ VPWR
+ VGND sg13g2_xor2_1
X_4895_ _1902_ _1884_ _1886_ _1893_ VPWR VGND sg13g2_and3_1
XFILLER_20_633 VPWR VGND sg13g2_fill_2
X_3846_ red_tmds_par\[9\] net751 _0279_ VPWR VGND sg13g2_and2_1
X_6634_ net139 VGND VPWR _0689_ serialize.shift_reg_b\[4\] clknet_3_1__leaf_clk_regs
+ sg13g2_dfrbpq_1
X_3777_ _0783_ net619 _0903_ VPWR VGND sg13g2_nor2b_1
X_6565_ net445 VGND VPWR _0620_ videogen.test_lut_thingy.pixel_feeder_inst.row\[41\]\[2\]
+ _0207_ sg13g2_dfrbpq_1
XFILLER_3_309 VPWR VGND sg13g2_decap_8
X_5516_ _2501_ _2485_ tmds_red.dc_balancing_reg\[2\] VPWR VGND sg13g2_nand2b_1
X_6496_ net303 VGND VPWR _0551_ green_tmds_par\[6\] net738 sg13g2_dfrbpq_1
X_5447_ _2436_ _2432_ _2435_ _2272_ _1666_ VPWR VGND sg13g2_a22oi_1
X_5378_ _2351_ _2369_ _2371_ VPWR VGND sg13g2_nor2_1
X_4329_ _1335_ VPWR _1336_ VGND videogen.test_lut_thingy.pixel_feeder_inst.row\[28\]\[2\]
+ net649 sg13g2_o21ai_1
XFILLER_47_14 VPWR VGND sg13g2_decap_8
XFILLER_28_700 VPWR VGND sg13g2_fill_1
XFILLER_28_755 VPWR VGND sg13g2_fill_1
XFILLER_15_449 VPWR VGND sg13g2_fill_1
XFILLER_27_298 VPWR VGND sg13g2_decap_8
XFILLER_31_909 VPWR VGND sg13g2_fill_1
XFILLER_42_279 VPWR VGND sg13g2_fill_2
XFILLER_7_615 VPWR VGND sg13g2_decap_8
XFILLER_6_158 VPWR VGND sg13g2_decap_8
XFILLER_12_72 VPWR VGND sg13g2_decap_8
XFILLER_2_375 VPWR VGND sg13g2_fill_1
Xfanout690 net695 net690 VPWR VGND sg13g2_buf_8
XFILLER_18_210 VPWR VGND sg13g2_fill_2
XFILLER_46_541 VPWR VGND sg13g2_decap_8
XFILLER_19_799 VPWR VGND sg13g2_fill_2
XFILLER_33_257 VPWR VGND sg13g2_decap_8
X_3700_ videogen.test_lut_thingy.pixel_feeder_inst.row\[19\]\[3\] net851 _0871_ _0343_
+ VPWR VGND sg13g2_mux2_1
X_4680_ _1687_ videogen.another_shader.time_cnt\[2\] net717 _1681_ VPWR VGND sg13g2_and3_1
X_3631_ videogen.test_lut_thingy.pixel_feeder_inst.row\[8\]\[0\] net881 _0855_ _0497_
+ VPWR VGND sg13g2_mux2_1
X_3562_ videogen.test_lut_thingy.pixel_feeder_inst.row\[2\]\[3\] net849 _0841_ _0561_
+ VPWR VGND sg13g2_mux2_1
X_6350_ net169 VGND VPWR _0409_ blue\[7\] net741 sg13g2_dfrbpq_2
X_5301_ _2292_ _2293_ _2294_ VPWR VGND sg13g2_nor2_1
X_6281_ net298 VGND VPWR _0340_ videogen.test_lut_thingy.pixel_feeder_inst.row\[19\]\[0\]
+ _0037_ sg13g2_dfrbpq_1
X_3493_ videogen.test_lut_thingy.pixel_feeder_inst.row\[42\]\[1\] net879 _0826_ _0615_
+ VPWR VGND sg13g2_mux2_1
X_6451__468 VPWR VGND net468 sg13g2_tiehi
X_5232_ _2213_ _2230_ _2231_ VPWR VGND sg13g2_nor2_1
X_5163_ _2168_ _1569_ _0403_ VPWR VGND _2167_ sg13g2_nand3b_1
XFILLER_38_0 VPWR VGND sg13g2_decap_8
X_4114_ _1119_ _1120_ _1121_ VPWR VGND sg13g2_and2_1
X_5094_ _2101_ videogen.another_shader.video_y\[2\] _2099_ VPWR VGND sg13g2_nand2_1
X_4045_ _1067_ _1071_ _1073_ _0379_ VPWR VGND sg13g2_nor3_1
X_5996_ net782 net825 _0057_ VPWR VGND sg13g2_nor2_1
XFILLER_12_408 VPWR VGND sg13g2_decap_4
X_4947_ VPWR VGND _1948_ _1940_ _1946_ _1738_ _1954_ _1739_ sg13g2_a221oi_1
XFILLER_33_38 VPWR VGND sg13g2_fill_2
XFILLER_33_780 VPWR VGND sg13g2_decap_8
X_4878_ _1871_ _1879_ _1885_ VPWR VGND sg13g2_and2_1
XFILLER_32_1019 VPWR VGND sg13g2_decap_4
X_6617_ net447 VGND VPWR _0672_ videogen.test_lut_thingy.pixel_feeder_inst.row\[23\]\[3\]
+ _0248_ sg13g2_dfrbpq_1
X_3829_ net715 _0889_ _0934_ VPWR VGND sg13g2_nor2_1
X_6548_ net56 VGND VPWR _0603_ videogen.test_lut_thingy.pixel_feeder_inst.row\[45\]\[1\]
+ _0190_ sg13g2_dfrbpq_1
X_6479_ net375 VGND VPWR _0534_ videogen.test_lut_thingy.pixel_feeder_inst.row\[55\]\[1\]
+ _0130_ sg13g2_dfrbpq_1
XFILLER_0_802 VPWR VGND sg13g2_decap_8
XFILLER_0_879 VPWR VGND sg13g2_decap_8
XFILLER_48_839 VPWR VGND sg13g2_decap_8
XFILLER_15_202 VPWR VGND sg13g2_decap_4
XFILLER_30_216 VPWR VGND sg13g2_fill_2
XFILLER_3_640 VPWR VGND sg13g2_decap_8
XFILLER_2_161 VPWR VGND sg13g2_decap_4
XFILLER_0_42 VPWR VGND sg13g2_decap_8
X_6426__61 VPWR VGND net61 sg13g2_tiehi
XFILLER_0_1028 VPWR VGND sg13g2_fill_1
X_6441__31 VPWR VGND net31 sg13g2_tiehi
XFILLER_19_585 VPWR VGND sg13g2_fill_1
X_5850_ _2807_ _2804_ _2806_ VPWR VGND sg13g2_xnor2_1
X_4801_ VGND VPWR _1762_ _1800_ _1808_ _1789_ sg13g2_a21oi_1
X_5781_ _2734_ _2740_ _2741_ VPWR VGND sg13g2_nor2b_2
X_4732_ _1739_ _1733_ videogen.another_shader.time_cnt\[15\] VPWR VGND sg13g2_nand2b_1
X_4663_ net2 net1 _1670_ VPWR VGND sg13g2_and2_1
X_6402_ net234 VGND VPWR _0003_ videogen.test_lut_thingy.pixel_feeder_inst.state\[1\]
+ net718 sg13g2_dfrbpq_1
X_3614_ net871 videogen.test_lut_thingy.pixel_feeder_inst.row\[60\]\[1\] _0851_ _0510_
+ VPWR VGND sg13g2_mux2_1
X_4594_ _1597_ _1598_ _1599_ _1600_ _1601_ VPWR VGND sg13g2_nor4_1
X_3545_ videogen.test_lut_thingy.pixel_feeder_inst.row\[25\]\[0\] net884 _0837_ _0574_
+ VPWR VGND sg13g2_mux2_1
X_6333_ net190 VGND VPWR _0392_ videogen.another_shader.video_y\[6\] net721 sg13g2_dfrbpq_2
X_6264_ net332 VGND VPWR _0323_ videogen.test_lut_thingy.pixel_feeder_inst.h_pix\[1\]
+ net722 sg13g2_dfrbpq_1
X_3476_ videogen.test_lut_thingy.pixel_feeder_inst.row\[3\]\[0\] net881 _0820_ _0626_
+ VPWR VGND sg13g2_mux2_1
X_5215_ _2214_ _2213_ _2206_ VPWR VGND sg13g2_nand2b_1
X_6631__199 VPWR VGND net199 sg13g2_tiehi
X_6195_ net790 net833 _0255_ VPWR VGND sg13g2_nor2_1
X_6486__339 VPWR VGND net339 sg13g2_tiehi
X_5146_ _2152_ _2151_ _2150_ _2153_ VPWR VGND sg13g2_a21o_1
X_5077_ VGND VPWR _2069_ _2071_ _2084_ _2082_ sg13g2_a21oi_1
X_4028_ net899 VPWR _1061_ VGND _0721_ _1059_ sg13g2_o21ai_1
XFILLER_13_706 VPWR VGND sg13g2_fill_1
X_5979_ net768 net810 _0040_ VPWR VGND sg13g2_nor2_1
XFILLER_12_205 VPWR VGND sg13g2_fill_2
XFILLER_12_216 VPWR VGND sg13g2_fill_2
XFILLER_40_547 VPWR VGND sg13g2_fill_1
XFILLER_21_772 VPWR VGND sg13g2_decap_4
XFILLER_5_938 VPWR VGND sg13g2_decap_8
XFILLER_0_665 VPWR VGND sg13g2_decap_8
XFILLER_29_861 VPWR VGND sg13g2_fill_1
XFILLER_44_842 VPWR VGND sg13g2_decap_8
XFILLER_16_522 VPWR VGND sg13g2_fill_2
XFILLER_43_352 VPWR VGND sg13g2_fill_1
XFILLER_31_503 VPWR VGND sg13g2_decap_4
XFILLER_8_732 VPWR VGND sg13g2_fill_1
XFILLER_8_721 VPWR VGND sg13g2_decap_8
XFILLER_15_1025 VPWR VGND sg13g2_decap_4
XFILLER_11_271 VPWR VGND sg13g2_decap_8
XFILLER_7_275 VPWR VGND sg13g2_fill_1
XFILLER_7_253 VPWR VGND sg13g2_fill_2
X_3330_ VPWR _0723_ videogen.another_shader.time_cnt\[29\] VGND sg13g2_inv_1
XFILLER_4_982 VPWR VGND sg13g2_decap_8
X_5000_ _1990_ _2000_ _1729_ _2007_ VPWR VGND _2002_ sg13g2_nand4_1
X_6329__198 VPWR VGND net198 sg13g2_tiehi
X_5902_ _2843_ net747 net508 net754 blue_tmds_par\[4\] VPWR VGND sg13g2_a22oi_1
XFILLER_35_853 VPWR VGND sg13g2_fill_2
X_5833_ _2791_ _2783_ _2790_ VPWR VGND sg13g2_xnor2_1
X_5764_ _2722_ _2723_ _2724_ VPWR VGND sg13g2_nor2b_1
X_5695_ _2661_ _2651_ _2660_ VPWR VGND sg13g2_nand2_1
XFILLER_30_591 VPWR VGND sg13g2_decap_8
X_4715_ videogen.another_shader.time_cnt\[9\] net708 _1722_ VPWR VGND sg13g2_nor2_1
X_4646_ videogen.test_lut_thingy.pixel_feeder_inst.row\[43\]\[0\] net660 _1653_ VPWR
+ VGND sg13g2_nor2_1
X_4577_ _1583_ VPWR _1584_ VGND videogen.test_lut_thingy.pixel_feeder_inst.row\[23\]\[0\]
+ net660 sg13g2_o21ai_1
X_6316_ net224 VGND VPWR _0375_ videogen.another_shader.time_cnt\[31\] net742 sg13g2_dfrbpq_1
XFILLER_1_407 VPWR VGND sg13g2_decap_8
X_3528_ videogen.test_lut_thingy.pixel_feeder_inst.row\[4\]\[2\] net861 _0834_ _0588_
+ VPWR VGND sg13g2_mux2_1
X_3459_ videogen.test_lut_thingy.pixel_feeder_inst.row\[7\]\[1\] net871 _0816_ _0639_
+ VPWR VGND sg13g2_mux2_1
X_6247_ net364 VGND VPWR _0306_ serialize.shift_reg_c\[4\] clknet_3_0__leaf_clk_regs
+ sg13g2_dfrbpq_1
X_6178_ net766 net808 _0238_ VPWR VGND sg13g2_nor2_1
X_5129_ _2133_ _2127_ _2135_ _2136_ VPWR VGND sg13g2_a21o_1
XFILLER_38_680 VPWR VGND sg13g2_fill_1
XFILLER_38_1014 VPWR VGND sg13g2_decap_8
XFILLER_41_889 VPWR VGND sg13g2_decap_8
XFILLER_9_529 VPWR VGND sg13g2_fill_1
X_6278__304 VPWR VGND net304 sg13g2_tiehi
XFILLER_1_963 VPWR VGND sg13g2_decap_8
XFILLER_48_400 VPWR VGND sg13g2_decap_8
XFILLER_0_462 VPWR VGND sg13g2_decap_8
XFILLER_49_967 VPWR VGND sg13g2_decap_8
XFILLER_29_81 VPWR VGND sg13g2_fill_2
X_5480_ red\[4\] red\[7\] _2466_ VPWR VGND sg13g2_xor2_1
X_4500_ _1506_ net682 _1507_ VPWR VGND sg13g2_nor2b_1
X_4431_ videogen.test_lut_thingy.pixel_feeder_inst.row\[4\]\[1\] net644 _1438_ VPWR
+ VGND sg13g2_nor2_1
XFILLER_6_52 VPWR VGND sg13g2_decap_4
XFILLER_6_41 VPWR VGND sg13g2_fill_1
X_4362_ videogen.test_lut_thingy.pixel_feeder_inst.row\[51\]\[2\] net655 _1369_ VPWR
+ VGND sg13g2_nor2_1
X_6101_ net776 net817 _0161_ VPWR VGND sg13g2_nor2_1
X_4293_ _1287_ _1281_ _1300_ VPWR VGND sg13g2_xor2_1
XFILLER_39_400 VPWR VGND sg13g2_decap_4
X_6032_ net759 net801 _0093_ VPWR VGND sg13g2_nor2_1
XFILLER_39_444 VPWR VGND sg13g2_fill_1
X_5816_ _2774_ _2733_ _2775_ VPWR VGND sg13g2_xor2_1
X_5747_ _2707_ blue\[7\] _2700_ VPWR VGND sg13g2_xnor2_1
X_5678_ _2626_ _2642_ _2645_ VPWR VGND sg13g2_nor2b_2
XFILLER_2_705 VPWR VGND sg13g2_decap_8
X_4629_ _1635_ VPWR _1636_ VGND videogen.test_lut_thingy.pixel_feeder_inst.row\[61\]\[0\]
+ net626 sg13g2_o21ai_1
X_6238__376 VPWR VGND net376 sg13g2_tiehi
XFILLER_1_226 VPWR VGND sg13g2_decap_8
XFILLER_46_904 VPWR VGND sg13g2_decap_8
XFILLER_18_617 VPWR VGND sg13g2_decap_8
XFILLER_13_333 VPWR VGND sg13g2_fill_2
XFILLER_14_867 VPWR VGND sg13g2_fill_2
XFILLER_41_686 VPWR VGND sg13g2_fill_2
XFILLER_41_675 VPWR VGND sg13g2_decap_8
XFILLER_13_377 VPWR VGND sg13g2_fill_2
XFILLER_41_697 VPWR VGND sg13g2_fill_1
XFILLER_9_326 VPWR VGND sg13g2_fill_2
X_6547__60 VPWR VGND net60 sg13g2_tiehi
XFILLER_5_532 VPWR VGND sg13g2_decap_8
XFILLER_12_1028 VPWR VGND sg13g2_fill_1
XFILLER_5_587 VPWR VGND sg13g2_fill_2
Xoutput3 net3 tmds_b VPWR VGND sg13g2_buf_1
X_6389__118 VPWR VGND net118 sg13g2_tiehi
XFILLER_49_720 VPWR VGND sg13g2_decap_4
XFILLER_49_764 VPWR VGND sg13g2_decap_8
XFILLER_37_904 VPWR VGND sg13g2_decap_8
XFILLER_36_436 VPWR VGND sg13g2_decap_8
XFILLER_36_447 VPWR VGND sg13g2_fill_2
XFILLER_45_981 VPWR VGND sg13g2_decap_8
X_4980_ _1986_ _1978_ _1732_ _1987_ VPWR VGND sg13g2_a21o_2
X_3931_ net897 VPWR _0994_ VGND net681 _0992_ sg13g2_o21ai_1
X_3862_ _0759_ _0905_ _0758_ _0947_ VPWR VGND _0946_ sg13g2_nand4_1
X_6650_ net373 VGND VPWR _0705_ serialize.shift_reg_r\[4\] clknet_3_5__leaf_clk_regs
+ sg13g2_dfrbpq_1
XFILLER_31_141 VPWR VGND sg13g2_fill_2
X_6581_ net287 VGND VPWR _0636_ videogen.test_lut_thingy.pixel_feeder_inst.row\[6\]\[2\]
+ _0223_ sg13g2_dfrbpq_1
X_5601_ _2573_ VPWR _2578_ VGND _2576_ _2577_ sg13g2_o21ai_1
X_5532_ _2517_ _2457_ _2472_ VPWR VGND sg13g2_nand2_1
X_3793_ _0909_ VPWR _0917_ VGND _0915_ _0916_ sg13g2_o21ai_1
XFILLER_31_196 VPWR VGND sg13g2_decap_8
XFILLER_9_882 VPWR VGND sg13g2_decap_8
X_5463_ _2449_ red\[6\] red\[4\] VPWR VGND sg13g2_nand2_1
X_4414_ _1421_ net661 videogen.test_lut_thingy.pixel_feeder_inst.row\[19\]\[1\] VPWR
+ VGND sg13g2_nand2b_1
X_5394_ _2384_ _2386_ _2387_ VPWR VGND sg13g2_nor2b_1
X_4345_ videogen.test_lut_thingy.pixel_feeder_inst.row\[8\]\[2\] net645 _1352_ VPWR
+ VGND sg13g2_nor2_1
XFILLER_28_1013 VPWR VGND sg13g2_decap_8
X_4276_ VPWR _1283_ _1282_ VGND sg13g2_inv_1
X_6015_ net791 net834 _0076_ VPWR VGND sg13g2_nor2_1
XFILLER_36_16 VPWR VGND sg13g2_fill_1
X_6461__448 VPWR VGND net448 sg13g2_tiehi
XFILLER_35_1028 VPWR VGND sg13g2_fill_1
XFILLER_11_848 VPWR VGND sg13g2_fill_1
XFILLER_22_185 VPWR VGND sg13g2_decap_4
XFILLER_2_579 VPWR VGND sg13g2_decap_8
Xfanout850 net859 net850 VPWR VGND sg13g2_buf_8
Xfanout861 net864 net861 VPWR VGND sg13g2_buf_8
Xfanout894 net896 net894 VPWR VGND sg13g2_buf_8
Xfanout872 net874 net872 VPWR VGND sg13g2_buf_8
Xfanout883 net885 net883 VPWR VGND sg13g2_buf_8
XFILLER_33_406 VPWR VGND sg13g2_decap_4
XFILLER_42_973 VPWR VGND sg13g2_decap_8
XFILLER_13_130 VPWR VGND sg13g2_decap_8
XFILLER_14_697 VPWR VGND sg13g2_decap_4
XFILLER_42_92 VPWR VGND sg13g2_decap_4
XFILLER_6_874 VPWR VGND sg13g2_decap_8
XFILLER_5_351 VPWR VGND sg13g2_fill_1
X_4130_ _1137_ _1125_ _1136_ VPWR VGND sg13g2_xnor2_1
X_4061_ VGND VPWR _0749_ _1084_ _0384_ _1083_ sg13g2_a21oi_1
XFILLER_49_583 VPWR VGND sg13g2_decap_8
XFILLER_3_1015 VPWR VGND sg13g2_decap_8
X_4963_ _1949_ _1940_ _1970_ VPWR VGND sg13g2_xor2_1
X_3914_ videogen.test_lut_thingy.pixel_feeder_inst.v_counter\[1\] videogen.test_lut_thingy.pixel_feeder_inst.v_counter\[0\]
+ videogen.test_lut_thingy.pixel_feeder_inst.v_counter\[2\] _0984_ VPWR VGND _0949_
+ sg13g2_nand4_1
X_4894_ _1899_ _1900_ _1898_ _1901_ VPWR VGND sg13g2_nand3_1
X_6304__252 VPWR VGND net252 sg13g2_tiehi
X_6633_ net183 VGND VPWR _0688_ serialize.shift_reg_b\[3\] clknet_3_1__leaf_clk_regs
+ sg13g2_dfrbpq_1
XFILLER_33_984 VPWR VGND sg13g2_fill_1
X_3845_ red_tmds_par\[8\] net751 _0278_ VPWR VGND sg13g2_and2_1
XFILLER_20_656 VPWR VGND sg13g2_decap_8
X_3776_ VGND VPWR _0743_ net15 _0784_ net620 sg13g2_a21oi_2
X_6564_ net449 VGND VPWR _0619_ videogen.test_lut_thingy.pixel_feeder_inst.row\[41\]\[1\]
+ _0206_ sg13g2_dfrbpq_1
X_5515_ _2500_ tmds_red.dc_balancing_reg\[2\] _2485_ VPWR VGND sg13g2_nand2_1
X_6495_ net305 VGND VPWR _0550_ green_tmds_par\[4\] net738 sg13g2_dfrbpq_1
X_5446_ _2178_ _2181_ _1413_ _2435_ VPWR VGND sg13g2_nand3_1
X_5377_ _2355_ _2361_ _2370_ VPWR VGND sg13g2_nor2b_2
X_4328_ VGND VPWR _0715_ net662 _1335_ _1334_ sg13g2_a21oi_1
X_4259_ _1202_ _1258_ _1266_ VPWR VGND sg13g2_nor2_1
XFILLER_42_214 VPWR VGND sg13g2_decap_4
XFILLER_10_155 VPWR VGND sg13g2_decap_4
XFILLER_10_188 VPWR VGND sg13g2_fill_2
XFILLER_12_40 VPWR VGND sg13g2_decap_8
XFILLER_12_51 VPWR VGND sg13g2_fill_2
XFILLER_3_844 VPWR VGND sg13g2_fill_2
XFILLER_2_365 VPWR VGND sg13g2_fill_2
Xfanout680 videogen.another_shader.time_cnt\[16\] net680 VPWR VGND sg13g2_buf_8
Xfanout691 net692 net691 VPWR VGND sg13g2_buf_8
XFILLER_18_233 VPWR VGND sg13g2_fill_2
XFILLER_46_586 VPWR VGND sg13g2_fill_1
XFILLER_46_564 VPWR VGND sg13g2_fill_1
X_6286__288 VPWR VGND net288 sg13g2_tiehi
XFILLER_34_704 VPWR VGND sg13g2_decap_8
XFILLER_34_715 VPWR VGND sg13g2_fill_2
X_6599__99 VPWR VGND net99 sg13g2_tiehi
XFILLER_30_943 VPWR VGND sg13g2_fill_2
X_3630_ videogen.test_lut_thingy.pixel_feeder_inst.row\[8\]\[1\] net870 _0855_ _0498_
+ VPWR VGND sg13g2_mux2_1
X_3561_ _0815_ _0825_ _0841_ VPWR VGND sg13g2_nor2_2
X_5300_ _2290_ VPWR _2293_ VGND _2284_ _2288_ sg13g2_o21ai_1
X_6280_ net300 VGND VPWR _0339_ videogen.test_lut_thingy.pixel_feeder_inst.row\[37\]\[3\]
+ _0036_ sg13g2_dfrbpq_1
X_3492_ videogen.test_lut_thingy.pixel_feeder_inst.row\[42\]\[2\] net868 _0826_ _0616_
+ VPWR VGND sg13g2_mux2_1
X_5231_ _2216_ _2226_ _2230_ VPWR VGND sg13g2_nor2_1
X_5162_ _1670_ _2153_ _0401_ _2168_ VPWR VGND _2160_ sg13g2_nand4_1
X_5093_ _2100_ _2098_ videogen.another_shader.video_y\[2\] VPWR VGND sg13g2_nand2b_1
X_4113_ videogen.fancy_shader.shader_counter_reg\[2\] net717 _1120_ VPWR VGND sg13g2_xor2_1
X_4044_ _1064_ _1072_ _1073_ VPWR VGND sg13g2_and2_1
XFILLER_25_715 VPWR VGND sg13g2_decap_8
X_5995_ net760 net802 _0056_ VPWR VGND sg13g2_nor2_1
X_4946_ _1736_ _1940_ _1949_ _1950_ _1953_ VPWR VGND sg13g2_nor4_1
X_4877_ VPWR _1884_ _1883_ VGND sg13g2_inv_1
XFILLER_21_943 VPWR VGND sg13g2_fill_1
X_6616_ net455 VGND VPWR _0671_ videogen.test_lut_thingy.pixel_feeder_inst.row\[23\]\[2\]
+ _0247_ sg13g2_dfrbpq_1
X_3828_ _0889_ _0933_ _0271_ VPWR VGND sg13g2_nor2_1
XFILLER_20_497 VPWR VGND sg13g2_decap_4
X_6547_ net60 VGND VPWR _0602_ videogen.test_lut_thingy.pixel_feeder_inst.row\[45\]\[0\]
+ _0189_ sg13g2_dfrbpq_1
X_3759_ _0895_ _0894_ videogen.test_lut_thingy.pixel_feeder_inst.state\[0\] VPWR VGND
+ sg13g2_nand2b_1
XFILLER_4_619 VPWR VGND sg13g2_fill_1
X_6478_ net379 VGND VPWR _0533_ videogen.test_lut_thingy.pixel_feeder_inst.row\[55\]\[0\]
+ _0129_ sg13g2_dfrbpq_1
X_5429_ VGND VPWR _2342_ _2420_ _2422_ _2421_ sg13g2_a21oi_1
XFILLER_48_818 VPWR VGND sg13g2_decap_8
XFILLER_0_858 VPWR VGND sg13g2_decap_8
XFILLER_28_542 VPWR VGND sg13g2_fill_1
XFILLER_28_553 VPWR VGND sg13g2_fill_1
XFILLER_28_564 VPWR VGND sg13g2_fill_1
XFILLER_15_225 VPWR VGND sg13g2_fill_1
XFILLER_12_921 VPWR VGND sg13g2_fill_2
XFILLER_7_402 VPWR VGND sg13g2_decap_4
XFILLER_12_998 VPWR VGND sg13g2_decap_8
XFILLER_3_696 VPWR VGND sg13g2_decap_8
XFILLER_2_184 VPWR VGND sg13g2_fill_1
XFILLER_38_317 VPWR VGND sg13g2_fill_1
XFILLER_38_339 VPWR VGND sg13g2_decap_4
XFILLER_0_21 VPWR VGND sg13g2_decap_8
XFILLER_47_895 VPWR VGND sg13g2_decap_8
XFILLER_46_394 VPWR VGND sg13g2_fill_2
XFILLER_46_383 VPWR VGND sg13g2_decap_8
X_4800_ _1790_ _1806_ _1807_ VPWR VGND sg13g2_nor2_1
XFILLER_0_98 VPWR VGND sg13g2_decap_8
XFILLER_22_718 VPWR VGND sg13g2_decap_8
XFILLER_34_545 VPWR VGND sg13g2_decap_8
X_5780_ _2738_ _2735_ _2740_ VPWR VGND sg13g2_xor2_1
X_4731_ VPWR _1738_ _1737_ VGND sg13g2_inv_1
XFILLER_15_792 VPWR VGND sg13g2_decap_8
XFILLER_30_740 VPWR VGND sg13g2_decap_4
XFILLER_9_85 VPWR VGND sg13g2_decap_8
X_4662_ VGND VPWR _1569_ _1669_ _1668_ _1413_ sg13g2_a21oi_2
XFILLER_30_751 VPWR VGND sg13g2_fill_1
X_6401_ net233 VGND VPWR _0002_ videogen.test_lut_thingy.pixel_feeder_inst.state\[0\]
+ net719 sg13g2_dfrbpq_1
X_3613_ net861 videogen.test_lut_thingy.pixel_feeder_inst.row\[60\]\[2\] _0851_ _0511_
+ VPWR VGND sg13g2_mux2_1
X_4593_ videogen.test_lut_thingy.pixel_feeder_inst.row\[13\]\[0\] net626 _1600_ VPWR
+ VGND sg13g2_nor2_1
X_3544_ videogen.test_lut_thingy.pixel_feeder_inst.row\[25\]\[1\] net874 _0837_ _0575_
+ VPWR VGND sg13g2_mux2_1
X_6332_ net192 VGND VPWR _0391_ videogen.another_shader.video_y\[5\] net721 sg13g2_dfrbpq_2
X_3475_ videogen.test_lut_thingy.pixel_feeder_inst.row\[3\]\[1\] net870 _0820_ _0627_
+ VPWR VGND sg13g2_mux2_1
X_6263_ net334 VGND VPWR _0322_ videogen.test_lut_thingy.pixel_feeder_inst.h_pix\[0\]
+ net722 sg13g2_dfrbpq_1
X_5214_ _2207_ _2212_ _2213_ VPWR VGND sg13g2_nor2_1
X_6194_ net790 net833 _0254_ VPWR VGND sg13g2_nor2_1
X_5145_ _2140_ _2129_ _2142_ _2152_ VPWR VGND sg13g2_a21o_1
X_5076_ _2071_ _2069_ _2082_ _2083_ VPWR VGND sg13g2_a21o_1
XFILLER_44_309 VPWR VGND sg13g2_fill_2
X_4027_ VGND VPWR _0722_ _1057_ _0374_ _1060_ sg13g2_a21oi_1
XFILLER_44_49 VPWR VGND sg13g2_fill_2
XFILLER_25_545 VPWR VGND sg13g2_fill_2
X_5978_ net770 net813 _0039_ VPWR VGND sg13g2_nor2_1
X_4929_ _1741_ _1912_ _1936_ VPWR VGND sg13g2_nor2_1
XFILLER_5_917 VPWR VGND sg13g2_fill_2
Xheichips25_bagel_21 VPWR VGND uio_oe[0] sg13g2_tielo
XFILLER_0_644 VPWR VGND sg13g2_decap_8
XFILLER_44_821 VPWR VGND sg13g2_decap_8
XFILLER_16_567 VPWR VGND sg13g2_fill_1
XFILLER_44_898 VPWR VGND sg13g2_decap_8
XFILLER_15_1004 VPWR VGND sg13g2_decap_8
X_6515__241 VPWR VGND net241 sg13g2_tiehi
X_6255__349 VPWR VGND net349 sg13g2_tiehi
XFILLER_4_961 VPWR VGND sg13g2_decap_8
XFILLER_22_4 VPWR VGND sg13g2_decap_4
XFILLER_39_637 VPWR VGND sg13g2_fill_2
XFILLER_38_114 VPWR VGND sg13g2_fill_1
XFILLER_19_350 VPWR VGND sg13g2_decap_4
XFILLER_38_147 VPWR VGND sg13g2_decap_8
XFILLER_47_692 VPWR VGND sg13g2_fill_2
XFILLER_47_681 VPWR VGND sg13g2_fill_1
X_5901_ VPWR _0688_ _2842_ VGND sg13g2_inv_1
XFILLER_46_180 VPWR VGND sg13g2_decap_4
XFILLER_34_320 VPWR VGND sg13g2_fill_1
X_5832_ _2788_ _2786_ _2790_ VPWR VGND sg13g2_xor2_1
XFILLER_22_526 VPWR VGND sg13g2_fill_2
X_5763_ _2723_ _2712_ net614 VPWR VGND sg13g2_xnor2_1
X_4714_ VGND VPWR _1719_ _1720_ _1721_ _1714_ sg13g2_a21oi_1
X_5694_ _2630_ VPWR _2660_ VGND _2596_ _2600_ sg13g2_o21ai_1
X_6375__142 VPWR VGND net142 sg13g2_tiehi
X_4645_ videogen.test_lut_thingy.pixel_feeder_inst.row\[40\]\[0\] net650 _1652_ VPWR
+ VGND sg13g2_nor2_1
X_4576_ VGND VPWR _1583_ net640 videogen.test_lut_thingy.pixel_feeder_inst.row\[22\]\[0\]
+ sg13g2_or2_1
X_6315_ net226 VGND VPWR _0374_ videogen.another_shader.time_cnt\[30\] net729 sg13g2_dfrbpq_1
X_3527_ videogen.test_lut_thingy.pixel_feeder_inst.row\[4\]\[3\] net850 _0834_ _0589_
+ VPWR VGND sg13g2_mux2_1
XFILLER_2_909 VPWR VGND sg13g2_decap_8
XFILLER_39_38 VPWR VGND sg13g2_fill_1
X_3458_ videogen.test_lut_thingy.pixel_feeder_inst.row\[7\]\[2\] net861 _0816_ _0640_
+ VPWR VGND sg13g2_mux2_1
X_6246_ net365 VGND VPWR net496 serialize.shift_reg_c\[3\] clknet_3_0__leaf_clk_regs
+ sg13g2_dfrbpq_1
X_3389_ net685 _0780_ _0781_ VPWR VGND sg13g2_nor2b_1
X_6177_ net767 net809 _0237_ VPWR VGND sg13g2_nor2_1
X_5128_ VPWR VGND _2117_ _2118_ _2134_ _2123_ _2135_ _2126_ sg13g2_a221oi_1
XFILLER_29_136 VPWR VGND sg13g2_decap_4
X_5059_ _2052_ _2060_ _2066_ VPWR VGND _2050_ sg13g2_nand3b_1
X_6527__189 VPWR VGND net189 sg13g2_tiehi
XFILLER_13_526 VPWR VGND sg13g2_decap_8
XFILLER_41_857 VPWR VGND sg13g2_fill_2
XFILLER_25_397 VPWR VGND sg13g2_decap_8
XFILLER_40_345 VPWR VGND sg13g2_fill_2
XFILLER_5_703 VPWR VGND sg13g2_decap_8
XFILLER_4_257 VPWR VGND sg13g2_decap_8
XFILLER_4_268 VPWR VGND sg13g2_decap_4
XFILLER_20_73 VPWR VGND sg13g2_fill_1
XFILLER_1_942 VPWR VGND sg13g2_decap_8
XFILLER_0_441 VPWR VGND sg13g2_decap_8
XFILLER_49_946 VPWR VGND sg13g2_decap_8
XFILLER_29_71 VPWR VGND sg13g2_fill_1
XFILLER_48_456 VPWR VGND sg13g2_decap_8
XFILLER_17_876 VPWR VGND sg13g2_decap_8
XFILLER_44_695 VPWR VGND sg13g2_fill_1
X_4430_ videogen.test_lut_thingy.pixel_feeder_inst.row\[5\]\[1\] net622 _1437_ VPWR
+ VGND sg13g2_nor2_1
X_4361_ _1364_ _1365_ _1366_ _1367_ _1368_ VPWR VGND sg13g2_nor4_1
X_6100_ net774 net817 _0160_ VPWR VGND sg13g2_nor2_1
X_4292_ _1299_ _1250_ _1298_ VPWR VGND sg13g2_nand2_1
X_6031_ net758 net800 _0092_ VPWR VGND sg13g2_nor2_1
XFILLER_39_423 VPWR VGND sg13g2_fill_2
XFILLER_6_1024 VPWR VGND sg13g2_fill_1
XFILLER_6_1013 VPWR VGND sg13g2_decap_8
XFILLER_39_478 VPWR VGND sg13g2_fill_2
XFILLER_39_467 VPWR VGND sg13g2_fill_2
XFILLER_27_607 VPWR VGND sg13g2_fill_2
X_5815_ _2774_ _2760_ _2772_ VPWR VGND sg13g2_xnor2_1
X_5746_ blue\[6\] blue\[4\] _2706_ VPWR VGND sg13g2_nor2_1
X_5677_ _2624_ _2579_ _2643_ _2644_ VPWR VGND sg13g2_a21o_1
X_4628_ VGND VPWR _0714_ net662 _1635_ _1634_ sg13g2_a21oi_1
X_6650__373 VPWR VGND net373 sg13g2_tiehi
X_4559_ _1566_ net897 _0750_ VPWR VGND sg13g2_nand2_1
XFILLER_1_249 VPWR VGND sg13g2_fill_1
X_6229_ net394 VGND VPWR _0288_ videogen.test_lut_thingy.pixel_feeder_inst.row\[1\]\[0\]
+ _0013_ sg13g2_dfrbpq_1
XFILLER_45_448 VPWR VGND sg13g2_decap_8
XFILLER_40_153 VPWR VGND sg13g2_fill_1
XFILLER_13_345 VPWR VGND sg13g2_decap_8
XFILLER_13_367 VPWR VGND sg13g2_fill_1
X_6321__214 VPWR VGND net214 sg13g2_tiehi
Xoutput4 net4 tmds_clk VPWR VGND sg13g2_buf_1
XFILLER_49_743 VPWR VGND sg13g2_fill_2
XFILLER_48_220 VPWR VGND sg13g2_fill_1
XFILLER_45_960 VPWR VGND sg13g2_decap_8
X_3930_ _0992_ _0993_ _0344_ VPWR VGND sg13g2_nor2_1
X_3861_ _0719_ net675 _0946_ VPWR VGND sg13g2_nor2_1
X_3792_ VGND VPWR videogen.test_lut_thingy.pixel_feeder_inst.v_pix\[1\] _0911_ _0916_
+ videogen.test_lut_thingy.pixel_feeder_inst.v_pix\[2\] sg13g2_a21oi_1
X_6580_ net313 VGND VPWR _0635_ videogen.test_lut_thingy.pixel_feeder_inst.row\[6\]\[1\]
+ _0222_ sg13g2_dfrbpq_1
X_5600_ VPWR VGND _2567_ _2565_ green\[3\] green\[1\] _2577_ green\[0\] sg13g2_a221oi_1
X_5531_ _2516_ _2472_ _2515_ VPWR VGND sg13g2_nand2b_1
X_6296__268 VPWR VGND net268 sg13g2_tiehi
XFILLER_8_393 VPWR VGND sg13g2_fill_1
X_5462_ _2448_ _2441_ _2447_ VPWR VGND sg13g2_nand2_1
X_4413_ videogen.test_lut_thingy.pixel_feeder_inst.row\[16\]\[1\] net646 _1420_ VPWR
+ VGND sg13g2_nor2_1
X_5393_ VGND VPWR _2386_ _2385_ _2374_ sg13g2_or2_1
X_4344_ videogen.test_lut_thingy.pixel_feeder_inst.row\[10\]\[2\] net633 _1351_ VPWR
+ VGND sg13g2_nor2_1
X_6014_ net794 net836 _0075_ VPWR VGND sg13g2_nor2_1
X_4275_ _1137_ _1269_ _1281_ _1282_ VPWR VGND sg13g2_nor3_1
X_6608__54 VPWR VGND net54 sg13g2_tiehi
XFILLER_43_919 VPWR VGND sg13g2_decap_8
XFILLER_23_632 VPWR VGND sg13g2_fill_1
XFILLER_35_481 VPWR VGND sg13g2_decap_8
XFILLER_35_492 VPWR VGND sg13g2_fill_1
XFILLER_23_676 VPWR VGND sg13g2_decap_4
XFILLER_35_1007 VPWR VGND sg13g2_decap_8
XFILLER_6_308 VPWR VGND sg13g2_fill_2
X_5729_ VPWR _2689_ _2688_ VGND sg13g2_inv_1
XFILLER_2_558 VPWR VGND sg13g2_decap_8
Xfanout840 net841 net840 VPWR VGND sg13g2_buf_8
Xfanout851 net853 net851 VPWR VGND sg13g2_buf_8
Xfanout873 net874 net873 VPWR VGND sg13g2_buf_1
Xfanout884 net885 net884 VPWR VGND sg13g2_buf_8
Xfanout862 net863 net862 VPWR VGND sg13g2_buf_8
Xfanout895 net896 net895 VPWR VGND sg13g2_buf_8
XFILLER_33_418 VPWR VGND sg13g2_fill_1
XFILLER_42_952 VPWR VGND sg13g2_decap_8
XFILLER_10_882 VPWR VGND sg13g2_decap_8
XFILLER_5_396 VPWR VGND sg13g2_fill_1
XFILLER_1_580 VPWR VGND sg13g2_decap_8
X_4060_ _1073_ _1080_ net892 _1084_ VPWR VGND sg13g2_nand3_1
XFILLER_37_702 VPWR VGND sg13g2_fill_1
X_4962_ VPWR VGND _1961_ _1951_ _1958_ _1733_ _1969_ _1734_ sg13g2_a221oi_1
X_4893_ _1886_ _1893_ _1889_ _1900_ VPWR VGND sg13g2_mux2_1
X_3913_ videogen.test_lut_thingy.pixel_feeder_inst.v_counter\[0\] _0949_ videogen.test_lut_thingy.pixel_feeder_inst.v_counter\[1\]
+ _0983_ VPWR VGND sg13g2_nand3_1
XFILLER_33_974 VPWR VGND sg13g2_decap_8
X_3844_ _0712_ net898 net525 _0942_ VPWR VGND sg13g2_and3_1
X_6632_ net191 VGND VPWR _0687_ serialize.shift_reg_b\[2\] clknet_3_1__leaf_clk_regs
+ sg13g2_dfrbpq_1
XFILLER_33_996 VPWR VGND sg13g2_decap_8
X_3775_ VGND VPWR _0743_ net14 _0782_ net620 sg13g2_a21oi_2
X_6563_ net453 VGND VPWR _0618_ videogen.test_lut_thingy.pixel_feeder_inst.row\[41\]\[0\]
+ _0205_ sg13g2_dfrbpq_1
X_5514_ _2458_ _2472_ _2499_ VPWR VGND sg13g2_nor2_1
X_6494_ net307 VGND VPWR _0549_ green_tmds_par\[2\] net738 sg13g2_dfrbpq_1
X_5445_ _2434_ VPWR _0419_ VGND _1671_ _2157_ sg13g2_o21ai_1
X_5376_ _2369_ _2366_ _2368_ VPWR VGND sg13g2_nand2_1
X_6530__141 VPWR VGND net141 sg13g2_tiehi
X_6489__327 VPWR VGND net327 sg13g2_tiehi
X_4327_ videogen.test_lut_thingy.pixel_feeder_inst.row\[30\]\[2\] net639 _1334_ VPWR
+ VGND sg13g2_nor2_1
X_4258_ _1262_ _1264_ _1265_ VPWR VGND sg13g2_nor2_1
XFILLER_41_1022 VPWR VGND sg13g2_decap_8
X_4189_ net679 net672 _1196_ VPWR VGND sg13g2_xor2_1
X_6611__38 VPWR VGND net38 sg13g2_tiehi
XFILLER_27_289 VPWR VGND sg13g2_decap_4
XFILLER_11_602 VPWR VGND sg13g2_decap_8
XFILLER_6_116 VPWR VGND sg13g2_fill_2
XFILLER_3_823 VPWR VGND sg13g2_decap_8
XFILLER_46_510 VPWR VGND sg13g2_decap_8
Xfanout681 videogen.another_shader.time_cnt\[1\] net681 VPWR VGND sg13g2_buf_8
Xfanout692 net695 net692 VPWR VGND sg13g2_buf_8
XFILLER_19_702 VPWR VGND sg13g2_fill_2
Xfanout670 videogen.another_shader.video_y\[7\] net670 VPWR VGND sg13g2_buf_8
XFILLER_46_521 VPWR VGND sg13g2_fill_1
XFILLER_34_738 VPWR VGND sg13g2_decap_4
XFILLER_18_1024 VPWR VGND sg13g2_decap_4
XFILLER_14_484 VPWR VGND sg13g2_decap_8
X_3560_ videogen.test_lut_thingy.pixel_feeder_inst.row\[28\]\[0\] net889 _0840_ _0562_
+ VPWR VGND sg13g2_mux2_1
X_3491_ videogen.test_lut_thingy.pixel_feeder_inst.row\[42\]\[3\] net857 _0826_ _0617_
+ VPWR VGND sg13g2_mux2_1
X_5230_ VPWR _2229_ _2228_ VGND sg13g2_inv_1
X_5161_ _2167_ _2146_ _2166_ _2144_ _0734_ VPWR VGND sg13g2_a22oi_1
X_6629__223 VPWR VGND net223 sg13g2_tiehi
X_5092_ VPWR _2099_ _2098_ VGND sg13g2_inv_1
X_4112_ _1115_ VPWR _1119_ VGND _1116_ _1118_ sg13g2_o21ai_1
XFILLER_25_1028 VPWR VGND sg13g2_fill_1
X_4043_ _1072_ videogen.fancy_shader.shader_counter_reg\[3\] videogen.fancy_shader.shader_counter_reg\[2\]
+ videogen.fancy_shader.shader_counter_reg\[1\] VPWR VGND sg13g2_and3_1
X_5994_ net760 net802 _0055_ VPWR VGND sg13g2_nor2_1
X_4945_ VPWR _1952_ _1951_ VGND sg13g2_inv_1
XFILLER_24_237 VPWR VGND sg13g2_fill_2
X_4876_ _1883_ _1750_ _1882_ VPWR VGND sg13g2_nand2_1
X_6601__82 VPWR VGND net82 sg13g2_tiehi
X_6615_ net463 VGND VPWR _0670_ videogen.test_lut_thingy.pixel_feeder_inst.row\[23\]\[1\]
+ _0246_ sg13g2_dfrbpq_1
X_3827_ net896 VPWR _0933_ VGND net716 _0888_ sg13g2_o21ai_1
X_3758_ _0894_ _0886_ _0893_ VPWR VGND sg13g2_nand2_1
X_6546_ net64 VGND VPWR _0601_ videogen.test_lut_thingy.pixel_feeder_inst.row\[46\]\[3\]
+ _0188_ sg13g2_dfrbpq_1
X_6477_ net383 VGND VPWR _0532_ videogen.test_lut_thingy.pixel_feeder_inst.row\[56\]\[3\]
+ _0128_ sg13g2_dfrbpq_1
X_3689_ _0790_ _0801_ _0869_ VPWR VGND sg13g2_nor2_2
X_5428_ _2421_ _2414_ _1250_ VPWR VGND sg13g2_nand2b_1
XFILLER_0_837 VPWR VGND sg13g2_decap_8
X_5359_ _1188_ _2349_ _2352_ VPWR VGND sg13g2_nor2_1
XFILLER_16_705 VPWR VGND sg13g2_fill_1
XFILLER_8_904 VPWR VGND sg13g2_decap_4
XFILLER_23_62 VPWR VGND sg13g2_decap_8
XFILLER_7_458 VPWR VGND sg13g2_fill_2
XFILLER_7_447 VPWR VGND sg13g2_decap_8
XFILLER_11_487 VPWR VGND sg13g2_fill_2
XFILLER_48_1028 VPWR VGND sg13g2_fill_1
XFILLER_3_675 VPWR VGND sg13g2_decap_8
X_6450__470 VPWR VGND net470 sg13g2_tiehi
XFILLER_24_8 VPWR VGND sg13g2_fill_2
XFILLER_47_874 VPWR VGND sg13g2_decap_8
XFILLER_0_77 VPWR VGND sg13g2_decap_8
XFILLER_0_1019 VPWR VGND sg13g2_decap_8
XFILLER_34_513 VPWR VGND sg13g2_decap_4
XFILLER_34_535 VPWR VGND sg13g2_fill_2
X_4730_ _1021_ _1729_ _1737_ VPWR VGND sg13g2_nor2_2
X_4661_ _1314_ _1667_ _1668_ VPWR VGND sg13g2_nor2_1
X_6400_ net232 VGND VPWR _0459_ videogen.test_lut_thingy.pixel_feeder_inst.row\[14\]\[3\]
+ _0064_ sg13g2_dfrbpq_1
X_3612_ net850 videogen.test_lut_thingy.pixel_feeder_inst.row\[60\]\[3\] _0851_ _0512_
+ VPWR VGND sg13g2_mux2_1
X_4592_ videogen.test_lut_thingy.pixel_feeder_inst.row\[15\]\[0\] net659 _1599_ VPWR
+ VGND sg13g2_nor2_1
X_6331_ net194 VGND VPWR _0390_ videogen.another_shader.video_y\[4\] net720 sg13g2_dfrbpq_2
X_3543_ videogen.test_lut_thingy.pixel_feeder_inst.row\[25\]\[2\] net863 _0837_ _0576_
+ VPWR VGND sg13g2_mux2_1
XFILLER_7_981 VPWR VGND sg13g2_decap_8
XFILLER_43_0 VPWR VGND sg13g2_decap_8
X_6262_ net336 VGND VPWR _0321_ videogen.test_lut_thingy.pixel_feeder_inst.v_pix\[5\]
+ net724 sg13g2_dfrbpq_2
X_3474_ videogen.test_lut_thingy.pixel_feeder_inst.row\[3\]\[2\] net860 _0820_ _0628_
+ VPWR VGND sg13g2_mux2_1
X_6193_ net789 net832 _0253_ VPWR VGND sg13g2_nor2_1
XFILLER_9_1011 VPWR VGND sg13g2_decap_8
X_5213_ _2210_ _2211_ _2212_ VPWR VGND sg13g2_nor2_1
X_5144_ _2129_ _2140_ _2115_ _2151_ VPWR VGND sg13g2_nand3_1
XFILLER_29_307 VPWR VGND sg13g2_fill_1
X_5075_ _2062_ _2065_ _2069_ _2082_ VPWR VGND sg13g2_nor3_1
X_4026_ _1060_ net899 _1059_ VPWR VGND sg13g2_nand2_1
X_5977_ net769 net813 _0038_ VPWR VGND sg13g2_nor2_1
XFILLER_12_207 VPWR VGND sg13g2_fill_1
XFILLER_12_218 VPWR VGND sg13g2_fill_1
X_4928_ _1935_ _1914_ _1925_ VPWR VGND sg13g2_xnor2_1
X_4859_ _1864_ _1865_ _1866_ VPWR VGND sg13g2_nor2_1
Xheichips25_bagel_22 VPWR VGND uio_oe[1] sg13g2_tielo
X_6529_ net145 VGND VPWR _0584_ videogen.test_lut_thingy.pixel_feeder_inst.row\[50\]\[2\]
+ _0171_ sg13g2_dfrbpq_1
XFILLER_0_623 VPWR VGND sg13g2_decap_8
XFILLER_44_800 VPWR VGND sg13g2_decap_8
XFILLER_16_546 VPWR VGND sg13g2_fill_1
XFILLER_44_877 VPWR VGND sg13g2_decap_8
XFILLER_12_752 VPWR VGND sg13g2_decap_8
XFILLER_7_244 VPWR VGND sg13g2_decap_4
XFILLER_7_299 VPWR VGND sg13g2_fill_2
XFILLER_4_940 VPWR VGND sg13g2_decap_8
XFILLER_3_494 VPWR VGND sg13g2_fill_1
X_5900_ _2842_ net749 net504 net755 blue_tmds_par\[3\] VPWR VGND sg13g2_a22oi_1
X_5831_ _2786_ _2788_ _2789_ VPWR VGND sg13g2_and2_1
XFILLER_34_354 VPWR VGND sg13g2_decap_4
X_5762_ _2722_ _2693_ _2721_ VPWR VGND sg13g2_xnor2_1
X_4713_ net710 videogen.another_shader.time_cnt\[8\] _1720_ VPWR VGND sg13g2_xor2_1
X_5693_ VGND VPWR _2623_ _2642_ _2659_ _2641_ sg13g2_a21oi_1
X_4644_ videogen.test_lut_thingy.pixel_feeder_inst.row\[42\]\[0\] net640 _1651_ VPWR
+ VGND sg13g2_nor2_1
X_4575_ videogen.test_lut_thingy.pixel_feeder_inst.row\[21\]\[0\] net630 _1582_ VPWR
+ VGND sg13g2_nor2_1
X_6314_ net228 VGND VPWR _0373_ videogen.another_shader.time_cnt\[29\] net729 sg13g2_dfrbpq_1
X_3526_ _0815_ _0828_ _0834_ VPWR VGND sg13g2_nor2_2
X_6245_ net366 VGND VPWR net493 serialize.shift_reg_c\[2\] clknet_3_0__leaf_clk_regs
+ sg13g2_dfrbpq_1
X_3457_ videogen.test_lut_thingy.pixel_feeder_inst.row\[7\]\[3\] net850 _0816_ _0641_
+ VPWR VGND sg13g2_mux2_1
X_3388_ net687 net697 net644 _0780_ VPWR VGND sg13g2_nor3_1
X_6176_ net774 net817 _0236_ VPWR VGND sg13g2_nor2_1
X_5127_ _2134_ _2097_ _2112_ VPWR VGND sg13g2_xnor2_1
X_5058_ _1703_ _2050_ _2064_ _2065_ VPWR VGND sg13g2_nor3_1
X_4009_ videogen.another_shader.time_cnt\[25\] videogen.another_shader.time_cnt\[24\]
+ videogen.another_shader.time_cnt\[23\] _1042_ _1048_ VPWR VGND sg13g2_and4_1
XFILLER_26_811 VPWR VGND sg13g2_decap_8
XFILLER_26_822 VPWR VGND sg13g2_fill_1
XFILLER_41_825 VPWR VGND sg13g2_decap_4
XFILLER_26_888 VPWR VGND sg13g2_fill_1
XFILLER_40_357 VPWR VGND sg13g2_fill_1
XFILLER_4_247 VPWR VGND sg13g2_decap_4
XFILLER_1_921 VPWR VGND sg13g2_decap_8
XFILLER_45_1009 VPWR VGND sg13g2_decap_8
XFILLER_0_420 VPWR VGND sg13g2_decap_8
XFILLER_49_925 VPWR VGND sg13g2_decap_8
XFILLER_48_435 VPWR VGND sg13g2_decap_8
XFILLER_0_497 VPWR VGND sg13g2_decap_8
XFILLER_1_998 VPWR VGND sg13g2_decap_8
XFILLER_29_83 VPWR VGND sg13g2_fill_1
XFILLER_29_94 VPWR VGND sg13g2_fill_2
XFILLER_36_608 VPWR VGND sg13g2_fill_2
XFILLER_44_652 VPWR VGND sg13g2_fill_1
XFILLER_16_376 VPWR VGND sg13g2_fill_1
XFILLER_16_398 VPWR VGND sg13g2_fill_1
XFILLER_31_324 VPWR VGND sg13g2_fill_2
XFILLER_32_836 VPWR VGND sg13g2_fill_2
XFILLER_32_858 VPWR VGND sg13g2_fill_1
XFILLER_8_520 VPWR VGND sg13g2_decap_4
XFILLER_8_564 VPWR VGND sg13g2_fill_1
XFILLER_8_553 VPWR VGND sg13g2_decap_8
X_4360_ videogen.test_lut_thingy.pixel_feeder_inst.row\[57\]\[2\] net623 _1367_ VPWR
+ VGND sg13g2_nor2_1
X_4291_ _1298_ _1288_ _1296_ VPWR VGND sg13g2_xnor2_1
X_6030_ net758 net800 _0091_ VPWR VGND sg13g2_nor2_1
XFILLER_26_118 VPWR VGND sg13g2_fill_2
X_5814_ _2760_ _2772_ _2773_ VPWR VGND sg13g2_nor2b_1
X_6399__98 VPWR VGND net98 sg13g2_tiehi
X_5745_ _2705_ blue\[6\] blue\[4\] VPWR VGND sg13g2_nand2_1
X_5676_ _2643_ _2624_ _2642_ VPWR VGND sg13g2_xnor2_1
X_4627_ videogen.test_lut_thingy.pixel_feeder_inst.row\[62\]\[0\] net637 _1634_ VPWR
+ VGND sg13g2_nor2_1
XFILLER_2_718 VPWR VGND sg13g2_fill_1
X_4558_ _1527_ _1564_ _1565_ VPWR VGND sg13g2_nor2_2
X_3509_ videogen.test_lut_thingy.pixel_feeder_inst.row\[45\]\[1\] net877 _0830_ _0603_
+ VPWR VGND sg13g2_mux2_1
X_4489_ videogen.test_lut_thingy.pixel_feeder_inst.row\[42\]\[1\] net640 _1496_ VPWR
+ VGND sg13g2_nor2_1
X_6228_ net395 VGND VPWR _0287_ serialize.shift_reg_b\[9\] clknet_3_2__leaf_clk_regs
+ sg13g2_dfrbpq_1
X_6159_ net785 net826 _0219_ VPWR VGND sg13g2_nor2_1
XFILLER_46_939 VPWR VGND sg13g2_decap_8
XFILLER_39_991 VPWR VGND sg13g2_decap_8
XFILLER_41_644 VPWR VGND sg13g2_fill_1
XFILLER_13_335 VPWR VGND sg13g2_fill_1
XFILLER_22_891 VPWR VGND sg13g2_fill_1
XFILLER_12_1019 VPWR VGND sg13g2_decap_8
Xoutput5 net5 tmds_g VPWR VGND sg13g2_buf_1
XFILLER_49_700 VPWR VGND sg13g2_fill_1
XFILLER_0_261 VPWR VGND sg13g2_fill_1
XFILLER_1_795 VPWR VGND sg13g2_decap_8
XFILLER_0_294 VPWR VGND sg13g2_decap_8
XFILLER_49_799 VPWR VGND sg13g2_decap_8
XFILLER_37_939 VPWR VGND sg13g2_decap_8
XFILLER_17_630 VPWR VGND sg13g2_decap_8
XFILLER_17_696 VPWR VGND sg13g2_decap_4
X_3860_ net498 net747 _0306_ VPWR VGND sg13g2_and2_1
X_3791_ _0915_ videogen.test_lut_thingy.pixel_feeder_inst.v_pix\[2\] videogen.test_lut_thingy.pixel_feeder_inst.v_pix\[1\]
+ _0911_ VPWR VGND sg13g2_and3_2
X_5530_ _2513_ _2502_ _2515_ VPWR VGND sg13g2_xor2_1
X_5461_ _2447_ red\[0\] _2446_ VPWR VGND sg13g2_nand2b_1
X_4412_ videogen.test_lut_thingy.pixel_feeder_inst.row\[18\]\[1\] net634 _1419_ VPWR
+ VGND sg13g2_nor2_1
X_5392_ VGND VPWR _2370_ _2372_ _2385_ _2373_ sg13g2_a21oi_1
X_4343_ net686 VPWR _1350_ VGND videogen.test_lut_thingy.pixel_feeder_inst.row\[11\]\[2\]
+ net654 sg13g2_o21ai_1
X_4274_ _1281_ _1211_ _1277_ VPWR VGND sg13g2_xnor2_1
X_6013_ net791 net834 _0074_ VPWR VGND sg13g2_nor2_1
XFILLER_36_994 VPWR VGND sg13g2_decap_8
XFILLER_23_666 VPWR VGND sg13g2_fill_2
X_3989_ net843 _1031_ _1033_ _0363_ VPWR VGND sg13g2_nor3_1
X_5728_ _2687_ blue\[2\] _2688_ VPWR VGND sg13g2_xor2_1
X_5659_ _2625_ _2626_ _2627_ VPWR VGND sg13g2_and2_1
XFILLER_2_537 VPWR VGND sg13g2_decap_8
Xfanout852 net853 net852 VPWR VGND sg13g2_buf_8
X_6388__120 VPWR VGND net120 sg13g2_tiehi
Xfanout830 net833 net830 VPWR VGND sg13g2_buf_8
Xfanout841 clockdiv.q1 net841 VPWR VGND sg13g2_buf_8
Xfanout874 net875 net874 VPWR VGND sg13g2_buf_8
Xfanout885 net890 net885 VPWR VGND sg13g2_buf_8
Xfanout863 net864 net863 VPWR VGND sg13g2_buf_8
XFILLER_46_714 VPWR VGND sg13g2_decap_4
Xfanout896 rst_n net896 VPWR VGND sg13g2_buf_8
X_6581__287 VPWR VGND net287 sg13g2_tiehi
XFILLER_26_40 VPWR VGND sg13g2_decap_4
XFILLER_42_931 VPWR VGND sg13g2_decap_8
XFILLER_41_463 VPWR VGND sg13g2_fill_1
XFILLER_47_7 VPWR VGND sg13g2_decap_8
XFILLER_49_541 VPWR VGND sg13g2_fill_2
XFILLER_3_77 VPWR VGND sg13g2_fill_2
XFILLER_37_725 VPWR VGND sg13g2_fill_1
XFILLER_36_202 VPWR VGND sg13g2_fill_2
XFILLER_36_213 VPWR VGND sg13g2_decap_8
XFILLER_37_769 VPWR VGND sg13g2_decap_8
X_4961_ _1951_ _1962_ _1964_ _1967_ _1968_ VPWR VGND sg13g2_nor4_1
XFILLER_17_471 VPWR VGND sg13g2_fill_1
XFILLER_33_931 VPWR VGND sg13g2_fill_1
X_4892_ _1866_ VPWR _1899_ VGND _1880_ _1897_ sg13g2_o21ai_1
X_6460__450 VPWR VGND net450 sg13g2_tiehi
X_3912_ _0953_ _0982_ _0329_ VPWR VGND sg13g2_nor2_1
X_3843_ net527 net491 _0942_ VPWR VGND sg13g2_nor2_1
X_6631_ net199 VGND VPWR _0686_ serialize.shift_reg_b\[1\] clknet_3_1__leaf_clk_regs
+ sg13g2_dfrbpq_1
XFILLER_32_474 VPWR VGND sg13g2_decap_4
X_3774_ VGND VPWR _0743_ net13 _0787_ net619 sg13g2_a21oi_2
X_6562_ net457 VGND VPWR _0617_ videogen.test_lut_thingy.pixel_feeder_inst.row\[42\]\[3\]
+ _0204_ sg13g2_dfrbpq_1
X_5513_ VGND VPWR _2472_ _2497_ _0423_ _2498_ sg13g2_a21oi_1
X_6493_ net311 VGND VPWR _0548_ videogen.test_lut_thingy.pixel_feeder_inst.row\[54\]\[3\]
+ _0144_ sg13g2_dfrbpq_1
X_5444_ _2434_ VPWR _0417_ VGND _1567_ _2271_ sg13g2_o21ai_1
X_5375_ _2368_ _1200_ _2367_ VPWR VGND sg13g2_xnor2_1
X_4326_ net693 VPWR _1333_ VGND videogen.test_lut_thingy.pixel_feeder_inst.row\[29\]\[2\]
+ net628 sg13g2_o21ai_1
XFILLER_41_1001 VPWR VGND sg13g2_decap_8
X_4257_ _1200_ _1260_ _1263_ _1264_ VPWR VGND sg13g2_nor3_1
X_4188_ _1194_ VPWR _1195_ VGND _1160_ _1193_ sg13g2_o21ai_1
XFILLER_24_997 VPWR VGND sg13g2_fill_1
XFILLER_10_124 VPWR VGND sg13g2_decap_4
XFILLER_11_636 VPWR VGND sg13g2_decap_8
X_6576__345 VPWR VGND net345 sg13g2_tiehi
XFILLER_3_802 VPWR VGND sg13g2_fill_1
XFILLER_3_846 VPWR VGND sg13g2_fill_1
XFILLER_3_879 VPWR VGND sg13g2_decap_8
XFILLER_2_334 VPWR VGND sg13g2_decap_8
XFILLER_2_389 VPWR VGND sg13g2_decap_8
Xfanout660 _0774_ net660 VPWR VGND sg13g2_buf_8
XFILLER_19_714 VPWR VGND sg13g2_decap_4
Xfanout671 videogen.another_shader.video_y\[6\] net671 VPWR VGND sg13g2_buf_8
Xfanout682 videogen.test_lut_thingy.pixel_feeder_inst.h_pix\[5\] net682 VPWR VGND
+ sg13g2_buf_8
Xfanout693 net694 net693 VPWR VGND sg13g2_buf_8
XFILLER_19_725 VPWR VGND sg13g2_fill_1
XFILLER_37_50 VPWR VGND sg13g2_decap_8
XFILLER_46_555 VPWR VGND sg13g2_decap_8
XFILLER_15_953 VPWR VGND sg13g2_decap_4
XFILLER_15_997 VPWR VGND sg13g2_decap_8
XFILLER_42_794 VPWR VGND sg13g2_fill_1
Xclkbuf_3_7__f_clk_regs clknet_0_clk_regs clknet_3_7__leaf_clk_regs VPWR VGND sg13g2_buf_8
XFILLER_6_662 VPWR VGND sg13g2_fill_2
X_3490_ _0821_ _0825_ _0826_ VPWR VGND sg13g2_nor2_2
X_6588__227 VPWR VGND net227 sg13g2_tiehi
X_5160_ VGND VPWR _2166_ _2165_ _1671_ sg13g2_or2_1
X_5091_ _1678_ _1677_ _2098_ VPWR VGND sg13g2_xor2_1
X_4111_ VPWR _1118_ _1117_ VGND sg13g2_inv_1
X_4042_ videogen.fancy_shader.shader_counter_reg\[3\] _1069_ _1071_ VPWR VGND sg13g2_nor2_1
XFILLER_49_382 VPWR VGND sg13g2_decap_8
XFILLER_37_566 VPWR VGND sg13g2_decap_8
XFILLER_37_544 VPWR VGND sg13g2_fill_2
X_5993_ net760 net802 _0054_ VPWR VGND sg13g2_nor2_1
X_4944_ VGND VPWR _1951_ _1950_ _1949_ sg13g2_or2_1
XFILLER_20_400 VPWR VGND sg13g2_fill_1
XFILLER_21_901 VPWR VGND sg13g2_fill_2
XFILLER_21_912 VPWR VGND sg13g2_fill_1
X_4875_ _1882_ _1743_ videogen.another_shader.time_cnt\[19\] VPWR VGND sg13g2_nand2b_1
X_6614_ net471 VGND VPWR _0669_ videogen.test_lut_thingy.pixel_feeder_inst.row\[23\]\[0\]
+ _0245_ sg13g2_dfrbpq_1
X_3826_ net842 _0888_ _0932_ _0270_ VPWR VGND sg13g2_nor3_1
X_3757_ _0763_ _0892_ _0893_ VPWR VGND net711 sg13g2_nand3b_1
X_6545_ net68 VGND VPWR _0600_ videogen.test_lut_thingy.pixel_feeder_inst.row\[46\]\[2\]
+ _0187_ sg13g2_dfrbpq_1
X_3688_ videogen.test_lut_thingy.pixel_feeder_inst.row\[15\]\[0\] net886 _0868_ _0444_
+ VPWR VGND sg13g2_mux2_1
X_6476_ net387 VGND VPWR _0531_ videogen.test_lut_thingy.pixel_feeder_inst.row\[56\]\[2\]
+ _0127_ sg13g2_dfrbpq_1
X_5427_ VGND VPWR _2418_ _2420_ _2419_ _2406_ sg13g2_a21oi_2
XFILLER_0_816 VPWR VGND sg13g2_decap_8
X_5358_ _2351_ _1190_ _2350_ VPWR VGND sg13g2_xnor2_1
X_4309_ net689 VPWR _1316_ VGND videogen.test_lut_thingy.pixel_feeder_inst.row\[25\]\[2\]
+ net624 sg13g2_o21ai_1
X_5289_ VPWR _2282_ _2281_ VGND sg13g2_inv_1
XFILLER_28_599 VPWR VGND sg13g2_fill_1
X_6285__290 VPWR VGND net290 sg13g2_tiehi
XFILLER_24_783 VPWR VGND sg13g2_fill_1
XFILLER_8_938 VPWR VGND sg13g2_decap_4
XFILLER_48_1007 VPWR VGND sg13g2_decap_8
XFILLER_3_654 VPWR VGND sg13g2_decap_8
XFILLER_17_8 VPWR VGND sg13g2_decap_4
XFILLER_47_853 VPWR VGND sg13g2_decap_8
XFILLER_46_330 VPWR VGND sg13g2_fill_2
XFILLER_0_56 VPWR VGND sg13g2_decap_8
XFILLER_21_219 VPWR VGND sg13g2_fill_1
X_4660_ _1667_ _1510_ _1666_ VPWR VGND sg13g2_nand2_1
X_3611_ _0802_ _0806_ _0828_ _0851_ VPWR VGND sg13g2_or3_1
XFILLER_7_960 VPWR VGND sg13g2_decap_8
X_4591_ videogen.test_lut_thingy.pixel_feeder_inst.row\[14\]\[0\] net637 _1598_ VPWR
+ VGND sg13g2_nor2_1
X_6330_ net196 VGND VPWR _0389_ videogen.another_shader.video_y\[3\] net725 sg13g2_dfrbpq_2
X_3542_ videogen.test_lut_thingy.pixel_feeder_inst.row\[25\]\[3\] net852 _0837_ _0577_
+ VPWR VGND sg13g2_mux2_1
X_3473_ videogen.test_lut_thingy.pixel_feeder_inst.row\[3\]\[3\] net849 _0820_ _0629_
+ VPWR VGND sg13g2_mux2_1
XFILLER_6_492 VPWR VGND sg13g2_fill_2
X_6261_ net338 VGND VPWR _0320_ videogen.test_lut_thingy.pixel_feeder_inst.v_pix\[4\]
+ net724 sg13g2_dfrbpq_1
X_6192_ net791 net834 _0252_ VPWR VGND sg13g2_nor2_1
X_5212_ _2200_ _2202_ _2211_ VPWR VGND sg13g2_nor2_1
X_5143_ _2119_ _2124_ _2117_ _2150_ VPWR VGND _2134_ sg13g2_nand4_1
XFILLER_36_0 VPWR VGND sg13g2_decap_8
X_5074_ _2078_ _2079_ _2076_ _2081_ VPWR VGND sg13g2_nand3_1
X_4025_ VGND VPWR _1059_ _1057_ _0722_ sg13g2_or2_1
XFILLER_37_352 VPWR VGND sg13g2_fill_1
XFILLER_25_547 VPWR VGND sg13g2_fill_1
X_5976_ net770 net813 _0037_ VPWR VGND sg13g2_nor2_1
X_4927_ _1925_ _1914_ _1934_ VPWR VGND sg13g2_xor2_1
X_4858_ _1752_ _1859_ _1863_ _1865_ VPWR VGND sg13g2_nor3_1
X_3809_ clk_video _0005_ VPWR VGND sg13g2_inv_2
X_4789_ VGND VPWR _1794_ _1796_ _1795_ _1786_ sg13g2_a21oi_2
XFILLER_5_919 VPWR VGND sg13g2_fill_1
XFILLER_4_429 VPWR VGND sg13g2_fill_2
Xheichips25_bagel_23 VPWR VGND uio_oe[2] sg13g2_tielo
X_6528_ net185 VGND VPWR _0583_ videogen.test_lut_thingy.pixel_feeder_inst.row\[50\]\[1\]
+ _0170_ sg13g2_dfrbpq_1
X_6459_ net452 VGND VPWR _0514_ videogen.test_lut_thingy.pixel_feeder_inst.row\[5\]\[1\]
+ _0110_ sg13g2_dfrbpq_1
XFILLER_0_602 VPWR VGND sg13g2_decap_8
XFILLER_0_679 VPWR VGND sg13g2_decap_8
XFILLER_18_41 VPWR VGND sg13g2_decap_4
XFILLER_44_856 VPWR VGND sg13g2_decap_8
X_6423__67 VPWR VGND net67 sg13g2_tiehi
XFILLER_34_95 VPWR VGND sg13g2_fill_2
XFILLER_11_252 VPWR VGND sg13g2_fill_2
XFILLER_4_996 VPWR VGND sg13g2_decap_8
XFILLER_39_606 VPWR VGND sg13g2_fill_2
XFILLER_47_650 VPWR VGND sg13g2_fill_1
X_6368__151 VPWR VGND net151 sg13g2_tiehi
X_5830_ _2787_ VPWR _2788_ VGND _2743_ _2746_ sg13g2_o21ai_1
X_5761_ _2721_ _2688_ _2719_ VPWR VGND sg13g2_xnor2_1
X_4712_ _1718_ VPWR _1719_ VGND _1688_ _1715_ sg13g2_o21ai_1
X_5692_ _2623_ _2635_ _2580_ _2658_ VPWR VGND _2655_ sg13g2_nand4_1
XFILLER_30_572 VPWR VGND sg13g2_decap_8
X_4643_ net694 VPWR _1650_ VGND videogen.test_lut_thingy.pixel_feeder_inst.row\[41\]\[0\]
+ net630 sg13g2_o21ai_1
X_4574_ videogen.test_lut_thingy.pixel_feeder_inst.row\[20\]\[0\] net650 _1581_ VPWR
+ VGND sg13g2_nor2_1
X_6313_ net230 VGND VPWR _0372_ videogen.another_shader.time_cnt\[28\] net731 sg13g2_dfrbpq_2
X_3525_ net883 videogen.test_lut_thingy.pixel_feeder_inst.row\[48\]\[0\] _0833_ _0590_
+ VPWR VGND sg13g2_mux2_1
X_6244_ net367 VGND VPWR _0303_ serialize.shift_reg_c\[1\] clknet_3_0__leaf_clk_regs
+ sg13g2_dfrbpq_1
X_3456_ net616 _0815_ _0816_ VPWR VGND sg13g2_nor2_2
X_6175_ net774 net817 _0235_ VPWR VGND sg13g2_nor2_1
X_3387_ net696 net644 _0779_ VPWR VGND sg13g2_nor2_1
X_5126_ _2133_ _2096_ _2112_ VPWR VGND sg13g2_xnor2_1
X_5057_ _2064_ _2052_ _2060_ VPWR VGND sg13g2_xnor2_1
X_4008_ videogen.another_shader.time_cnt\[25\] _1046_ _1047_ VPWR VGND sg13g2_nor2_1
XFILLER_38_1028 VPWR VGND sg13g2_fill_1
X_5959_ net784 net827 _0020_ VPWR VGND sg13g2_nor2_1
XFILLER_20_42 VPWR VGND sg13g2_fill_2
XFILLER_1_900 VPWR VGND sg13g2_decap_8
X_6254__351 VPWR VGND net351 sg13g2_tiehi
XFILLER_20_97 VPWR VGND sg13g2_fill_2
XFILLER_49_904 VPWR VGND sg13g2_decap_8
XFILLER_1_977 VPWR VGND sg13g2_decap_8
XFILLER_48_414 VPWR VGND sg13g2_decap_8
XFILLER_0_476 VPWR VGND sg13g2_decap_8
XFILLER_29_40 VPWR VGND sg13g2_decap_8
Xhold40 serialize.bit_cnt\[2\] VPWR VGND net528 sg13g2_dlygate4sd3_1
X_6584__263 VPWR VGND net263 sg13g2_tiehi
XFILLER_17_856 VPWR VGND sg13g2_fill_2
X_6398__100 VPWR VGND net100 sg13g2_tiehi
XFILLER_12_583 VPWR VGND sg13g2_fill_1
XFILLER_8_587 VPWR VGND sg13g2_fill_2
XFILLER_4_760 VPWR VGND sg13g2_fill_2
X_4290_ VGND VPWR _1297_ _1296_ _1288_ sg13g2_or2_1
XFILLER_39_425 VPWR VGND sg13g2_fill_1
X_5813_ VGND VPWR _2732_ _2742_ _2772_ _2771_ sg13g2_a21oi_1
X_6596__123 VPWR VGND net123 sg13g2_tiehi
XFILLER_22_347 VPWR VGND sg13g2_fill_2
XFILLER_22_369 VPWR VGND sg13g2_fill_2
X_5744_ _2703_ _2701_ _2704_ VPWR VGND sg13g2_xor2_1
X_5675_ _2642_ _2631_ _2640_ VPWR VGND sg13g2_xnor2_1
X_4626_ net687 VPWR _1633_ VGND videogen.test_lut_thingy.pixel_feeder_inst.row\[60\]\[0\]
+ net644 sg13g2_o21ai_1
X_4557_ _1544_ _1563_ _1564_ VPWR VGND sg13g2_nor2_2
X_6470__430 VPWR VGND net430 sg13g2_tiehi
X_3508_ videogen.test_lut_thingy.pixel_feeder_inst.row\[45\]\[2\] net866 _0830_ _0604_
+ VPWR VGND sg13g2_mux2_1
X_4488_ net693 VPWR _1495_ VGND videogen.test_lut_thingy.pixel_feeder_inst.row\[41\]\[1\]
+ net628 sg13g2_o21ai_1
XFILLER_44_1010 VPWR VGND sg13g2_decap_8
X_3439_ net872 videogen.test_lut_thingy.pixel_feeder_inst.row\[49\]\[1\] _0808_ _0651_
+ VPWR VGND sg13g2_mux2_1
X_6227_ net396 VGND VPWR _0286_ serialize.shift_reg_b\[8\] clknet_3_3__leaf_clk_regs
+ sg13g2_dfrbpq_1
X_6158_ net785 net828 _0218_ VPWR VGND sg13g2_nor2_1
XFILLER_46_918 VPWR VGND sg13g2_decap_8
X_5109_ VPWR _2116_ _2115_ VGND sg13g2_inv_1
X_6089_ net793 net838 _0149_ VPWR VGND sg13g2_nor2_1
XFILLER_39_970 VPWR VGND sg13g2_decap_8
XFILLER_45_439 VPWR VGND sg13g2_fill_1
X_6579__321 VPWR VGND net321 sg13g2_tiehi
XFILLER_15_31 VPWR VGND sg13g2_fill_1
XFILLER_41_656 VPWR VGND sg13g2_fill_1
XFILLER_15_42 VPWR VGND sg13g2_fill_1
XFILLER_15_64 VPWR VGND sg13g2_decap_4
XFILLER_15_97 VPWR VGND sg13g2_decap_4
XFILLER_40_188 VPWR VGND sg13g2_fill_2
XFILLER_5_513 VPWR VGND sg13g2_decap_8
X_6358__161 VPWR VGND net161 sg13g2_tiehi
Xoutput6 net6 tmds_r VPWR VGND sg13g2_buf_1
XFILLER_5_579 VPWR VGND sg13g2_fill_1
XFILLER_1_785 VPWR VGND sg13g2_fill_1
XFILLER_49_756 VPWR VGND sg13g2_fill_2
XFILLER_49_745 VPWR VGND sg13g2_fill_1
XFILLER_49_778 VPWR VGND sg13g2_decap_8
XFILLER_48_255 VPWR VGND sg13g2_fill_2
XFILLER_37_918 VPWR VGND sg13g2_decap_8
X_6365__154 VPWR VGND net154 sg13g2_tiehi
X_6447__476 VPWR VGND net476 sg13g2_tiehi
X_6482__356 VPWR VGND net356 sg13g2_tiehi
XFILLER_29_491 VPWR VGND sg13g2_decap_4
XFILLER_45_995 VPWR VGND sg13g2_decap_8
XFILLER_31_100 VPWR VGND sg13g2_decap_8
XFILLER_32_612 VPWR VGND sg13g2_fill_2
XFILLER_32_623 VPWR VGND sg13g2_fill_1
X_3790_ VGND VPWR _0909_ _0914_ net17 _0910_ sg13g2_a21oi_1
XFILLER_9_841 VPWR VGND sg13g2_fill_2
XFILLER_8_340 VPWR VGND sg13g2_decap_8
XFILLER_9_896 VPWR VGND sg13g2_fill_2
X_5460_ _2446_ red\[7\] _2445_ VPWR VGND sg13g2_xnor2_1
X_4411_ _1414_ _1415_ _1416_ _1417_ _1418_ VPWR VGND sg13g2_nor4_1
X_5391_ _2378_ _2383_ _2384_ VPWR VGND sg13g2_nor2_1
X_6372__147 VPWR VGND net147 sg13g2_tiehi
X_4342_ net664 _1343_ _1348_ _1349_ VPWR VGND sg13g2_nor3_1
XFILLER_4_590 VPWR VGND sg13g2_fill_1
XFILLER_28_1027 VPWR VGND sg13g2_fill_2
X_4273_ _1279_ _1260_ _1280_ VPWR VGND sg13g2_xor2_1
X_6012_ net794 net836 _0073_ VPWR VGND sg13g2_nor2_1
.ends
