* NGSPICE file created from heichips25_bagel.ext - technology: ihp-sg13g2

* Black-box entry subcircuit for sg13g2_fill_1 abstract view
.subckt sg13g2_fill_1 VDD VSS
.ends

* Black-box entry subcircuit for sg13g2_and2_1 abstract view
.subckt sg13g2_and2_1 A B X VDD VSS
.ends

* Black-box entry subcircuit for sg13g2_decap_8 abstract view
.subckt sg13g2_decap_8 VDD VSS
.ends

* Black-box entry subcircuit for sg13g2_nor2_1 abstract view
.subckt sg13g2_nor2_1 A B Y VDD VSS
.ends

* Black-box entry subcircuit for sg13g2_fill_2 abstract view
.subckt sg13g2_fill_2 VDD VSS
.ends

* Black-box entry subcircuit for sg13g2_decap_4 abstract view
.subckt sg13g2_decap_4 VDD VSS
.ends

* Black-box entry subcircuit for sg13g2_nor3_1 abstract view
.subckt sg13g2_nor3_1 A B C Y VDD VSS
.ends

* Black-box entry subcircuit for sg13g2_tiehi abstract view
.subckt sg13g2_tiehi VDD VSS L_HI
.ends

* Black-box entry subcircuit for sg13g2_mux2_1 abstract view
.subckt sg13g2_mux2_1 A0 A1 S X VDD VSS
.ends

* Black-box entry subcircuit for sg13g2_xnor2_1 abstract view
.subckt sg13g2_xnor2_1 Y A B VDD VSS
.ends

* Black-box entry subcircuit for sg13g2_dfrbpq_1 abstract view
.subckt sg13g2_dfrbpq_1 RESET_B VSS VDD D Q CLK
.ends

* Black-box entry subcircuit for sg13g2_o21ai_1 abstract view
.subckt sg13g2_o21ai_1 B1 VDD Y VSS A1 A2
.ends

* Black-box entry subcircuit for sg13g2_nand2b_1 abstract view
.subckt sg13g2_nand2b_1 Y B A_N VDD VSS
.ends

* Black-box entry subcircuit for sg13g2_nand3b_1 abstract view
.subckt sg13g2_nand3b_1 B C Y VDD VSS A_N
.ends

* Black-box entry subcircuit for sg13g2_nor2_2 abstract view
.subckt sg13g2_nor2_2 A B Y VDD VSS
.ends

* Black-box entry subcircuit for sg13g2_nand2_1 abstract view
.subckt sg13g2_nand2_1 Y A B VDD VSS
.ends

* Black-box entry subcircuit for sg13g2_buf_8 abstract view
.subckt sg13g2_buf_8 A X VDD VSS
.ends

* Black-box entry subcircuit for sg13g2_buf_1 abstract view
.subckt sg13g2_buf_1 A X VDD VSS
.ends

* Black-box entry subcircuit for sg13g2_nor4_1 abstract view
.subckt sg13g2_nor4_1 A B C D Y VDD VSS
.ends

* Black-box entry subcircuit for sg13g2_a21oi_1 abstract view
.subckt sg13g2_a21oi_1 VSS VDD A1 A2 Y B1
.ends

* Black-box entry subcircuit for sg13g2_nor3_2 abstract view
.subckt sg13g2_nor3_2 A B C Y VDD VSS
.ends

* Black-box entry subcircuit for sg13g2_a221oi_1 abstract view
.subckt sg13g2_a221oi_1 VDD VSS B2 C1 B1 A1 Y A2
.ends

* Black-box entry subcircuit for sg13g2_tielo abstract view
.subckt sg13g2_tielo VDD VSS L_LO
.ends

* Black-box entry subcircuit for sg13g2_a22oi_1 abstract view
.subckt sg13g2_a22oi_1 Y B1 B2 A2 A1 VDD VSS
.ends

* Black-box entry subcircuit for sg13g2_xor2_1 abstract view
.subckt sg13g2_xor2_1 B A X VDD VSS
.ends

* Black-box entry subcircuit for sg13g2_dlygate4sd3_1 abstract view
.subckt sg13g2_dlygate4sd3_1 A VDD VSS X
.ends

* Black-box entry subcircuit for sg13g2_nand2b_2 abstract view
.subckt sg13g2_nand2b_2 Y B VDD VSS A_N
.ends

* Black-box entry subcircuit for sg13g2_inv_1 abstract view
.subckt sg13g2_inv_1 VDD Y A VSS
.ends

* Black-box entry subcircuit for sg13g2_dfrbpq_2 abstract view
.subckt sg13g2_dfrbpq_2 RESET_B VSS VDD D Q CLK
.ends

* Black-box entry subcircuit for sg13g2_or2_1 abstract view
.subckt sg13g2_or2_1 VSS VDD X B A
.ends

* Black-box entry subcircuit for sg13g2_nor2b_2 abstract view
.subckt sg13g2_nor2b_2 A B_N Y VDD VSS
.ends

* Black-box entry subcircuit for sg13g2_nand3_1 abstract view
.subckt sg13g2_nand3_1 B C A Y VDD VSS
.ends

* Black-box entry subcircuit for sg13g2_a21o_1 abstract view
.subckt sg13g2_a21o_1 A2 A1 B1 X VDD VSS
.ends

* Black-box entry subcircuit for sg13g2_nor2b_1 abstract view
.subckt sg13g2_nor2b_1 A B_N Y VDD VSS
.ends

* Black-box entry subcircuit for sg13g2_or3_1 abstract view
.subckt sg13g2_or3_1 A B C X VDD VSS
.ends

* Black-box entry subcircuit for sg13g2_nand2_2 abstract view
.subckt sg13g2_nand2_2 Y A B VDD VSS
.ends

* Black-box entry subcircuit for sg13g2_buf_2 abstract view
.subckt sg13g2_buf_2 A X VDD VSS
.ends

* Black-box entry subcircuit for sg13g2_nand4_1 abstract view
.subckt sg13g2_nand4_1 B C A Y VDD VSS D
.ends

* Black-box entry subcircuit for sg13g2_and3_1 abstract view
.subckt sg13g2_and3_1 X A B C VDD VSS
.ends

* Black-box entry subcircuit for sg13g2_and4_1 abstract view
.subckt sg13g2_and4_1 A B C D X VDD VSS
.ends

* Black-box entry subcircuit for sg13g2_a21o_2 abstract view
.subckt sg13g2_a21o_2 A2 A1 B1 X VDD VSS
.ends

* Black-box entry subcircuit for sg13g2_and3_2 abstract view
.subckt sg13g2_and3_2 X A B C VDD VSS
.ends

* Black-box entry subcircuit for sg13g2_nor4_2 abstract view
.subckt sg13g2_nor4_2 A B C Y VSS VDD D
.ends

* Black-box entry subcircuit for sg13g2_a21oi_2 abstract view
.subckt sg13g2_a21oi_2 VSS VDD B1 Y A2 A1
.ends

* Black-box entry subcircuit for sg13g2_or4_1 abstract view
.subckt sg13g2_or4_1 A B C D X VDD VSS
.ends

* Black-box entry subcircuit for sg13g2_inv_8 abstract view
.subckt sg13g2_inv_8 Y A VDD VSS
.ends

* Black-box entry subcircuit for sg13g2_inv_2 abstract view
.subckt sg13g2_inv_2 Y A VDD VSS
.ends

* Black-box entry subcircuit for sg13g2_inv_4 abstract view
.subckt sg13g2_inv_4 A Y VDD VSS
.ends

.subckt heichips25_bagel VGND VPWR clk ena rst_n tmds_b tmds_clk tmds_g tmds_r ui_in[0]
+ ui_in[1] ui_in[2] ui_in[3] ui_in[4] ui_in[5] ui_in[6] ui_in[7] uio_in[0] uio_in[1]
+ uio_in[2] uio_in[3] uio_in[4] uio_in[5] uio_in[6] uio_in[7] uio_oe[0] uio_oe[1]
+ uio_oe[2] uio_oe[3] uio_oe[4] uio_oe[5] uio_oe[6] uio_oe[7] uio_out[0] uio_out[1]
+ uio_out[2] uio_out[3] uio_out[4] uio_out[5] uio_out[6] uio_out[7] uo_out[0] uo_out[1]
+ uo_out[2] uo_out[3] uo_out[4] uo_out[5] uo_out[6] uo_out[7]
XFILLER_39_211 VPWR VGND sg13g2_fill_1
X_3155_ tmds_blue.dc_balancing_reg\[0\] _0879_ _0262_ VPWR VGND sg13g2_and2_1
XFILLER_39_277 VPWR VGND sg13g2_decap_8
X_3086_ videogen.test_lut_thingy.pixel_feeder_inst.h_counter\[2\] videogen.test_lut_thingy.pixel_feeder_inst.h_counter\[1\]
+ _0837_ VPWR VGND sg13g2_nor2_1
XFILLER_27_428 VPWR VGND sg13g2_fill_2
XFILLER_35_450 VPWR VGND sg13g2_decap_4
XFILLER_23_623 VPWR VGND sg13g2_decap_8
XFILLER_23_634 VPWR VGND sg13g2_fill_2
XFILLER_11_829 VPWR VGND sg13g2_decap_4
X_3988_ net630 _1634_ _1639_ _1640_ VPWR VGND sg13g2_nor3_1
X_5255__183 VPWR VGND net183 sg13g2_tiehi
XFILLER_10_328 VPWR VGND sg13g2_fill_1
X_2939_ videogen.test_lut_thingy.pixel_feeder_inst.row\[61\]\[3\] net767 _0801_ _0479_
+ VPWR VGND sg13g2_mux2_1
X_4609_ _2219_ _2214_ _2218_ VPWR VGND sg13g2_xnor2_1
X_5010__439 VPWR VGND net439 sg13g2_tiehi
XFILLER_19_907 VPWR VGND sg13g2_decap_8
XFILLER_18_406 VPWR VGND sg13g2_decap_4
XFILLER_27_962 VPWR VGND sg13g2_decap_8
XFILLER_42_921 VPWR VGND sg13g2_fill_1
XFILLER_14_623 VPWR VGND sg13g2_decap_8
XFILLER_41_420 VPWR VGND sg13g2_decap_8
XFILLER_13_111 VPWR VGND sg13g2_fill_1
XFILLER_42_987 VPWR VGND sg13g2_decap_8
XFILLER_41_453 VPWR VGND sg13g2_fill_2
XFILLER_9_115 VPWR VGND sg13g2_fill_1
XFILLER_13_166 VPWR VGND sg13g2_decap_8
XFILLER_42_73 VPWR VGND sg13g2_fill_1
XFILLER_6_833 VPWR VGND sg13g2_decap_8
XFILLER_6_899 VPWR VGND sg13g2_decap_8
XFILLER_49_553 VPWR VGND sg13g2_decap_8
XFILLER_18_951 VPWR VGND sg13g2_decap_8
XFILLER_45_781 VPWR VGND sg13g2_decap_4
X_4960_ net114 VGND VPWR _0292_ videogen.test_lut_thingy.pixel_feeder_inst.row\[20\]\[2\]
+ _0019_ sg13g2_dfrbpq_1
X_3911_ net633 VPWR _1563_ VGND videogen.test_lut_thingy.pixel_feeder_inst.row\[13\]\[0\]
+ net567 sg13g2_o21ai_1
XFILLER_33_943 VPWR VGND sg13g2_fill_1
X_4891_ net683 net728 _0226_ VPWR VGND sg13g2_nor2_1
X_3842_ net626 VPWR _1495_ VGND _1489_ _1494_ sg13g2_o21ai_1
X_3773_ videogen.test_lut_thingy.pixel_feeder_inst.row\[40\]\[1\] net596 _1426_ VPWR
+ VGND sg13g2_nor2_1
X_2724_ _0731_ net639 net640 VPWR VGND sg13g2_nand2b_1
X_4931__157 VPWR VGND net157 sg13g2_tiehi
X_4325_ _1964_ VPWR _1966_ VGND _1953_ _1965_ sg13g2_o21ai_1
X_4256_ _1892_ _1885_ _1902_ VPWR VGND _1894_ sg13g2_nand3b_1
XFILLER_41_1024 VPWR VGND sg13g2_decap_4
X_3207_ _0903_ _0904_ _0905_ VPWR VGND sg13g2_nor2_2
X_4187_ _1833_ _1832_ _1758_ VPWR VGND sg13g2_nand2b_1
X_3138_ _0875_ _0873_ _0874_ VPWR VGND sg13g2_nand2_1
X_3069_ net794 videogen.test_lut_thingy.pixel_feeder_inst.row\[18\]\[1\] _0829_ _0287_
+ VPWR VGND sg13g2_mux2_1
XFILLER_23_420 VPWR VGND sg13g2_decap_8
XFILLER_24_954 VPWR VGND sg13g2_decap_8
XFILLER_11_604 VPWR VGND sg13g2_decap_4
XFILLER_23_453 VPWR VGND sg13g2_decap_4
X_5333__177 VPWR VGND net177 sg13g2_tiehi
X_5186__84 VPWR VGND net84 sg13g2_tiehi
XFILLER_5_4 VPWR VGND sg13g2_decap_8
XFILLER_3_869 VPWR VGND sg13g2_decap_8
Xfanout650 net654 net650 VPWR VGND sg13g2_buf_8
Xfanout694 net716 net694 VPWR VGND sg13g2_buf_8
Xfanout672 net676 net672 VPWR VGND sg13g2_buf_8
Xfanout661 clk_video net661 VPWR VGND sg13g2_buf_8
Xfanout683 net684 net683 VPWR VGND sg13g2_buf_1
XFILLER_46_589 VPWR VGND sg13g2_decap_8
XFILLER_15_910 VPWR VGND sg13g2_decap_8
XFILLER_27_781 VPWR VGND sg13g2_decap_8
XFILLER_26_280 VPWR VGND sg13g2_fill_1
XFILLER_15_987 VPWR VGND sg13g2_decap_8
X_5091__319 VPWR VGND net319 sg13g2_tiehi
XFILLER_14_497 VPWR VGND sg13g2_fill_2
XFILLER_30_957 VPWR VGND sg13g2_decap_8
X_5212__373 VPWR VGND net373 sg13g2_tiehi
X_4110_ _0979_ _1028_ _1756_ VPWR VGND sg13g2_nor2_1
X_5090_ net320 VGND VPWR _0418_ red_tmds_par\[8\] net657 sg13g2_dfrbpq_1
XFILLER_49_350 VPWR VGND sg13g2_fill_2
X_4041_ _1676_ VPWR _1690_ VGND _1662_ _1681_ sg13g2_o21ai_1
XFILLER_37_523 VPWR VGND sg13g2_fill_2
XFILLER_37_512 VPWR VGND sg13g2_fill_1
XFILLER_18_770 VPWR VGND sg13g2_fill_2
X_4943_ net141 VGND VPWR _0275_ videogen.test_lut_thingy.pixel_feeder_inst.row\[17\]\[0\]
+ _0009_ sg13g2_dfrbpq_1
XFILLER_17_291 VPWR VGND sg13g2_fill_2
XFILLER_33_740 VPWR VGND sg13g2_decap_8
X_4874_ net691 net736 _0209_ VPWR VGND sg13g2_nor2_1
XFILLER_21_957 VPWR VGND sg13g2_decap_8
X_3825_ _1474_ _1475_ _1476_ _1477_ _1478_ VPWR VGND sg13g2_nor4_1
XFILLER_20_434 VPWR VGND sg13g2_fill_1
X_3756_ _1405_ _1406_ _1407_ _1408_ _1409_ VPWR VGND sg13g2_nor4_1
X_2707_ videogen.fancy_shader.video_x\[7\] _0713_ _0714_ VPWR VGND sg13g2_and2_1
X_3687_ _1336_ _1337_ _1338_ _1339_ _1340_ VPWR VGND sg13g2_nor4_1
XFILLER_0_839 VPWR VGND sg13g2_decap_8
X_4308_ VGND VPWR _1942_ _1950_ _0373_ net766 sg13g2_a21oi_1
X_5288_ net273 VGND VPWR _0616_ blue_tmds_par\[0\] net652 sg13g2_dfrbpq_1
X_4239_ _1881_ _1883_ _1884_ _1885_ VPWR VGND sg13g2_nor3_2
X_5009__441 VPWR VGND net441 sg13g2_tiehi
XFILLER_28_545 VPWR VGND sg13g2_decap_8
XFILLER_15_239 VPWR VGND sg13g2_fill_2
XFILLER_23_250 VPWR VGND sg13g2_decap_8
XFILLER_11_401 VPWR VGND sg13g2_decap_4
XFILLER_12_935 VPWR VGND sg13g2_decap_8
XFILLER_8_939 VPWR VGND sg13g2_decap_8
XFILLER_11_445 VPWR VGND sg13g2_fill_2
XFILLER_23_42 VPWR VGND sg13g2_decap_8
XFILLER_47_832 VPWR VGND sg13g2_decap_8
XFILLER_48_83 VPWR VGND sg13g2_fill_1
X_5084__189 VPWR VGND net189 sg13g2_tiehi
XFILLER_0_35 VPWR VGND sg13g2_decap_8
XFILLER_34_559 VPWR VGND sg13g2_decap_8
XFILLER_9_33 VPWR VGND sg13g2_fill_1
XFILLER_14_261 VPWR VGND sg13g2_decap_8
X_4590_ VPWR VGND _2193_ _2140_ _2204_ _2138_ _2205_ _2200_ sg13g2_a221oi_1
X_3610_ videogen.test_lut_thingy.pixel_feeder_inst.row\[26\]\[2\] net586 _1263_ VPWR
+ VGND sg13g2_nor2_1
XFILLER_30_798 VPWR VGND sg13g2_fill_1
XFILLER_7_961 VPWR VGND sg13g2_decap_8
X_3541_ _1101_ _1193_ _1194_ VPWR VGND sg13g2_and2_1
XFILLER_6_471 VPWR VGND sg13g2_decap_4
X_3472_ _1050_ _1124_ _1125_ VPWR VGND sg13g2_nor2_1
X_5211_ net380 VGND VPWR _0539_ videogen.test_lut_thingy.pixel_feeder_inst.row\[52\]\[3\]
+ _0168_ sg13g2_dfrbpq_1
XFILLER_9_1002 VPWR VGND sg13g2_decap_8
X_5142_ net222 VGND VPWR _0470_ videogen.test_lut_thingy.pixel_feeder_inst.row\[62\]\[2\]
+ _0107_ sg13g2_dfrbpq_1
X_5143__220 VPWR VGND net220 sg13g2_tiehi
X_5073_ net343 VGND VPWR _0405_ videogen.test_lut_thingy.pixel_feeder_inst.row\[15\]\[2\]
+ _0051_ sg13g2_dfrbpq_1
X_4024_ VPWR VGND _1672_ _1668_ _1671_ _1664_ _1673_ _1666_ sg13g2_a221oi_1
XFILLER_37_397 VPWR VGND sg13g2_fill_2
X_4979__87 VPWR VGND net87 sg13g2_tiehi
X_5293__253 VPWR VGND net253 sg13g2_tiehi
X_4926_ net677 net722 _0259_ VPWR VGND sg13g2_nor2_1
X_4994__57 VPWR VGND net57 sg13g2_tiehi
XFILLER_20_220 VPWR VGND sg13g2_fill_2
X_4857_ net689 net734 _0192_ VPWR VGND sg13g2_nor2_1
X_3808_ net630 _1455_ _1460_ _1461_ VPWR VGND sg13g2_nor3_1
XFILLER_5_909 VPWR VGND sg13g2_decap_8
X_4788_ net702 net747 _0123_ VPWR VGND sg13g2_nor2_1
Xheichips25_bagel_24 VPWR VGND uio_oe[3] sg13g2_tielo
X_3739_ videogen.test_lut_thingy.pixel_feeder_inst.row\[1\]\[1\] net567 _1392_ VPWR
+ VGND sg13g2_nor2_1
XFILLER_0_625 VPWR VGND sg13g2_decap_8
XFILLER_28_353 VPWR VGND sg13g2_fill_2
XFILLER_44_857 VPWR VGND sg13g2_decap_8
XFILLER_16_526 VPWR VGND sg13g2_fill_1
XFILLER_18_97 VPWR VGND sg13g2_decap_4
XFILLER_44_868 VPWR VGND sg13g2_fill_1
XFILLER_34_30 VPWR VGND sg13g2_decap_8
XFILLER_8_703 VPWR VGND sg13g2_fill_1
XFILLER_12_732 VPWR VGND sg13g2_decap_8
XFILLER_24_592 VPWR VGND sg13g2_decap_8
XFILLER_34_74 VPWR VGND sg13g2_fill_2
XFILLER_7_202 VPWR VGND sg13g2_fill_2
XFILLER_7_257 VPWR VGND sg13g2_fill_1
XFILLER_4_986 VPWR VGND sg13g2_decap_8
XFILLER_3_452 VPWR VGND sg13g2_fill_2
XFILLER_38_128 VPWR VGND sg13g2_fill_1
XFILLER_47_640 VPWR VGND sg13g2_decap_8
XFILLER_35_824 VPWR VGND sg13g2_fill_2
X_2972_ net767 videogen.test_lut_thingy.pixel_feeder_inst.row\[63\]\[3\] _0810_ _0455_
+ VPWR VGND sg13g2_mux2_1
X_4711_ net696 net741 _0046_ VPWR VGND sg13g2_nor2_1
X_4642_ _2236_ net666 net487 net670 green_tmds_par\[2\] VPWR VGND sg13g2_a22oi_1
X_4573_ _2189_ _2161_ _2145_ VPWR VGND sg13g2_nand2b_1
X_3524_ _1177_ _1137_ _1176_ VPWR VGND sg13g2_xnor2_1
X_3455_ _1108_ _1074_ _1085_ VPWR VGND sg13g2_xnor2_1
X_3386_ _1038_ _0977_ _1039_ VPWR VGND sg13g2_xor2_1
X_5125_ net256 VGND VPWR _0453_ videogen.test_lut_thingy.pixel_feeder_inst.row\[63\]\[1\]
+ _0090_ sg13g2_dfrbpq_1
X_5056_ net372 VGND VPWR _0388_ videogen.test_lut_thingy.pixel_feeder_inst.row\[12\]\[2\]
+ _0039_ sg13g2_dfrbpq_1
X_4007_ _1656_ _1170_ _1655_ VPWR VGND sg13g2_xnor2_1
X_4909_ net693 net737 _0244_ VPWR VGND sg13g2_nor2_1
XFILLER_5_739 VPWR VGND sg13g2_decap_8
XFILLER_1_923 VPWR VGND sg13g2_decap_8
XFILLER_49_905 VPWR VGND sg13g2_decap_8
XFILLER_0_433 VPWR VGND sg13g2_decap_8
Xhold41 _2229_ VPWR VGND net486 sg13g2_dlygate4sd3_1
Xhold30 serialize.shift_reg_r\[5\] VPWR VGND net475 sg13g2_dlygate4sd3_1
XFILLER_29_41 VPWR VGND sg13g2_decap_8
XFILLER_48_448 VPWR VGND sg13g2_decap_8
XFILLER_29_662 VPWR VGND sg13g2_decap_8
XFILLER_45_40 VPWR VGND sg13g2_decap_4
XFILLER_16_367 VPWR VGND sg13g2_decap_8
X_5020__419 VPWR VGND net419 sg13g2_tiehi
XFILLER_3_282 VPWR VGND sg13g2_fill_1
X_3240_ _0848_ VPWR _0930_ VGND net637 _0927_ sg13g2_o21ai_1
X_3171_ net452 net663 _0282_ VPWR VGND sg13g2_and2_1
XFILLER_39_459 VPWR VGND sg13g2_decap_8
XFILLER_48_971 VPWR VGND sg13g2_decap_8
X_5324__293 VPWR VGND net293 sg13g2_tiehi
XFILLER_47_481 VPWR VGND sg13g2_decap_4
XFILLER_35_643 VPWR VGND sg13g2_fill_1
XFILLER_35_654 VPWR VGND sg13g2_decap_8
XFILLER_34_153 VPWR VGND sg13g2_fill_2
X_2955_ _0806_ _0767_ VPWR VGND _0727_ sg13g2_nand2b_2
XFILLER_31_860 VPWR VGND sg13g2_fill_2
X_2886_ videogen.test_lut_thingy.pixel_feeder_inst.row\[25\]\[1\] net794 _0790_ _0529_
+ VPWR VGND sg13g2_mux2_1
X_4625_ VPWR _0645_ net484 VGND sg13g2_inv_1
X_4556_ _2173_ _2171_ _2172_ _2170_ _2141_ VPWR VGND sg13g2_a22oi_1
X_3507_ _1155_ _1157_ _1159_ _1160_ VPWR VGND sg13g2_nor3_1
X_4487_ VGND VPWR _2101_ _2109_ _2111_ _2064_ sg13g2_a21oi_1
X_3438_ VGND VPWR _1070_ _1072_ _1091_ _1088_ sg13g2_a21oi_1
X_3369_ _1022_ videogen.fancy_shader.video_y\[0\] videogen.fancy_shader.n646\[0\]
+ VPWR VGND sg13g2_nand2_1
X_5108_ net290 VGND VPWR _0436_ videogen.test_lut_thingy.pixel_feeder_inst.row\[34\]\[0\]
+ _0073_ sg13g2_dfrbpq_1
XFILLER_39_993 VPWR VGND sg13g2_decap_8
XFILLER_26_610 VPWR VGND sg13g2_fill_2
X_5039_ net395 VGND VPWR _0371_ red\[0\] net656 sg13g2_dfrbpq_2
XFILLER_25_142 VPWR VGND sg13g2_decap_8
XFILLER_13_304 VPWR VGND sg13g2_decap_8
XFILLER_25_153 VPWR VGND sg13g2_fill_2
XFILLER_41_635 VPWR VGND sg13g2_decap_4
XFILLER_40_134 VPWR VGND sg13g2_fill_1
X_5273__432 VPWR VGND net432 sg13g2_tiehi
XFILLER_41_668 VPWR VGND sg13g2_decap_8
XFILLER_15_87 VPWR VGND sg13g2_decap_8
XFILLER_31_75 VPWR VGND sg13g2_decap_4
XFILLER_31_97 VPWR VGND sg13g2_decap_4
Xoutput20 net20 uo_out[7] VPWR VGND sg13g2_buf_1
Xoutput7 net7 uio_out[0] VPWR VGND sg13g2_buf_1
XFILLER_1_720 VPWR VGND sg13g2_decap_8
XFILLER_0_230 VPWR VGND sg13g2_decap_8
XFILLER_1_786 VPWR VGND sg13g2_decap_8
XFILLER_49_779 VPWR VGND sg13g2_decap_8
XFILLER_45_941 VPWR VGND sg13g2_decap_8
XFILLER_17_610 VPWR VGND sg13g2_fill_1
XFILLER_17_621 VPWR VGND sg13g2_decap_8
XFILLER_17_632 VPWR VGND sg13g2_fill_2
XFILLER_32_602 VPWR VGND sg13g2_fill_1
XFILLER_16_197 VPWR VGND sg13g2_fill_1
X_2740_ net779 videogen.test_lut_thingy.pixel_feeder_inst.row\[23\]\[2\] _0737_ _0632_
+ VPWR VGND sg13g2_mux2_1
XFILLER_9_842 VPWR VGND sg13g2_decap_8
X_2671_ VPWR _0679_ videogen.fancy_shader.n646\[7\] VGND sg13g2_inv_1
XFILLER_9_897 VPWR VGND sg13g2_decap_8
X_4410_ _2036_ VPWR _2048_ VGND _2023_ _2033_ sg13g2_o21ai_1
X_4341_ _1982_ _1968_ _1981_ VPWR VGND sg13g2_nand2_1
XFILLER_28_1017 VPWR VGND sg13g2_decap_8
X_4272_ VGND VPWR _1918_ _1917_ _1916_ sg13g2_or2_1
XFILLER_28_1028 VPWR VGND sg13g2_fill_1
X_3223_ VGND VPWR videogen.test_lut_thingy.pixel_feeder_inst.v_pix\[3\] _0916_ _0918_
+ _0909_ sg13g2_a21oi_1
XFILLER_39_223 VPWR VGND sg13g2_decap_4
X_3154_ tmds_green.dc_balancing_reg\[0\] _0879_ _0261_ VPWR VGND sg13g2_and2_1
XFILLER_39_245 VPWR VGND sg13g2_fill_1
X_3085_ videogen.test_lut_thingy.pixel_feeder_inst.v_counter\[2\] videogen.test_lut_thingy.pixel_feeder_inst.v_counter\[1\]
+ _0835_ _0836_ VPWR VGND sg13g2_nor3_1
XFILLER_36_963 VPWR VGND sg13g2_fill_1
X_3987_ _1635_ _1636_ _1637_ _1638_ _1639_ VPWR VGND sg13g2_nor4_1
X_2938_ _0741_ _0747_ _0759_ _0801_ VPWR VGND sg13g2_nor3_2
X_2869_ videogen.test_lut_thingy.pixel_feeder_inst.row\[51\]\[3\] net775 _0787_ _0543_
+ VPWR VGND sg13g2_mux2_1
XFILLER_11_1010 VPWR VGND sg13g2_decap_8
X_4608_ _2143_ blue\[6\] _2218_ VPWR VGND sg13g2_xor2_1
X_4539_ VPWR _2156_ _2155_ VGND sg13g2_inv_1
Xfanout810 net811 net810 VPWR VGND sg13g2_buf_8
XFILLER_46_716 VPWR VGND sg13g2_fill_2
XFILLER_46_705 VPWR VGND sg13g2_fill_1
XFILLER_26_42 VPWR VGND sg13g2_decap_4
XFILLER_26_440 VPWR VGND sg13g2_fill_1
XFILLER_42_966 VPWR VGND sg13g2_decap_8
X_5019__421 VPWR VGND net421 sg13g2_tiehi
XFILLER_42_85 VPWR VGND sg13g2_fill_2
XFILLER_42_63 VPWR VGND sg13g2_decap_4
XFILLER_5_311 VPWR VGND sg13g2_fill_1
XFILLER_10_874 VPWR VGND sg13g2_decap_8
XFILLER_5_355 VPWR VGND sg13g2_decap_8
XFILLER_49_532 VPWR VGND sg13g2_decap_8
XFILLER_1_572 VPWR VGND sg13g2_decap_4
XFILLER_18_930 VPWR VGND sg13g2_decap_8
X_5102__302 VPWR VGND net302 sg13g2_tiehi
XFILLER_44_270 VPWR VGND sg13g2_fill_1
X_4890_ net682 net727 _0225_ VPWR VGND sg13g2_nor2_1
X_3910_ net637 _1556_ _1561_ _1562_ VPWR VGND sg13g2_nor3_1
X_3841_ net629 VPWR _1494_ VGND _1490_ _1493_ sg13g2_o21ai_1
XFILLER_32_454 VPWR VGND sg13g2_fill_2
X_3772_ videogen.test_lut_thingy.pixel_feeder_inst.row\[42\]\[1\] net585 _1425_ VPWR
+ VGND sg13g2_nor2_1
X_2723_ net640 net639 _0730_ VPWR VGND sg13g2_nor2b_2
X_5195__52 VPWR VGND net52 sg13g2_tiehi
X_4324_ red\[7\] red\[6\] red\[4\] _1965_ VPWR VGND sg13g2_nand3_1
XFILLER_41_1003 VPWR VGND sg13g2_decap_8
X_4255_ _1899_ _1898_ _1888_ _1901_ VPWR VGND sg13g2_a21o_1
X_3206_ _0719_ VPWR _0904_ VGND net614 _0851_ sg13g2_o21ai_1
X_4186_ _1823_ VPWR _1832_ VGND _1827_ _1830_ sg13g2_o21ai_1
XFILLER_28_705 VPWR VGND sg13g2_decap_4
X_3137_ _0870_ videogen.test_lut_thingy.pixel_feeder_inst.v_pix\[3\] videogen.test_lut_thingy.pixel_feeder_inst.v_pix\[4\]
+ _0874_ VPWR VGND sg13g2_a21o_1
X_3068_ net783 videogen.test_lut_thingy.pixel_feeder_inst.row\[18\]\[2\] _0829_ _0288_
+ VPWR VGND sg13g2_mux2_1
XFILLER_24_933 VPWR VGND sg13g2_decap_8
X_5153__200 VPWR VGND net200 sg13g2_tiehi
XFILLER_7_609 VPWR VGND sg13g2_decap_4
XFILLER_3_837 VPWR VGND sg13g2_fill_1
XFILLER_3_826 VPWR VGND sg13g2_decap_8
XFILLER_2_303 VPWR VGND sg13g2_fill_1
XFILLER_3_848 VPWR VGND sg13g2_decap_8
Xfanout640 net641 net640 VPWR VGND sg13g2_buf_8
Xfanout651 net654 net651 VPWR VGND sg13g2_buf_1
Xfanout662 _0883_ net662 VPWR VGND sg13g2_buf_8
Xfanout684 net688 net684 VPWR VGND sg13g2_buf_8
Xfanout673 net676 net673 VPWR VGND sg13g2_buf_1
Xfanout695 net698 net695 VPWR VGND sg13g2_buf_8
XFILLER_46_568 VPWR VGND sg13g2_decap_8
XFILLER_15_966 VPWR VGND sg13g2_decap_8
X_4040_ _1689_ _1687_ _1688_ VPWR VGND sg13g2_xnor2_1
XFILLER_49_384 VPWR VGND sg13g2_decap_8
XFILLER_37_557 VPWR VGND sg13g2_decap_8
X_4942_ net143 VGND VPWR _0274_ videogen.test_lut_thingy.pixel_feeder_inst.row\[1\]\[3\]
+ _0008_ sg13g2_dfrbpq_1
XFILLER_33_763 VPWR VGND sg13g2_fill_1
X_4873_ net692 net736 _0208_ VPWR VGND sg13g2_nor2_1
XFILLER_21_936 VPWR VGND sg13g2_decap_8
X_3824_ videogen.test_lut_thingy.pixel_feeder_inst.row\[50\]\[3\] net590 _1477_ VPWR
+ VGND sg13g2_nor2_1
X_3755_ videogen.test_lut_thingy.pixel_feeder_inst.row\[50\]\[1\] net590 _1408_ VPWR
+ VGND sg13g2_nor2_1
X_3686_ videogen.test_lut_thingy.pixel_feeder_inst.row\[42\]\[2\] net585 _1339_ VPWR
+ VGND sg13g2_nor2_1
X_2706_ videogen.fancy_shader.video_x\[8\] videogen.fancy_shader.video_x\[9\] _0713_
+ VPWR VGND sg13g2_nor2b_1
XFILLER_0_818 VPWR VGND sg13g2_decap_8
X_5287_ net281 VGND VPWR _0615_ videogen.test_lut_thingy.pixel_feeder_inst.row\[49\]\[3\]
+ _0244_ sg13g2_dfrbpq_1
X_4307_ _1950_ _1944_ _1949_ _1649_ _1548_ VPWR VGND sg13g2_a22oi_1
X_5341__436 VPWR VGND net436 sg13g2_tiehi
X_4238_ _1878_ _1882_ _1884_ VPWR VGND sg13g2_nor2b_2
XFILLER_28_502 VPWR VGND sg13g2_decap_8
X_4169_ _1757_ _1756_ _1815_ VPWR VGND sg13g2_xor2_1
XFILLER_43_505 VPWR VGND sg13g2_fill_2
XFILLER_43_527 VPWR VGND sg13g2_fill_1
XFILLER_24_730 VPWR VGND sg13g2_decap_8
XFILLER_12_914 VPWR VGND sg13g2_decap_8
XFILLER_24_741 VPWR VGND sg13g2_fill_1
XFILLER_24_763 VPWR VGND sg13g2_decap_4
XFILLER_8_918 VPWR VGND sg13g2_decap_8
X_5090__320 VPWR VGND net320 sg13g2_tiehi
XFILLER_20_991 VPWR VGND sg13g2_decap_8
XFILLER_2_111 VPWR VGND sg13g2_decap_8
XFILLER_3_678 VPWR VGND sg13g2_decap_4
XFILLER_2_144 VPWR VGND sg13g2_decap_4
XFILLER_19_502 VPWR VGND sg13g2_fill_2
XFILLER_19_524 VPWR VGND sg13g2_fill_2
XFILLER_0_14 VPWR VGND sg13g2_decap_8
XFILLER_47_888 VPWR VGND sg13g2_decap_8
XFILLER_46_365 VPWR VGND sg13g2_fill_2
XFILLER_46_354 VPWR VGND sg13g2_fill_1
XFILLER_14_273 VPWR VGND sg13g2_decap_4
XFILLER_7_940 VPWR VGND sg13g2_decap_8
X_3540_ _1096_ _1102_ _1120_ _1193_ VPWR VGND sg13g2_mux2_1
X_3471_ VGND VPWR _1119_ _1122_ _1124_ _1123_ sg13g2_a21oi_1
XFILLER_6_494 VPWR VGND sg13g2_decap_4
XFILLER_6_483 VPWR VGND sg13g2_decap_8
X_5210_ net384 VGND VPWR _0538_ videogen.test_lut_thingy.pixel_feeder_inst.row\[52\]\[2\]
+ _0167_ sg13g2_dfrbpq_1
X_5141_ net224 VGND VPWR _0469_ videogen.test_lut_thingy.pixel_feeder_inst.row\[62\]\[1\]
+ _0106_ sg13g2_dfrbpq_1
X_5067__355 VPWR VGND net355 sg13g2_tiehi
X_5072_ net345 VGND VPWR _0404_ videogen.test_lut_thingy.pixel_feeder_inst.row\[15\]\[1\]
+ _0050_ sg13g2_dfrbpq_1
X_4023_ _1091_ _1093_ _1670_ _1672_ VPWR VGND sg13g2_or3_1
X_4925_ net678 net723 _0258_ VPWR VGND sg13g2_nor2_1
XFILLER_21_744 VPWR VGND sg13g2_fill_1
X_4856_ net684 net729 _0191_ VPWR VGND sg13g2_nor2_1
X_3807_ _1456_ _1457_ _1458_ _1459_ _1460_ VPWR VGND sg13g2_nor4_1
XFILLER_21_788 VPWR VGND sg13g2_fill_2
X_4787_ net701 net746 _0122_ VPWR VGND sg13g2_nor2_1
XFILLER_20_276 VPWR VGND sg13g2_fill_1
Xheichips25_bagel_25 VPWR VGND uio_oe[4] sg13g2_tielo
X_3738_ net608 VPWR _1391_ VGND videogen.test_lut_thingy.pixel_feeder_inst.row\[0\]\[1\]
+ net600 sg13g2_o21ai_1
X_3669_ _1321_ VPWR _1322_ VGND videogen.test_lut_thingy.pixel_feeder_inst.row\[60\]\[2\]
+ net594 sg13g2_o21ai_1
X_5050__381 VPWR VGND net381 sg13g2_tiehi
XFILLER_0_604 VPWR VGND sg13g2_decap_8
X_5339_ net54 VGND VPWR _0667_ serialize.shift_reg_c\[5\] clknet_3_3_0_clk_regs sg13g2_dfrbpq_1
XFILLER_29_822 VPWR VGND sg13g2_fill_2
XFILLER_18_32 VPWR VGND sg13g2_fill_2
XFILLER_28_310 VPWR VGND sg13g2_fill_2
XFILLER_28_332 VPWR VGND sg13g2_decap_8
XFILLER_18_76 VPWR VGND sg13g2_decap_8
XFILLER_44_836 VPWR VGND sg13g2_decap_8
XFILLER_43_379 VPWR VGND sg13g2_fill_1
XFILLER_11_210 VPWR VGND sg13g2_fill_2
XFILLER_15_1008 VPWR VGND sg13g2_decap_8
XFILLER_34_86 VPWR VGND sg13g2_fill_2
XFILLER_11_265 VPWR VGND sg13g2_fill_2
XFILLER_12_766 VPWR VGND sg13g2_decap_4
XFILLER_11_287 VPWR VGND sg13g2_fill_2
XFILLER_11_298 VPWR VGND sg13g2_fill_2
XFILLER_4_965 VPWR VGND sg13g2_decap_8
XFILLER_3_497 VPWR VGND sg13g2_decap_8
XFILLER_38_107 VPWR VGND sg13g2_decap_8
XFILLER_34_368 VPWR VGND sg13g2_decap_4
X_2971_ _0810_ _0755_ _0763_ VPWR VGND sg13g2_nand2_2
X_4710_ net696 net741 _0045_ VPWR VGND sg13g2_nor2_1
X_4641_ VPWR _0653_ _2235_ VGND sg13g2_inv_1
X_4572_ VGND VPWR _2186_ _2187_ _2188_ _2181_ sg13g2_a21oi_1
X_3523_ VGND VPWR _1156_ _1167_ _1176_ _1157_ sg13g2_a21oi_1
X_3454_ _1107_ _1104_ _1106_ VPWR VGND sg13g2_xnor2_1
X_5110__286 VPWR VGND net286 sg13g2_tiehi
XFILLER_41_0 VPWR VGND sg13g2_decap_8
X_3385_ _1038_ _1035_ _1037_ VPWR VGND sg13g2_xnor2_1
X_5124_ net258 VGND VPWR _0452_ videogen.test_lut_thingy.pixel_feeder_inst.row\[63\]\[0\]
+ _0089_ sg13g2_dfrbpq_1
X_5055_ net374 VGND VPWR _0387_ videogen.test_lut_thingy.pixel_feeder_inst.row\[12\]\[1\]
+ _0038_ sg13g2_dfrbpq_1
XFILLER_37_151 VPWR VGND sg13g2_fill_1
X_4006_ _1654_ VPWR _1655_ VGND _1169_ _1653_ sg13g2_o21ai_1
X_5258__171 VPWR VGND net171 sg13g2_tiehi
X_4908_ net708 net753 _0243_ VPWR VGND sg13g2_nor2_1
X_4839_ net709 net752 _0174_ VPWR VGND sg13g2_nor2_1
XFILLER_21_585 VPWR VGND sg13g2_decap_8
Xclkbuf_3_7_0_clk_regs clknet_0_clk_regs clknet_3_7_0_clk_regs VPWR VGND sg13g2_buf_8
XFILLER_4_217 VPWR VGND sg13g2_decap_8
XFILLER_1_902 VPWR VGND sg13g2_decap_8
XFILLER_1_979 VPWR VGND sg13g2_decap_8
XFILLER_48_427 VPWR VGND sg13g2_decap_8
XFILLER_48_416 VPWR VGND sg13g2_decap_8
Xhold31 serialize.shift_reg_b\[3\] VPWR VGND net476 sg13g2_dlygate4sd3_1
Xhold20 _2238_ VPWR VGND net465 sg13g2_dlygate4sd3_1
XFILLER_0_489 VPWR VGND sg13g2_decap_8
XFILLER_29_31 VPWR VGND sg13g2_decap_4
Xhold42 serialize.shift_reg_g\[6\] VPWR VGND net487 sg13g2_dlygate4sd3_1
XFILLER_45_52 VPWR VGND sg13g2_fill_1
XFILLER_43_143 VPWR VGND sg13g2_fill_1
XFILLER_43_132 VPWR VGND sg13g2_decap_8
XFILLER_43_110 VPWR VGND sg13g2_fill_1
XFILLER_16_335 VPWR VGND sg13g2_fill_1
XFILLER_8_523 VPWR VGND sg13g2_fill_2
X_4981__83 VPWR VGND net83 sg13g2_tiehi
X_3170_ net448 net663 _0281_ VPWR VGND sg13g2_and2_1
XFILLER_39_416 VPWR VGND sg13g2_fill_2
X_5064__358 VPWR VGND net358 sg13g2_tiehi
XFILLER_48_950 VPWR VGND sg13g2_decap_8
XFILLER_19_162 VPWR VGND sg13g2_decap_8
XFILLER_19_173 VPWR VGND sg13g2_fill_1
XFILLER_47_493 VPWR VGND sg13g2_decap_8
XFILLER_19_184 VPWR VGND sg13g2_decap_8
XFILLER_19_195 VPWR VGND sg13g2_fill_1
XFILLER_23_839 VPWR VGND sg13g2_decap_8
X_2954_ videogen.test_lut_thingy.pixel_feeder_inst.row\[62\]\[0\] net800 _0805_ _0468_
+ VPWR VGND sg13g2_mux2_1
X_2885_ videogen.test_lut_thingy.pixel_feeder_inst.row\[25\]\[2\] net783 _0790_ _0530_
+ VPWR VGND sg13g2_mux2_1
X_4624_ _2227_ net662 net483 net667 serialize.tmds_parallel_b\[3\] VPWR VGND sg13g2_a22oi_1
X_4555_ VGND VPWR net618 _2160_ _2172_ _2141_ sg13g2_a21oi_1
X_3506_ _1159_ _1030_ _1137_ VPWR VGND sg13g2_nand2_1
X_4486_ VGND VPWR _2110_ _2109_ _2101_ sg13g2_or2_1
X_3437_ _1088_ VPWR _1090_ VGND _1069_ _1071_ sg13g2_o21ai_1
X_3368_ _1021_ videogen.fancy_shader.video_y\[1\] videogen.fancy_shader.n646\[1\]
+ VPWR VGND sg13g2_nand2_1
X_5107_ net292 VGND VPWR _0435_ videogen.test_lut_thingy.pixel_feeder_inst.row\[31\]\[3\]
+ _0072_ sg13g2_dfrbpq_1
XFILLER_39_972 VPWR VGND sg13g2_decap_8
X_3299_ VGND VPWR _0965_ _0971_ _0973_ _0972_ sg13g2_a21oi_1
XFILLER_38_471 VPWR VGND sg13g2_decap_4
X_5038_ net396 VGND VPWR _0370_ red\[2\] net657 sg13g2_dfrbpq_2
XFILLER_25_121 VPWR VGND sg13g2_decap_8
XFILLER_40_113 VPWR VGND sg13g2_decap_4
XFILLER_13_349 VPWR VGND sg13g2_fill_1
XFILLER_21_371 VPWR VGND sg13g2_decap_8
Xoutput8 net8 uio_out[2] VPWR VGND sg13g2_buf_1
Xoutput10 net10 uio_out[4] VPWR VGND sg13g2_buf_1
XFILLER_0_297 VPWR VGND sg13g2_fill_2
XFILLER_45_920 VPWR VGND sg13g2_decap_8
XFILLER_36_419 VPWR VGND sg13g2_fill_2
XFILLER_45_997 VPWR VGND sg13g2_decap_8
XFILLER_17_677 VPWR VGND sg13g2_fill_1
XFILLER_13_872 VPWR VGND sg13g2_decap_8
XFILLER_12_360 VPWR VGND sg13g2_fill_1
XFILLER_13_883 VPWR VGND sg13g2_fill_2
X_5215__361 VPWR VGND net361 sg13g2_tiehi
XFILLER_8_364 VPWR VGND sg13g2_decap_4
X_2670_ VPWR _0678_ videogen.fancy_shader.n646\[9\] VGND sg13g2_inv_1
XFILLER_9_876 VPWR VGND sg13g2_fill_2
X_4340_ _1980_ _1978_ _1981_ VPWR VGND sg13g2_xor2_1
X_4271_ _1917_ _1856_ _1906_ VPWR VGND sg13g2_nand2_1
X_3222_ _0909_ _0915_ _0917_ _0307_ VPWR VGND sg13g2_nor3_1
X_3153_ _0880_ net814 net620 VPWR VGND sg13g2_nand2_1
X_3084_ _0835_ videogen.test_lut_thingy.pixel_feeder_inst.v_counter\[3\] videogen.test_lut_thingy.pixel_feeder_inst.v_counter\[0\]
+ VPWR VGND sg13g2_nand2_1
XFILLER_35_474 VPWR VGND sg13g2_fill_2
X_3986_ videogen.test_lut_thingy.pixel_feeder_inst.row\[32\]\[0\] net595 _1638_ VPWR
+ VGND sg13g2_nor2_1
XFILLER_22_146 VPWR VGND sg13g2_decap_8
X_2937_ videogen.test_lut_thingy.pixel_feeder_inst.row\[60\]\[0\] net801 _0800_ _0480_
+ VPWR VGND sg13g2_mux2_1
X_2868_ _0749_ _0765_ _0787_ VPWR VGND sg13g2_nor2_2
X_4607_ _2213_ _2217_ _0621_ VPWR VGND sg13g2_nor2_1
X_2799_ videogen.test_lut_thingy.pixel_feeder_inst.row\[59\]\[0\] net800 _0766_ _0592_
+ VPWR VGND sg13g2_mux2_1
XFILLER_2_518 VPWR VGND sg13g2_decap_4
X_4538_ _2155_ tmds_blue.dc_balancing_reg\[2\] _2153_ VPWR VGND sg13g2_xnor2_1
X_4469_ _2094_ _2093_ VPWR VGND _2092_ sg13g2_nand2b_2
Xfanout800 net804 net800 VPWR VGND sg13g2_buf_8
Xfanout811 net813 net811 VPWR VGND sg13g2_buf_8
XFILLER_45_205 VPWR VGND sg13g2_fill_2
XFILLER_26_21 VPWR VGND sg13g2_decap_8
XFILLER_27_931 VPWR VGND sg13g2_decap_4
XFILLER_27_997 VPWR VGND sg13g2_decap_8
XFILLER_13_124 VPWR VGND sg13g2_decap_8
XFILLER_10_842 VPWR VGND sg13g2_decap_4
XFILLER_42_97 VPWR VGND sg13g2_decap_4
XFILLER_10_897 VPWR VGND sg13g2_decap_8
XFILLER_3_25 VPWR VGND sg13g2_decap_8
XFILLER_1_551 VPWR VGND sg13g2_decap_8
XFILLER_49_511 VPWR VGND sg13g2_decap_8
XFILLER_3_1009 VPWR VGND sg13g2_decap_8
XFILLER_49_588 VPWR VGND sg13g2_decap_8
XFILLER_36_249 VPWR VGND sg13g2_fill_1
XFILLER_18_986 VPWR VGND sg13g2_decap_8
XFILLER_32_433 VPWR VGND sg13g2_fill_2
X_3840_ _1492_ VPWR _1493_ VGND videogen.test_lut_thingy.pixel_feeder_inst.row\[61\]\[3\]
+ net560 sg13g2_o21ai_1
XFILLER_32_466 VPWR VGND sg13g2_decap_4
XFILLER_33_989 VPWR VGND sg13g2_decap_8
X_3771_ videogen.test_lut_thingy.pixel_feeder_inst.row\[43\]\[1\] net574 _1424_ VPWR
+ VGND sg13g2_nor2_1
X_2722_ _0726_ net555 net614 _0729_ VPWR VGND sg13g2_nand3_1
XFILLER_8_161 VPWR VGND sg13g2_fill_1
XFILLER_8_150 VPWR VGND sg13g2_decap_8
XFILLER_9_673 VPWR VGND sg13g2_fill_2
XFILLER_9_695 VPWR VGND sg13g2_decap_8
X_4323_ _1960_ _1963_ _1964_ VPWR VGND sg13g2_nor2_1
X_4254_ VGND VPWR _1898_ _1899_ _1900_ _1888_ sg13g2_a21oi_1
X_3205_ videogen.test_lut_thingy.pixel_feeder_inst.v_counter\[3\] VPWR _0903_ VGND
+ videogen.test_lut_thingy.pixel_feeder_inst.v_counter\[2\] _0902_ sg13g2_o21ai_1
X_4185_ _1827_ _1830_ _1831_ VPWR VGND sg13g2_nor2_1
X_3136_ videogen.test_lut_thingy.pixel_feeder_inst.v_pix\[3\] _0870_ videogen.test_lut_thingy.pixel_feeder_inst.v_pix\[4\]
+ _0873_ VPWR VGND sg13g2_nand3_1
XFILLER_28_728 VPWR VGND sg13g2_fill_1
X_3067_ net772 videogen.test_lut_thingy.pixel_feeder_inst.row\[18\]\[3\] _0829_ _0289_
+ VPWR VGND sg13g2_mux2_1
XFILLER_42_219 VPWR VGND sg13g2_fill_2
X_5296__241 VPWR VGND net241 sg13g2_tiehi
X_5077__335 VPWR VGND net335 sg13g2_tiehi
XFILLER_24_989 VPWR VGND sg13g2_decap_8
X_3969_ net607 VPWR _1621_ VGND videogen.test_lut_thingy.pixel_feeder_inst.row\[41\]\[0\]
+ net563 sg13g2_o21ai_1
XFILLER_2_315 VPWR VGND sg13g2_decap_4
Xfanout641 videogen.test_lut_thingy.pixel_feeder_inst.h_pix\[0\] net641 VPWR VGND
+ sg13g2_buf_8
Xfanout630 net633 net630 VPWR VGND sg13g2_buf_8
X_4947__133 VPWR VGND net133 sg13g2_tiehi
Xfanout685 net687 net685 VPWR VGND sg13g2_buf_8
Xfanout652 net653 net652 VPWR VGND sg13g2_buf_8
Xfanout663 _0883_ net663 VPWR VGND sg13g2_buf_2
XFILLER_19_706 VPWR VGND sg13g2_fill_2
Xfanout674 net675 net674 VPWR VGND sg13g2_buf_8
XFILLER_37_31 VPWR VGND sg13g2_decap_8
Xfanout696 net698 net696 VPWR VGND sg13g2_buf_8
XFILLER_46_547 VPWR VGND sg13g2_decap_8
XFILLER_33_208 VPWR VGND sg13g2_fill_1
XFILLER_15_945 VPWR VGND sg13g2_decap_8
XFILLER_18_1028 VPWR VGND sg13g2_fill_1
XFILLER_30_937 VPWR VGND sg13g2_fill_2
XFILLER_41_296 VPWR VGND sg13g2_fill_2
X_4954__126 VPWR VGND net126 sg13g2_tiehi
XFILLER_10_672 VPWR VGND sg13g2_fill_2
XFILLER_10_694 VPWR VGND sg13g2_decap_8
XFILLER_49_363 VPWR VGND sg13g2_decap_8
XFILLER_37_536 VPWR VGND sg13g2_fill_2
XFILLER_45_591 VPWR VGND sg13g2_decap_8
X_4941_ net145 VGND VPWR _0273_ videogen.test_lut_thingy.pixel_feeder_inst.row\[1\]\[2\]
+ _0007_ sg13g2_dfrbpq_1
X_4872_ net691 net736 _0207_ VPWR VGND sg13g2_nor2_1
X_3823_ videogen.test_lut_thingy.pixel_feeder_inst.row\[48\]\[3\] net602 _1476_ VPWR
+ VGND sg13g2_nor2_1
XFILLER_20_414 VPWR VGND sg13g2_fill_2
XFILLER_21_915 VPWR VGND sg13g2_decap_8
X_3754_ videogen.test_lut_thingy.pixel_feeder_inst.row\[48\]\[1\] net602 _1407_ VPWR
+ VGND sg13g2_nor2_1
X_3685_ videogen.test_lut_thingy.pixel_feeder_inst.row\[41\]\[2\] net562 _1338_ VPWR
+ VGND sg13g2_nor2_1
X_5252__199 VPWR VGND net199 sg13g2_tiehi
X_2705_ VPWR _0712_ _0711_ VGND sg13g2_inv_1
X_5286_ net289 VGND VPWR _0614_ videogen.test_lut_thingy.pixel_feeder_inst.row\[49\]\[2\]
+ _0243_ sg13g2_dfrbpq_1
X_4306_ _1651_ _1748_ _1351_ _1949_ VPWR VGND sg13g2_nand3_1
XFILLER_4_90 VPWR VGND sg13g2_fill_2
X_4237_ _1882_ _1878_ _1883_ VPWR VGND sg13g2_nor2b_2
X_4168_ _1814_ _1812_ _1813_ VPWR VGND sg13g2_nand2_1
X_3119_ videogen.fancy_shader.video_y\[8\] videogen.fancy_shader.video_y\[7\] _0676_
+ _0860_ VPWR VGND videogen.fancy_shader.video_y\[6\] sg13g2_nand4_1
X_4099_ _0368_ _1744_ _1747_ VPWR VGND sg13g2_nand2_1
X_5120__266 VPWR VGND net266 sg13g2_tiehi
XFILLER_23_241 VPWR VGND sg13g2_decap_4
XFILLER_23_11 VPWR VGND sg13g2_decap_4
XFILLER_11_425 VPWR VGND sg13g2_decap_8
XFILLER_11_436 VPWR VGND sg13g2_decap_4
XFILLER_11_458 VPWR VGND sg13g2_decap_8
XFILLER_20_970 VPWR VGND sg13g2_decap_8
XFILLER_3_657 VPWR VGND sg13g2_decap_8
XFILLER_24_1010 VPWR VGND sg13g2_decap_8
XFILLER_46_333 VPWR VGND sg13g2_decap_8
XFILLER_47_867 VPWR VGND sg13g2_decap_8
XFILLER_46_399 VPWR VGND sg13g2_fill_1
XFILLER_42_572 VPWR VGND sg13g2_decap_8
XFILLER_42_561 VPWR VGND sg13g2_fill_1
XFILLER_31_1025 VPWR VGND sg13g2_decap_4
XFILLER_7_996 VPWR VGND sg13g2_decap_8
X_3470_ _1123_ _1096_ _1113_ _1121_ VPWR VGND sg13g2_and3_1
X_5140_ net226 VGND VPWR _0468_ videogen.test_lut_thingy.pixel_feeder_inst.row\[62\]\[0\]
+ _0105_ sg13g2_dfrbpq_1
X_5071_ net347 VGND VPWR _0403_ videogen.test_lut_thingy.pixel_feeder_inst.row\[15\]\[0\]
+ _0049_ sg13g2_dfrbpq_1
X_4022_ _1670_ VPWR _1671_ VGND _1091_ _1093_ sg13g2_o21ai_1
XFILLER_49_171 VPWR VGND sg13g2_fill_1
XFILLER_49_160 VPWR VGND sg13g2_decap_8
XFILLER_18_580 VPWR VGND sg13g2_decap_8
XFILLER_25_528 VPWR VGND sg13g2_decap_8
XFILLER_40_509 VPWR VGND sg13g2_decap_8
X_4924_ net678 net723 _0257_ VPWR VGND sg13g2_nor2_1
XFILLER_21_701 VPWR VGND sg13g2_fill_2
XFILLER_20_222 VPWR VGND sg13g2_fill_1
X_4855_ net684 net729 _0190_ VPWR VGND sg13g2_nor2_1
X_3806_ videogen.test_lut_thingy.pixel_feeder_inst.row\[35\]\[3\] net573 _1459_ VPWR
+ VGND sg13g2_nor2_1
X_4786_ net701 net746 _0121_ VPWR VGND sg13g2_nor2_1
X_3737_ _1386_ _1387_ _1388_ _1389_ _1390_ VPWR VGND sg13g2_nor4_1
X_3668_ VGND VPWR _0672_ _0738_ _1321_ _1320_ sg13g2_a21oi_1
Xheichips25_bagel_26 VPWR VGND uio_oe[5] sg13g2_tielo
XFILLER_47_1021 VPWR VGND sg13g2_decap_8
X_3599_ _1252_ _1191_ _1251_ VPWR VGND sg13g2_nand2_1
X_5338_ net70 VGND VPWR net447 clockdiv.q0 clknet_3_0_0_clk_regs sg13g2_dfrbpq_1
XFILLER_29_812 VPWR VGND sg13g2_fill_2
X_5269_ net50 VGND VPWR _0597_ videogen.test_lut_thingy.pixel_feeder_inst.row\[38\]\[1\]
+ _0226_ sg13g2_dfrbpq_1
XFILLER_18_44 VPWR VGND sg13g2_decap_4
XFILLER_44_826 VPWR VGND sg13g2_decap_4
XFILLER_28_399 VPWR VGND sg13g2_fill_1
XFILLER_24_561 VPWR VGND sg13g2_fill_2
XFILLER_34_54 VPWR VGND sg13g2_decap_4
XFILLER_7_204 VPWR VGND sg13g2_fill_1
X_4951__129 VPWR VGND net129 sg13g2_tiehi
XFILLER_4_944 VPWR VGND sg13g2_decap_8
XFILLER_3_421 VPWR VGND sg13g2_decap_4
XFILLER_1_0 VPWR VGND sg13g2_decap_8
XFILLER_19_344 VPWR VGND sg13g2_fill_1
XFILLER_19_355 VPWR VGND sg13g2_decap_8
XFILLER_19_366 VPWR VGND sg13g2_fill_1
XFILLER_19_377 VPWR VGND sg13g2_fill_1
XFILLER_34_303 VPWR VGND sg13g2_decap_4
XFILLER_35_826 VPWR VGND sg13g2_fill_1
X_2970_ videogen.test_lut_thingy.pixel_feeder_inst.row\[10\]\[0\] net809 _0809_ _0456_
+ VPWR VGND sg13g2_mux2_1
XFILLER_43_881 VPWR VGND sg13g2_fill_1
X_4640_ _2235_ net665 net471 net670 green_tmds_par\[1\] VPWR VGND sg13g2_a22oi_1
XFILLER_30_542 VPWR VGND sg13g2_decap_8
X_4571_ net618 _2141_ _2187_ VPWR VGND sg13g2_nor2_1
XFILLER_7_771 VPWR VGND sg13g2_decap_8
X_3522_ _1168_ _1171_ _1158_ _1175_ VPWR VGND sg13g2_nand3_1
X_3453_ _1106_ _1077_ _1105_ VPWR VGND sg13g2_xnor2_1
X_3384_ _1037_ net624 videogen.fancy_shader.n646\[4\] VPWR VGND sg13g2_xnor2_1
X_5123_ net260 VGND VPWR _0451_ videogen.test_lut_thingy.pixel_feeder_inst.row\[6\]\[3\]
+ _0088_ sg13g2_dfrbpq_1
XFILLER_34_0 VPWR VGND sg13g2_decap_8
X_5054_ net376 VGND VPWR _0386_ videogen.test_lut_thingy.pixel_feeder_inst.row\[12\]\[0\]
+ _0037_ sg13g2_dfrbpq_1
XFILLER_29_119 VPWR VGND sg13g2_fill_2
X_4005_ _1654_ _1653_ VPWR VGND _1023_ sg13g2_nand2b_2
XFILLER_26_815 VPWR VGND sg13g2_decap_8
XFILLER_37_174 VPWR VGND sg13g2_decap_4
XFILLER_1_91 VPWR VGND sg13g2_decap_8
X_5178__115 VPWR VGND net115 sg13g2_tiehi
X_4907_ net708 net737 _0242_ VPWR VGND sg13g2_nor2_1
X_4838_ net707 net752 _0173_ VPWR VGND sg13g2_nor2_1
X_4769_ net707 net752 _0104_ VPWR VGND sg13g2_nor2_1
XFILLER_0_424 VPWR VGND sg13g2_fill_1
XFILLER_1_958 VPWR VGND sg13g2_decap_8
Xhold10 _0279_ VPWR VGND net455 sg13g2_dlygate4sd3_1
Xhold21 serialize.shift_reg_g\[4\] VPWR VGND net466 sg13g2_dlygate4sd3_1
XFILLER_0_468 VPWR VGND sg13g2_decap_8
Xhold32 serialize.shift_reg_r\[8\] VPWR VGND net477 sg13g2_dlygate4sd3_1
Xhold43 _2236_ VPWR VGND net488 sg13g2_dlygate4sd3_1
XFILLER_21_1013 VPWR VGND sg13g2_decap_8
XFILLER_28_196 VPWR VGND sg13g2_decap_8
XFILLER_44_689 VPWR VGND sg13g2_fill_1
XFILLER_44_678 VPWR VGND sg13g2_decap_8
XFILLER_31_306 VPWR VGND sg13g2_fill_2
XFILLER_25_892 VPWR VGND sg13g2_decap_4
XFILLER_4_752 VPWR VGND sg13g2_fill_2
XFILLER_4_774 VPWR VGND sg13g2_decap_8
XFILLER_6_1018 VPWR VGND sg13g2_decap_8
XFILLER_35_623 VPWR VGND sg13g2_fill_2
XFILLER_16_870 VPWR VGND sg13g2_decap_8
XFILLER_34_155 VPWR VGND sg13g2_fill_1
X_2953_ videogen.test_lut_thingy.pixel_feeder_inst.row\[62\]\[1\] net789 _0805_ _0469_
+ VPWR VGND sg13g2_mux2_1
XFILLER_22_317 VPWR VGND sg13g2_fill_2
X_2884_ videogen.test_lut_thingy.pixel_feeder_inst.row\[25\]\[3\] net772 _0790_ _0531_
+ VPWR VGND sg13g2_mux2_1
X_4623_ VPWR _0644_ net490 VGND sg13g2_inv_1
X_4554_ _2171_ _2166_ net618 VPWR VGND sg13g2_nand2b_1
X_3505_ _1155_ _1157_ _1158_ VPWR VGND sg13g2_nor2_1
X_4485_ _2109_ _2107_ _2108_ VPWR VGND sg13g2_xnor2_1
XFILLER_44_1013 VPWR VGND sg13g2_decap_8
X_3436_ _1069_ _1071_ _1088_ _1089_ VPWR VGND sg13g2_or3_1
X_3367_ net762 _1020_ _0361_ VPWR VGND sg13g2_nor2_1
X_5106_ net294 VGND VPWR _0434_ videogen.test_lut_thingy.pixel_feeder_inst.row\[31\]\[2\]
+ _0071_ sg13g2_dfrbpq_1
XFILLER_45_409 VPWR VGND sg13g2_decap_4
X_3298_ _0969_ _0966_ _0968_ _0972_ VPWR VGND sg13g2_a21o_1
X_5037_ net397 VGND VPWR _0369_ green\[7\] net656 sg13g2_dfrbpq_2
XFILLER_14_829 VPWR VGND sg13g2_decap_8
XFILLER_25_177 VPWR VGND sg13g2_fill_2
XFILLER_15_67 VPWR VGND sg13g2_decap_8
XFILLER_22_884 VPWR VGND sg13g2_decap_8
XFILLER_5_505 VPWR VGND sg13g2_decap_8
XFILLER_21_394 VPWR VGND sg13g2_decap_8
XFILLER_1_711 VPWR VGND sg13g2_decap_4
Xoutput9 net9 uio_out[3] VPWR VGND sg13g2_buf_1
Xoutput11 net11 uio_out[6] VPWR VGND sg13g2_buf_1
XFILLER_49_704 VPWR VGND sg13g2_fill_2
XFILLER_1_755 VPWR VGND sg13g2_decap_4
XFILLER_45_976 VPWR VGND sg13g2_decap_8
X_5278__367 VPWR VGND net367 sg13g2_tiehi
XFILLER_16_166 VPWR VGND sg13g2_decap_4
XFILLER_44_486 VPWR VGND sg13g2_decap_8
X_5319__342 VPWR VGND net342 sg13g2_tiehi
XFILLER_32_648 VPWR VGND sg13g2_decap_4
XFILLER_13_840 VPWR VGND sg13g2_decap_8
XFILLER_31_136 VPWR VGND sg13g2_fill_1
XFILLER_31_158 VPWR VGND sg13g2_decap_8
XFILLER_32_659 VPWR VGND sg13g2_fill_1
XFILLER_8_321 VPWR VGND sg13g2_decap_4
XFILLER_9_833 VPWR VGND sg13g2_fill_1
XFILLER_31_169 VPWR VGND sg13g2_fill_2
XFILLER_8_343 VPWR VGND sg13g2_fill_1
X_4270_ VGND VPWR _1857_ _1914_ _1916_ _1915_ sg13g2_a21oi_1
X_3221_ videogen.test_lut_thingy.pixel_feeder_inst.v_pix\[2\] videogen.test_lut_thingy.pixel_feeder_inst.v_pix\[1\]
+ videogen.test_lut_thingy.pixel_feeder_inst.v_pix\[0\] _0907_ _0917_ VPWR VGND sg13g2_and4_1
X_3152_ net814 net620 _0879_ VPWR VGND sg13g2_and2_1
X_3083_ videogen.test_lut_thingy.pixel_feeder_inst.h_counter\[0\] _0833_ _0834_ VPWR
+ VGND sg13g2_and2_1
XFILLER_36_954 VPWR VGND sg13g2_decap_8
X_3985_ videogen.test_lut_thingy.pixel_feeder_inst.row\[34\]\[0\] net585 _1637_ VPWR
+ VGND sg13g2_nor2_1
X_5198__40 VPWR VGND net40 sg13g2_tiehi
X_2936_ videogen.test_lut_thingy.pixel_feeder_inst.row\[60\]\[1\] net789 _0800_ _0481_
+ VPWR VGND sg13g2_mux2_1
X_2867_ videogen.test_lut_thingy.pixel_feeder_inst.row\[50\]\[0\] net807 _0786_ _0544_
+ VPWR VGND sg13g2_mux2_1
X_4606_ VGND VPWR _2214_ _2215_ _2217_ _2216_ sg13g2_a21oi_1
XFILLER_7_90 VPWR VGND sg13g2_fill_1
X_2798_ videogen.test_lut_thingy.pixel_feeder_inst.row\[59\]\[1\] net790 _0766_ _0593_
+ VPWR VGND sg13g2_mux2_1
XFILLER_2_508 VPWR VGND sg13g2_fill_2
X_4537_ _2154_ tmds_blue.dc_balancing_reg\[2\] _2153_ VPWR VGND sg13g2_nand2_1
X_4468_ _2084_ VPWR _2093_ VGND _2075_ _2091_ sg13g2_o21ai_1
X_3419_ _1067_ _1052_ _1068_ _1072_ VPWR VGND sg13g2_a21o_2
Xfanout812 net813 net812 VPWR VGND sg13g2_buf_8
Xfanout801 net804 net801 VPWR VGND sg13g2_buf_2
X_4399_ _2038_ _2007_ _2037_ VPWR VGND sg13g2_nand2_1
X_5227__299 VPWR VGND net299 sg13g2_tiehi
XFILLER_46_718 VPWR VGND sg13g2_fill_1
X_5047__387 VPWR VGND net387 sg13g2_tiehi
XFILLER_38_291 VPWR VGND sg13g2_decap_8
XFILLER_27_976 VPWR VGND sg13g2_decap_8
XFILLER_14_637 VPWR VGND sg13g2_decap_4
XFILLER_42_10 VPWR VGND sg13g2_decap_4
XFILLER_13_136 VPWR VGND sg13g2_fill_1
XFILLER_41_489 VPWR VGND sg13g2_decap_4
XFILLER_22_692 VPWR VGND sg13g2_decap_8
XFILLER_6_847 VPWR VGND sg13g2_fill_1
XFILLER_5_335 VPWR VGND sg13g2_fill_2
X_5130__246 VPWR VGND net246 sg13g2_tiehi
XFILLER_49_567 VPWR VGND sg13g2_decap_8
XFILLER_44_250 VPWR VGND sg13g2_decap_4
XFILLER_17_464 VPWR VGND sg13g2_decap_8
XFILLER_18_965 VPWR VGND sg13g2_decap_8
X_3770_ net607 VPWR _1423_ VGND videogen.test_lut_thingy.pixel_feeder_inst.row\[41\]\[1\]
+ net563 sg13g2_o21ai_1
XFILLER_34_1012 VPWR VGND sg13g2_decap_8
XFILLER_9_641 VPWR VGND sg13g2_decap_4
X_2721_ _0728_ net613 _0726_ net555 VPWR VGND sg13g2_and3_2
XFILLER_13_692 VPWR VGND sg13g2_decap_8
XFILLER_9_663 VPWR VGND sg13g2_fill_2
X_4322_ VPWR VGND _1956_ _1961_ _1962_ _1957_ _1963_ _1959_ sg13g2_a221oi_1
X_4253_ _1885_ VPWR _1899_ VGND _1888_ _1891_ sg13g2_o21ai_1
X_3204_ VGND VPWR _0902_ videogen.test_lut_thingy.pixel_feeder_inst.v_counter\[0\]
+ videogen.test_lut_thingy.pixel_feeder_inst.v_counter\[1\] sg13g2_or2_1
X_4184_ _1830_ _1828_ _1829_ VPWR VGND sg13g2_xnor2_1
X_3135_ VGND VPWR _0863_ _0872_ net19 _0864_ sg13g2_a21oi_1
X_3066_ _0829_ _0728_ _0773_ VPWR VGND sg13g2_nand2_2
XFILLER_23_434 VPWR VGND sg13g2_fill_1
XFILLER_24_968 VPWR VGND sg13g2_decap_8
XFILLER_23_467 VPWR VGND sg13g2_fill_2
X_3968_ _1609_ _1619_ _1620_ VPWR VGND sg13g2_nor2_1
X_2919_ net768 videogen.test_lut_thingy.pixel_feeder_inst.row\[57\]\[3\] _0797_ _0495_
+ VPWR VGND sg13g2_mux2_1
X_3899_ _0363_ _1254_ _1551_ VPWR VGND sg13g2_nand2_1
Xfanout631 net633 net631 VPWR VGND sg13g2_buf_8
Xfanout642 videogen.fancy_shader.video_x\[5\] net642 VPWR VGND sg13g2_buf_8
Xfanout620 net621 net620 VPWR VGND sg13g2_buf_8
Xfanout664 net666 net664 VPWR VGND sg13g2_buf_8
Xfanout653 net654 net653 VPWR VGND sg13g2_buf_8
Xfanout675 net676 net675 VPWR VGND sg13g2_buf_8
Xfanout686 net687 net686 VPWR VGND sg13g2_buf_1
Xfanout697 net698 net697 VPWR VGND sg13g2_buf_1
XFILLER_27_740 VPWR VGND sg13g2_fill_1
XFILLER_14_423 VPWR VGND sg13g2_fill_1
XFILLER_15_924 VPWR VGND sg13g2_decap_8
XFILLER_42_754 VPWR VGND sg13g2_fill_1
XFILLER_18_1007 VPWR VGND sg13g2_decap_8
XFILLER_14_489 VPWR VGND sg13g2_decap_4
XFILLER_10_640 VPWR VGND sg13g2_fill_1
XFILLER_2_883 VPWR VGND sg13g2_decap_8
XFILLER_38_7 VPWR VGND sg13g2_decap_4
XFILLER_49_342 VPWR VGND sg13g2_decap_4
XFILLER_18_740 VPWR VGND sg13g2_fill_1
XFILLER_45_570 VPWR VGND sg13g2_decap_8
X_4940_ net147 VGND VPWR _0272_ videogen.test_lut_thingy.pixel_feeder_inst.row\[1\]\[1\]
+ _0006_ sg13g2_dfrbpq_1
X_4871_ net691 net736 _0206_ VPWR VGND sg13g2_nor2_1
XFILLER_33_754 VPWR VGND sg13g2_decap_8
X_3822_ videogen.test_lut_thingy.pixel_feeder_inst.row\[49\]\[3\] net569 _1475_ VPWR
+ VGND sg13g2_nor2_1
XFILLER_32_242 VPWR VGND sg13g2_decap_4
XFILLER_20_426 VPWR VGND sg13g2_fill_2
X_3753_ videogen.test_lut_thingy.pixel_feeder_inst.row\[49\]\[1\] net569 _1406_ VPWR
+ VGND sg13g2_nor2_1
X_3684_ videogen.test_lut_thingy.pixel_feeder_inst.row\[43\]\[2\] net574 _1337_ VPWR
+ VGND sg13g2_nor2_1
X_2704_ _0708_ _0710_ _0711_ VPWR VGND sg13g2_and2_1
X_5037__397 VPWR VGND net397 sg13g2_tiehi
X_4305_ _1946_ VPWR _0371_ VGND _1550_ _1648_ sg13g2_o21ai_1
X_5285_ net297 VGND VPWR _0613_ videogen.test_lut_thingy.pixel_feeder_inst.row\[49\]\[1\]
+ _0242_ sg13g2_dfrbpq_1
XFILLER_4_80 VPWR VGND sg13g2_fill_1
X_4236_ _1874_ _1865_ _1872_ _1882_ VPWR VGND sg13g2_mux2_1
X_4167_ _1764_ _1809_ _1811_ _1813_ VPWR VGND sg13g2_or3_1
X_3118_ _0859_ videogen.fancy_shader.video_y\[1\] videogen.fancy_shader.video_y\[0\]
+ VPWR VGND sg13g2_nand2_2
XFILLER_43_507 VPWR VGND sg13g2_fill_1
X_4098_ _1746_ VPWR _1747_ VGND _1351_ _1547_ sg13g2_o21ai_1
XFILLER_28_559 VPWR VGND sg13g2_decap_8
XFILLER_43_518 VPWR VGND sg13g2_decap_8
X_3049_ videogen.test_lut_thingy.pixel_feeder_inst.row\[36\]\[1\] net791 _0825_ _0334_
+ VPWR VGND sg13g2_mux2_1
XFILLER_24_754 VPWR VGND sg13g2_decap_4
XFILLER_11_415 VPWR VGND sg13g2_fill_2
XFILLER_12_949 VPWR VGND sg13g2_decap_8
XFILLER_3_603 VPWR VGND sg13g2_decap_4
XFILLER_3_636 VPWR VGND sg13g2_decap_8
XFILLER_3_4 VPWR VGND sg13g2_decap_8
XFILLER_48_42 VPWR VGND sg13g2_decap_8
XFILLER_48_53 VPWR VGND sg13g2_fill_1
XFILLER_47_846 VPWR VGND sg13g2_decap_8
XFILLER_19_537 VPWR VGND sg13g2_decap_8
XFILLER_46_367 VPWR VGND sg13g2_fill_1
XFILLER_0_49 VPWR VGND sg13g2_decap_8
XFILLER_27_570 VPWR VGND sg13g2_fill_1
XFILLER_34_518 VPWR VGND sg13g2_decap_8
XFILLER_34_529 VPWR VGND sg13g2_fill_2
XFILLER_14_231 VPWR VGND sg13g2_fill_2
XFILLER_15_732 VPWR VGND sg13g2_decap_8
XFILLER_15_743 VPWR VGND sg13g2_fill_2
XFILLER_15_754 VPWR VGND sg13g2_decap_8
XFILLER_14_297 VPWR VGND sg13g2_decap_8
XFILLER_31_1004 VPWR VGND sg13g2_decap_8
XFILLER_11_982 VPWR VGND sg13g2_decap_8
XFILLER_7_975 VPWR VGND sg13g2_decap_8
XFILLER_6_441 VPWR VGND sg13g2_fill_2
XFILLER_9_1016 VPWR VGND sg13g2_decap_8
XFILLER_9_1027 VPWR VGND sg13g2_fill_2
XFILLER_36_4 VPWR VGND sg13g2_fill_1
X_5070_ net349 VGND VPWR _0402_ videogen.test_lut_thingy.pixel_feeder_inst.row\[16\]\[3\]
+ _0048_ sg13g2_dfrbpq_1
X_4021_ _1110_ _1663_ _1670_ VPWR VGND sg13g2_and2_1
XFILLER_49_183 VPWR VGND sg13g2_fill_1
XFILLER_46_890 VPWR VGND sg13g2_decap_8
X_4923_ net677 net722 _0256_ VPWR VGND sg13g2_nor2_1
XFILLER_33_573 VPWR VGND sg13g2_fill_1
X_4854_ net684 net729 _0189_ VPWR VGND sg13g2_nor2_1
X_3805_ videogen.test_lut_thingy.pixel_feeder_inst.row\[33\]\[3\] net563 _1458_ VPWR
+ VGND sg13g2_nor2_1
XFILLER_21_757 VPWR VGND sg13g2_decap_8
X_4785_ net679 net725 _0120_ VPWR VGND sg13g2_nor2_1
X_3736_ videogen.test_lut_thingy.pixel_feeder_inst.row\[5\]\[1\] net565 _1389_ VPWR
+ VGND sg13g2_nor2_1
XFILLER_9_290 VPWR VGND sg13g2_fill_1
X_3667_ videogen.test_lut_thingy.pixel_feeder_inst.row\[63\]\[2\] net571 _1320_ VPWR
+ VGND sg13g2_nor2_1
Xheichips25_bagel_27 VPWR VGND uio_oe[6] sg13g2_tielo
XFILLER_47_1000 VPWR VGND sg13g2_decap_8
X_3598_ _1185_ _1249_ _1250_ _1251_ VPWR VGND sg13g2_nor3_1
X_5337_ net113 VGND VPWR _0665_ serialize.shift_reg_r\[7\] clknet_3_4_0_clk_regs sg13g2_dfrbpq_1
X_5268_ net58 VGND VPWR _0596_ videogen.test_lut_thingy.pixel_feeder_inst.row\[38\]\[0\]
+ _0225_ sg13g2_dfrbpq_1
XFILLER_47_109 VPWR VGND sg13g2_decap_4
X_4219_ _1865_ _1863_ _1862_ VPWR VGND sg13g2_nand2b_1
X_5199_ net36 VGND VPWR _0527_ videogen.test_lut_thingy.pixel_feeder_inst.row\[26\]\[3\]
+ _0156_ sg13g2_dfrbpq_1
XFILLER_18_23 VPWR VGND sg13g2_decap_4
XFILLER_28_312 VPWR VGND sg13g2_fill_1
XFILLER_29_824 VPWR VGND sg13g2_fill_1
XFILLER_43_337 VPWR VGND sg13g2_decap_8
XFILLER_11_212 VPWR VGND sg13g2_fill_1
XFILLER_12_746 VPWR VGND sg13g2_fill_2
XFILLER_11_267 VPWR VGND sg13g2_fill_1
XFILLER_11_289 VPWR VGND sg13g2_fill_1
XFILLER_4_923 VPWR VGND sg13g2_decap_8
XFILLER_15_9 VPWR VGND sg13g2_decap_8
XFILLER_19_312 VPWR VGND sg13g2_fill_1
XFILLER_47_654 VPWR VGND sg13g2_decap_4
XFILLER_28_890 VPWR VGND sg13g2_decap_8
XFILLER_34_326 VPWR VGND sg13g2_fill_2
XFILLER_43_860 VPWR VGND sg13g2_decap_8
XFILLER_43_893 VPWR VGND sg13g2_fill_2
XFILLER_30_521 VPWR VGND sg13g2_decap_8
XFILLER_42_392 VPWR VGND sg13g2_decap_8
X_4570_ _2185_ _2182_ _2186_ VPWR VGND sg13g2_xor2_1
X_3521_ _1155_ _1157_ _1173_ _1174_ VPWR VGND sg13g2_nor3_1
XFILLER_7_783 VPWR VGND sg13g2_decap_8
X_3452_ _1075_ VPWR _1105_ VGND _1078_ _1082_ sg13g2_o21ai_1
X_3383_ _1036_ net624 videogen.fancy_shader.n646\[4\] VPWR VGND sg13g2_nand2_1
X_5122_ net262 VGND VPWR _0450_ videogen.test_lut_thingy.pixel_feeder_inst.row\[6\]\[2\]
+ _0087_ sg13g2_dfrbpq_1
XFILLER_27_0 VPWR VGND sg13g2_fill_2
X_5053_ net377 VGND VPWR _0385_ green_tmds_par\[7\] net659 sg13g2_dfrbpq_1
XFILLER_38_654 VPWR VGND sg13g2_fill_2
X_4004_ videogen.fancy_shader.n646\[0\] videogen.fancy_shader.video_y\[0\] _1653_
+ VPWR VGND sg13g2_xor2_1
XFILLER_1_70 VPWR VGND sg13g2_decap_8
XFILLER_40_307 VPWR VGND sg13g2_decap_4
X_4906_ net708 net753 _0241_ VPWR VGND sg13g2_nor2_1
X_4837_ net693 net738 _0172_ VPWR VGND sg13g2_nor2_1
XFILLER_21_543 VPWR VGND sg13g2_decap_8
X_4768_ net712 net759 _0103_ VPWR VGND sg13g2_nor2_1
X_4699_ net688 net733 _0036_ VPWR VGND sg13g2_nor2_1
XFILLER_4_208 VPWR VGND sg13g2_decap_4
X_3719_ _1368_ _1369_ _1370_ _1371_ _1372_ VPWR VGND sg13g2_nor4_1
X_4950__130 VPWR VGND net130 sg13g2_tiehi
XFILLER_0_403 VPWR VGND sg13g2_decap_8
XFILLER_1_937 VPWR VGND sg13g2_decap_8
XFILLER_49_919 VPWR VGND sg13g2_decap_8
Xhold11 serialize.shift_reg_c\[3\] VPWR VGND net456 sg13g2_dlygate4sd3_1
XFILLER_0_447 VPWR VGND sg13g2_decap_8
Xhold22 serialize.shift_reg_r\[6\] VPWR VGND net467 sg13g2_dlygate4sd3_1
Xhold33 serialize.shift_reg_g\[3\] VPWR VGND net478 sg13g2_dlygate4sd3_1
Xhold44 serialize.shift_reg_b\[4\] VPWR VGND net489 sg13g2_dlygate4sd3_1
XFILLER_29_676 VPWR VGND sg13g2_decap_8
XFILLER_29_687 VPWR VGND sg13g2_decap_4
XFILLER_45_76 VPWR VGND sg13g2_fill_1
XFILLER_12_521 VPWR VGND sg13g2_fill_1
XFILLER_40_863 VPWR VGND sg13g2_fill_2
XFILLER_12_543 VPWR VGND sg13g2_decap_8
XFILLER_8_525 VPWR VGND sg13g2_fill_1
XFILLER_12_587 VPWR VGND sg13g2_fill_2
XFILLER_4_764 VPWR VGND sg13g2_fill_2
XFILLER_3_296 VPWR VGND sg13g2_decap_8
XFILLER_3_274 VPWR VGND sg13g2_fill_2
XFILLER_39_429 VPWR VGND sg13g2_decap_8
XFILLER_39_418 VPWR VGND sg13g2_fill_1
XFILLER_48_985 VPWR VGND sg13g2_decap_8
X_5140__226 VPWR VGND net226 sg13g2_tiehi
XFILLER_23_808 VPWR VGND sg13g2_fill_2
X_2952_ videogen.test_lut_thingy.pixel_feeder_inst.row\[62\]\[2\] net778 _0805_ _0470_
+ VPWR VGND sg13g2_mux2_1
X_2883_ _0743_ _0751_ _0790_ VPWR VGND sg13g2_nor2_2
XFILLER_31_885 VPWR VGND sg13g2_decap_8
X_4622_ _2226_ net662 net489 net668 blue_tmds_par\[2\] VPWR VGND sg13g2_a22oi_1
X_4553_ _2170_ _2168_ _2169_ _2162_ _2138_ VPWR VGND sg13g2_a22oi_1
X_4484_ _2086_ VPWR _2108_ VGND _2076_ _2085_ sg13g2_o21ai_1
X_3504_ _1157_ _1143_ _1149_ _1151_ VPWR VGND sg13g2_and3_2
X_3435_ _1088_ _1086_ _1087_ VPWR VGND sg13g2_xnor2_1
X_3366_ VGND VPWR _0717_ _0892_ _1020_ _1019_ sg13g2_a21oi_1
X_5105_ net296 VGND VPWR _0433_ videogen.test_lut_thingy.pixel_feeder_inst.row\[31\]\[1\]
+ _0070_ sg13g2_dfrbpq_1
X_3297_ _0967_ _0970_ _0971_ VPWR VGND sg13g2_and2_1
X_5036_ net398 VGND VPWR _0368_ green\[6\] net656 sg13g2_dfrbpq_2
XFILLER_25_101 VPWR VGND sg13g2_fill_2
XFILLER_26_679 VPWR VGND sg13g2_fill_2
XFILLER_13_329 VPWR VGND sg13g2_decap_4
XFILLER_22_863 VPWR VGND sg13g2_decap_8
XFILLER_5_539 VPWR VGND sg13g2_fill_1
Xoutput12 net12 uio_out[7] VPWR VGND sg13g2_buf_1
XFILLER_49_716 VPWR VGND sg13g2_decap_4
XFILLER_0_244 VPWR VGND sg13g2_fill_2
XFILLER_49_738 VPWR VGND sg13g2_decap_8
XFILLER_0_277 VPWR VGND sg13g2_fill_2
XFILLER_0_299 VPWR VGND sg13g2_fill_1
XFILLER_29_451 VPWR VGND sg13g2_decap_4
XFILLER_45_955 VPWR VGND sg13g2_decap_8
XFILLER_29_484 VPWR VGND sg13g2_fill_2
XFILLER_32_616 VPWR VGND sg13g2_decap_8
XFILLER_32_627 VPWR VGND sg13g2_fill_2
XFILLER_9_801 VPWR VGND sg13g2_decap_8
XFILLER_12_395 VPWR VGND sg13g2_decap_8
X_3220_ videogen.test_lut_thingy.pixel_feeder_inst.v_pix\[2\] _0914_ _0916_ VPWR VGND
+ sg13g2_and2_1
X_3151_ _0846_ _0852_ _0000_ VPWR VGND sg13g2_nor2_1
XFILLER_48_782 VPWR VGND sg13g2_decap_8
X_3082_ videogen.fancy_shader.video_y\[9\] _0707_ _0714_ _0833_ VGND VPWR _0832_ sg13g2_nor4_2
XFILLER_36_977 VPWR VGND sg13g2_decap_4
XFILLER_22_115 VPWR VGND sg13g2_decap_4
X_3984_ videogen.test_lut_thingy.pixel_feeder_inst.row\[35\]\[0\] net573 _1636_ VPWR
+ VGND sg13g2_nor2_1
X_2935_ videogen.test_lut_thingy.pixel_feeder_inst.row\[60\]\[2\] net778 _0800_ _0482_
+ VPWR VGND sg13g2_mux2_1
X_2866_ videogen.test_lut_thingy.pixel_feeder_inst.row\[50\]\[1\] net797 _0786_ _0545_
+ VPWR VGND sg13g2_mux2_1
XFILLER_30_181 VPWR VGND sg13g2_decap_4
XFILLER_31_693 VPWR VGND sg13g2_fill_1
X_4605_ net620 VPWR _2216_ VGND _2214_ _2215_ sg13g2_o21ai_1
XFILLER_11_1024 VPWR VGND sg13g2_decap_4
X_2797_ videogen.test_lut_thingy.pixel_feeder_inst.row\[59\]\[2\] net779 _0766_ _0594_
+ VPWR VGND sg13g2_mux2_1
X_4536_ _2143_ _2152_ _2153_ VPWR VGND sg13g2_nor2b_2
X_4467_ _2075_ _2084_ _2091_ _2092_ VPWR VGND sg13g2_nor3_1
X_3418_ VGND VPWR _1052_ _1067_ _1071_ _1068_ sg13g2_a21oi_1
Xfanout813 rst_n net813 VPWR VGND sg13g2_buf_2
Xfanout802 net803 net802 VPWR VGND sg13g2_buf_8
X_4398_ _2037_ _2034_ _2035_ VPWR VGND sg13g2_xnor2_1
X_3349_ net762 _1009_ _0354_ VPWR VGND sg13g2_nor2_1
XFILLER_45_207 VPWR VGND sg13g2_fill_1
XFILLER_39_760 VPWR VGND sg13g2_fill_1
X_5019_ net421 VGND VPWR _0351_ videogen.fancy_shader.video_y\[4\] net648 sg13g2_dfrbpq_1
XFILLER_26_12 VPWR VGND sg13g2_decap_4
XFILLER_27_955 VPWR VGND sg13g2_decap_8
XFILLER_41_413 VPWR VGND sg13g2_decap_8
XFILLER_13_104 VPWR VGND sg13g2_decap_8
XFILLER_41_446 VPWR VGND sg13g2_decap_8
XFILLER_41_435 VPWR VGND sg13g2_decap_4
XFILLER_41_479 VPWR VGND sg13g2_decap_4
XFILLER_13_159 VPWR VGND sg13g2_decap_8
XFILLER_21_181 VPWR VGND sg13g2_decap_8
XFILLER_6_826 VPWR VGND sg13g2_decap_8
XFILLER_21_192 VPWR VGND sg13g2_fill_1
XFILLER_6_859 VPWR VGND sg13g2_decap_4
XFILLER_49_546 VPWR VGND sg13g2_decap_8
XFILLER_18_944 VPWR VGND sg13g2_decap_8
XFILLER_45_785 VPWR VGND sg13g2_fill_1
XFILLER_32_413 VPWR VGND sg13g2_decap_4
XFILLER_32_435 VPWR VGND sg13g2_fill_1
XFILLER_20_619 VPWR VGND sg13g2_fill_2
XFILLER_40_490 VPWR VGND sg13g2_decap_4
XFILLER_12_181 VPWR VGND sg13g2_decap_4
X_2720_ _0727_ net629 _0701_ VPWR VGND sg13g2_xnor2_1
XFILLER_8_196 VPWR VGND sg13g2_fill_1
XFILLER_5_881 VPWR VGND sg13g2_decap_8
X_4321_ VGND VPWR red\[6\] _1953_ _1962_ red\[7\] sg13g2_a21oi_1
XFILLER_4_380 VPWR VGND sg13g2_fill_1
X_4252_ _1889_ VPWR _1898_ VGND _1877_ _1883_ sg13g2_o21ai_1
X_3203_ net812 _0901_ _0304_ VPWR VGND sg13g2_and2_1
XFILLER_41_1028 VPWR VGND sg13g2_fill_1
XFILLER_41_1017 VPWR VGND sg13g2_decap_8
X_4183_ _1814_ _1816_ _1824_ _1829_ VPWR VGND sg13g2_nor3_1
X_3134_ _0872_ videogen.test_lut_thingy.pixel_feeder_inst.v_pix\[3\] _0870_ VPWR VGND
+ sg13g2_xnor2_1
XFILLER_27_207 VPWR VGND sg13g2_fill_2
X_3065_ videogen.test_lut_thingy.pixel_feeder_inst.row\[20\]\[0\] net801 _0828_ _0290_
+ VPWR VGND sg13g2_mux2_1
XFILLER_24_947 VPWR VGND sg13g2_decap_8
X_3967_ net626 VPWR _1619_ VGND _1614_ _1618_ sg13g2_o21ai_1
X_2918_ _0797_ _0763_ VPWR VGND _0751_ sg13g2_nand2b_2
XFILLER_32_980 VPWR VGND sg13g2_decap_8
X_3898_ _1551_ _1450_ _1550_ VPWR VGND sg13g2_nand2b_1
X_2849_ net769 videogen.test_lut_thingy.pixel_feeder_inst.row\[47\]\[3\] _0783_ _0559_
+ VPWR VGND sg13g2_mux2_1
X_4519_ _0690_ tmds_blue.dc_balancing_reg\[4\] _2136_ _2137_ VPWR VGND sg13g2_nor3_1
Xfanout632 net633 net632 VPWR VGND sg13g2_buf_8
Xfanout610 _0684_ net610 VPWR VGND sg13g2_buf_8
Xfanout621 display_enable net621 VPWR VGND sg13g2_buf_1
Xfanout665 net666 net665 VPWR VGND sg13g2_buf_1
Xfanout676 net716 net676 VPWR VGND sg13g2_buf_8
Xfanout643 clk_video net643 VPWR VGND sg13g2_buf_8
Xfanout654 net661 net654 VPWR VGND sg13g2_buf_8
Xfanout687 net688 net687 VPWR VGND sg13g2_buf_8
Xfanout698 net704 net698 VPWR VGND sg13g2_buf_8
XFILLER_39_590 VPWR VGND sg13g2_decap_8
XFILLER_37_88 VPWR VGND sg13g2_fill_2
XFILLER_15_903 VPWR VGND sg13g2_decap_8
XFILLER_27_752 VPWR VGND sg13g2_decap_8
XFILLER_27_763 VPWR VGND sg13g2_fill_2
XFILLER_42_711 VPWR VGND sg13g2_decap_8
XFILLER_27_774 VPWR VGND sg13g2_decap_8
XFILLER_41_210 VPWR VGND sg13g2_decap_8
XFILLER_14_435 VPWR VGND sg13g2_decap_8
XFILLER_30_906 VPWR VGND sg13g2_fill_1
XFILLER_41_287 VPWR VGND sg13g2_fill_2
XFILLER_5_133 VPWR VGND sg13g2_decap_4
XFILLER_2_862 VPWR VGND sg13g2_decap_8
XFILLER_49_398 VPWR VGND sg13g2_decap_8
XFILLER_18_796 VPWR VGND sg13g2_decap_4
X_4870_ net691 net737 _0205_ VPWR VGND sg13g2_nor2_1
X_3821_ net609 VPWR _1474_ VGND videogen.test_lut_thingy.pixel_feeder_inst.row\[51\]\[3\]
+ net579 sg13g2_o21ai_1
XFILLER_20_449 VPWR VGND sg13g2_fill_2
XFILLER_32_298 VPWR VGND sg13g2_fill_1
X_3752_ net609 VPWR _1405_ VGND videogen.test_lut_thingy.pixel_feeder_inst.row\[51\]\[1\]
+ net579 sg13g2_o21ai_1
XFILLER_13_490 VPWR VGND sg13g2_fill_2
X_3683_ net630 VPWR _1336_ VGND videogen.test_lut_thingy.pixel_feeder_inst.row\[40\]\[2\]
+ net596 sg13g2_o21ai_1
X_2703_ videogen.fancy_shader.video_y\[3\] videogen.fancy_shader.video_y\[2\] _0709_
+ _0710_ VPWR VGND sg13g2_nor3_1
X_4304_ _0370_ _1946_ _1948_ VPWR VGND sg13g2_nand2_1
X_5284_ net305 VGND VPWR _0612_ videogen.test_lut_thingy.pixel_feeder_inst.row\[49\]\[0\]
+ _0241_ sg13g2_dfrbpq_1
X_4235_ _1877_ _1879_ _1881_ VPWR VGND sg13g2_and2_1
X_4166_ _1764_ VPWR _1812_ VGND _1809_ _1811_ sg13g2_o21ai_1
X_3117_ _0858_ net624 net623 VPWR VGND sg13g2_nand2b_1
XFILLER_28_538 VPWR VGND sg13g2_decap_8
X_4097_ _1549_ _1745_ _1746_ VPWR VGND sg13g2_and2_1
X_3048_ videogen.test_lut_thingy.pixel_feeder_inst.row\[36\]\[2\] net780 _0825_ _0335_
+ VPWR VGND sg13g2_mux2_1
XFILLER_36_560 VPWR VGND sg13g2_decap_8
XFILLER_11_405 VPWR VGND sg13g2_fill_1
XFILLER_12_928 VPWR VGND sg13g2_decap_8
X_4999_ net47 VGND VPWR _0331_ videogen.test_lut_thingy.pixel_feeder_inst.row\[35\]\[2\]
+ _0027_ sg13g2_dfrbpq_1
XFILLER_23_35 VPWR VGND sg13g2_decap_8
X_5016__427 VPWR VGND net427 sg13g2_tiehi
XFILLER_2_125 VPWR VGND sg13g2_fill_1
XFILLER_48_21 VPWR VGND sg13g2_decap_8
XFILLER_47_825 VPWR VGND sg13g2_decap_8
XFILLER_0_28 VPWR VGND sg13g2_decap_8
X_4988__69 VPWR VGND net69 sg13g2_tiehi
XFILLER_42_552 VPWR VGND sg13g2_fill_1
XFILLER_11_961 VPWR VGND sg13g2_decap_8
XFILLER_7_954 VPWR VGND sg13g2_decap_8
XFILLER_10_493 VPWR VGND sg13g2_fill_1
XFILLER_6_475 VPWR VGND sg13g2_fill_2
X_4020_ _1666_ _1667_ _1664_ _1669_ VPWR VGND sg13g2_nand3_1
XFILLER_49_195 VPWR VGND sg13g2_decap_8
X_4922_ net677 net722 _0255_ VPWR VGND sg13g2_nor2_1
X_5043__391 VPWR VGND net391 sg13g2_tiehi
XFILLER_21_703 VPWR VGND sg13g2_fill_1
XFILLER_33_541 VPWR VGND sg13g2_fill_2
X_4853_ net690 net734 _0188_ VPWR VGND sg13g2_nor2_1
X_3804_ videogen.test_lut_thingy.pixel_feeder_inst.row\[34\]\[3\] net585 _1457_ VPWR
+ VGND sg13g2_nor2_1
X_4784_ net675 net720 _0119_ VPWR VGND sg13g2_nor2_1
X_5150__206 VPWR VGND net206 sg13g2_tiehi
X_3735_ videogen.test_lut_thingy.pixel_feeder_inst.row\[4\]\[1\] net598 _1388_ VPWR
+ VGND sg13g2_nor2_1
X_3666_ net629 VPWR _1319_ VGND videogen.test_lut_thingy.pixel_feeder_inst.row\[62\]\[2\]
+ net582 sg13g2_o21ai_1
Xheichips25_bagel_28 VPWR VGND uio_oe[7] sg13g2_tielo
X_3597_ _1250_ _1180_ _1173_ _1179_ _1168_ VPWR VGND sg13g2_a22oi_1
XFILLER_0_618 VPWR VGND sg13g2_decap_8
X_5336_ net136 VGND VPWR _0664_ serialize.shift_reg_r\[6\] clknet_3_7_0_clk_regs sg13g2_dfrbpq_1
X_5267_ net66 VGND VPWR _0595_ videogen.test_lut_thingy.pixel_feeder_inst.row\[59\]\[3\]
+ _0224_ sg13g2_dfrbpq_1
X_4218_ _1862_ _1863_ _1864_ VPWR VGND sg13g2_nor2b_1
X_5198_ net40 VGND VPWR _0526_ videogen.test_lut_thingy.pixel_feeder_inst.row\[26\]\[2\]
+ _0155_ sg13g2_dfrbpq_1
X_4149_ VGND VPWR _1795_ _1794_ _1793_ sg13g2_or2_1
XFILLER_28_346 VPWR VGND sg13g2_decap_8
XFILLER_24_530 VPWR VGND sg13g2_decap_8
XFILLER_34_23 VPWR VGND sg13g2_fill_2
XFILLER_24_585 VPWR VGND sg13g2_decap_8
XFILLER_34_67 VPWR VGND sg13g2_decap_8
Xclkload0 VPWR clkload0/Y clknet_1_1__leaf_clk VGND sg13g2_inv_1
XFILLER_4_902 VPWR VGND sg13g2_decap_8
X_5001__43 VPWR VGND net43 sg13g2_tiehi
XFILLER_4_979 VPWR VGND sg13g2_decap_8
XFILLER_47_633 VPWR VGND sg13g2_decap_8
XFILLER_46_121 VPWR VGND sg13g2_fill_2
XFILLER_46_110 VPWR VGND sg13g2_decap_8
XFILLER_47_699 VPWR VGND sg13g2_decap_4
XFILLER_30_500 VPWR VGND sg13g2_decap_8
X_3520_ _1173_ _1168_ _1171_ VPWR VGND sg13g2_nand2_1
XFILLER_6_250 VPWR VGND sg13g2_decap_8
XFILLER_6_294 VPWR VGND sg13g2_fill_1
X_3451_ _1104_ _1055_ _1103_ VPWR VGND sg13g2_xnor2_1
X_3382_ VPWR VGND _1034_ _1032_ _1024_ videogen.fancy_shader.video_y\[3\] _1035_ videogen.fancy_shader.n646\[3\]
+ sg13g2_a221oi_1
X_4967__105 VPWR VGND net105 sg13g2_tiehi
X_5121_ net264 VGND VPWR _0449_ videogen.test_lut_thingy.pixel_feeder_inst.row\[6\]\[1\]
+ _0086_ sg13g2_dfrbpq_1
X_5052_ net378 VGND VPWR _0384_ green_tmds_par\[1\] net659 sg13g2_dfrbpq_1
XFILLER_38_633 VPWR VGND sg13g2_decap_4
X_4003_ _1254_ VPWR _0366_ VGND _1550_ _1652_ sg13g2_o21ai_1
XFILLER_25_305 VPWR VGND sg13g2_fill_2
XFILLER_21_522 VPWR VGND sg13g2_decap_8
X_4905_ net674 net720 _0240_ VPWR VGND sg13g2_nor2_1
XFILLER_33_382 VPWR VGND sg13g2_fill_2
XFILLER_34_883 VPWR VGND sg13g2_decap_8
XFILLER_34_894 VPWR VGND sg13g2_fill_2
X_4836_ net693 net737 _0171_ VPWR VGND sg13g2_nor2_1
X_4767_ net707 net754 _0102_ VPWR VGND sg13g2_nor2_1
XFILLER_21_599 VPWR VGND sg13g2_fill_2
X_4698_ net687 net732 _0035_ VPWR VGND sg13g2_nor2_1
X_3718_ videogen.test_lut_thingy.pixel_feeder_inst.row\[26\]\[1\] net586 _1371_ VPWR
+ VGND sg13g2_nor2_1
X_3649_ _1301_ VPWR _1302_ VGND _1265_ _1277_ sg13g2_o21ai_1
XFILLER_1_916 VPWR VGND sg13g2_decap_8
X_5319_ net342 VGND VPWR _0647_ serialize.shift_reg_b\[5\] clknet_3_2_0_clk_regs sg13g2_dfrbpq_1
Xhold12 _0280_ VPWR VGND net457 sg13g2_dlygate4sd3_1
Xhold23 _2244_ VPWR VGND net468 sg13g2_dlygate4sd3_1
Xhold34 serialize.shift_reg_r\[3\] VPWR VGND net479 sg13g2_dlygate4sd3_1
XFILLER_29_622 VPWR VGND sg13g2_decap_4
Xhold45 _2226_ VPWR VGND net490 sg13g2_dlygate4sd3_1
XFILLER_28_110 VPWR VGND sg13g2_fill_2
XFILLER_29_655 VPWR VGND sg13g2_decap_8
XFILLER_17_828 VPWR VGND sg13g2_decap_4
XFILLER_45_33 VPWR VGND sg13g2_decap_8
XFILLER_45_88 VPWR VGND sg13g2_fill_1
XFILLER_31_308 VPWR VGND sg13g2_fill_1
XFILLER_4_754 VPWR VGND sg13g2_fill_1
XFILLER_4_798 VPWR VGND sg13g2_decap_8
XFILLER_0_993 VPWR VGND sg13g2_decap_8
XFILLER_48_964 VPWR VGND sg13g2_decap_8
XFILLER_47_474 VPWR VGND sg13g2_decap_8
XFILLER_35_625 VPWR VGND sg13g2_fill_1
XFILLER_35_636 VPWR VGND sg13g2_decap_8
XFILLER_16_850 VPWR VGND sg13g2_fill_1
XFILLER_15_360 VPWR VGND sg13g2_decap_8
X_2951_ videogen.test_lut_thingy.pixel_feeder_inst.row\[62\]\[3\] net767 _0805_ _0471_
+ VPWR VGND sg13g2_mux2_1
X_5040__394 VPWR VGND net394 sg13g2_tiehi
XFILLER_30_330 VPWR VGND sg13g2_decap_8
XFILLER_31_853 VPWR VGND sg13g2_decap_8
X_4621_ VPWR _0643_ _2225_ VGND sg13g2_inv_1
X_2882_ videogen.test_lut_thingy.pixel_feeder_inst.row\[53\]\[0\] net807 _0789_ _0532_
+ VPWR VGND sg13g2_mux2_1
X_4552_ _2138_ _2167_ _2169_ VPWR VGND sg13g2_nor2_1
X_4483_ _2104_ _2102_ _2107_ VPWR VGND sg13g2_xor2_1
X_3503_ VPWR _1156_ _1155_ VGND sg13g2_inv_1
X_3434_ videogen.fancy_shader.video_x\[9\] videogen.fancy_shader.n646\[9\] _1087_
+ VPWR VGND sg13g2_xor2_1
X_3365_ _0714_ VPWR _1019_ VGND _0842_ _0892_ sg13g2_o21ai_1
X_5104_ net298 VGND VPWR _0432_ videogen.test_lut_thingy.pixel_feeder_inst.row\[31\]\[0\]
+ _0069_ sg13g2_dfrbpq_1
X_3296_ videogen.fancy_shader.video_x\[3\] videogen.fancy_shader.n646\[3\] _0970_
+ VPWR VGND sg13g2_xor2_1
XFILLER_39_942 VPWR VGND sg13g2_fill_1
X_5035_ net399 VGND VPWR _0367_ green\[0\] net656 sg13g2_dfrbpq_1
XFILLER_39_986 VPWR VGND sg13g2_decap_8
XFILLER_26_603 VPWR VGND sg13g2_decap_8
XFILLER_25_135 VPWR VGND sg13g2_decap_8
XFILLER_41_639 VPWR VGND sg13g2_fill_2
XFILLER_25_179 VPWR VGND sg13g2_fill_1
XFILLER_34_680 VPWR VGND sg13g2_decap_8
XFILLER_22_853 VPWR VGND sg13g2_fill_1
XFILLER_33_190 VPWR VGND sg13g2_decap_8
XFILLER_21_341 VPWR VGND sg13g2_fill_1
XFILLER_21_352 VPWR VGND sg13g2_decap_8
X_4819_ net699 net744 _0154_ VPWR VGND sg13g2_nor2_1
XFILLER_21_385 VPWR VGND sg13g2_decap_4
XFILLER_31_68 VPWR VGND sg13g2_decap_8
Xoutput13 net13 uo_out[0] VPWR VGND sg13g2_buf_1
XFILLER_0_223 VPWR VGND sg13g2_fill_2
XFILLER_1_779 VPWR VGND sg13g2_decap_8
XFILLER_45_934 VPWR VGND sg13g2_decap_8
XFILLER_25_680 VPWR VGND sg13g2_decap_4
XFILLER_40_672 VPWR VGND sg13g2_fill_2
XFILLER_40_694 VPWR VGND sg13g2_fill_2
XFILLER_39_216 VPWR VGND sg13g2_fill_2
X_3150_ _0850_ _0878_ _0001_ VPWR VGND sg13g2_nor2_1
X_4964__108 VPWR VGND net108 sg13g2_tiehi
XFILLER_39_227 VPWR VGND sg13g2_fill_1
X_3081_ videogen.fancy_shader.video_x\[9\] videogen.fancy_shader.video_x\[8\] _0832_
+ VPWR VGND sg13g2_and2_1
XFILLER_0_790 VPWR VGND sg13g2_decap_8
XFILLER_11_4 VPWR VGND sg13g2_fill_2
XFILLER_36_901 VPWR VGND sg13g2_decap_4
XFILLER_47_282 VPWR VGND sg13g2_fill_2
Xclkbuf_3_6_0_clk_regs clknet_0_clk_regs clknet_3_6_0_clk_regs VPWR VGND sg13g2_buf_8
XFILLER_23_617 VPWR VGND sg13g2_fill_2
XFILLER_35_488 VPWR VGND sg13g2_decap_4
X_3983_ net607 VPWR _1635_ VGND videogen.test_lut_thingy.pixel_feeder_inst.row\[33\]\[0\]
+ net563 sg13g2_o21ai_1
X_2934_ videogen.test_lut_thingy.pixel_feeder_inst.row\[60\]\[3\] net768 _0800_ _0483_
+ VPWR VGND sg13g2_mux2_1
X_2865_ videogen.test_lut_thingy.pixel_feeder_inst.row\[50\]\[2\] net786 _0786_ _0546_
+ VPWR VGND sg13g2_mux2_1
XFILLER_11_1003 VPWR VGND sg13g2_decap_8
X_4604_ _2215_ blue\[6\] _2209_ VPWR VGND sg13g2_xnor2_1
XFILLER_8_890 VPWR VGND sg13g2_decap_8
X_2796_ videogen.test_lut_thingy.pixel_feeder_inst.row\[59\]\[3\] net768 _0766_ _0595_
+ VPWR VGND sg13g2_mux2_1
X_4535_ _2150_ _2151_ _2149_ _2152_ VPWR VGND sg13g2_nand3_1
X_4466_ net615 green\[7\] _2091_ VPWR VGND sg13g2_nor2b_1
X_3417_ _1067_ _1068_ _1052_ _1070_ VPWR VGND sg13g2_nand3_1
Xfanout814 net815 net814 VPWR VGND sg13g2_buf_8
Xfanout803 net804 net803 VPWR VGND sg13g2_buf_8
X_4397_ _2036_ _2034_ _2035_ VPWR VGND sg13g2_nand2b_1
X_3348_ _1008_ videogen.fancy_shader.video_y\[7\] _1009_ VPWR VGND sg13g2_xor2_1
X_3279_ VGND VPWR _0682_ _0953_ _0338_ _0955_ sg13g2_a21oi_1
X_5018_ net423 VGND VPWR _0350_ videogen.fancy_shader.video_y\[3\] net648 sg13g2_dfrbpq_2
XFILLER_26_35 VPWR VGND sg13g2_decap_8
XFILLER_26_46 VPWR VGND sg13g2_fill_1
XFILLER_42_78 VPWR VGND sg13g2_decap_8
XFILLER_10_867 VPWR VGND sg13g2_decap_8
XFILLER_5_337 VPWR VGND sg13g2_fill_1
XFILLER_1_565 VPWR VGND sg13g2_decap_8
XFILLER_49_525 VPWR VGND sg13g2_decap_8
XFILLER_45_731 VPWR VGND sg13g2_decap_8
XFILLER_18_923 VPWR VGND sg13g2_decap_8
XFILLER_17_444 VPWR VGND sg13g2_decap_4
XFILLER_17_499 VPWR VGND sg13g2_fill_1
XFILLER_32_447 VPWR VGND sg13g2_decap_8
XFILLER_33_948 VPWR VGND sg13g2_decap_8
XFILLER_20_609 VPWR VGND sg13g2_fill_1
XFILLER_8_120 VPWR VGND sg13g2_decap_8
X_4320_ red\[4\] red\[6\] _1961_ VPWR VGND sg13g2_nor2_1
X_4251_ _1897_ _1698_ _1756_ VPWR VGND sg13g2_xnor2_1
X_3202_ _0709_ _0859_ _0708_ _0901_ VPWR VGND _0900_ sg13g2_nand4_1
X_4182_ _1828_ _1803_ _1812_ VPWR VGND sg13g2_xnor2_1
X_3133_ VGND VPWR _0863_ _0871_ net18 _0864_ sg13g2_a21oi_1
XFILLER_28_709 VPWR VGND sg13g2_fill_1
X_3064_ videogen.test_lut_thingy.pixel_feeder_inst.row\[20\]\[1\] net790 _0828_ _0291_
+ VPWR VGND sg13g2_mux2_1
XFILLER_24_926 VPWR VGND sg13g2_decap_8
XFILLER_23_447 VPWR VGND sg13g2_fill_1
X_3966_ net629 VPWR _1618_ VGND _1615_ _1617_ sg13g2_o21ai_1
XFILLER_23_469 VPWR VGND sg13g2_fill_1
X_2917_ net801 videogen.test_lut_thingy.pixel_feeder_inst.row\[56\]\[0\] _0796_ _0496_
+ VPWR VGND sg13g2_mux2_1
X_3897_ _1550_ _1547_ _1549_ VPWR VGND sg13g2_nand2_2
X_2848_ _0783_ _0755_ VPWR VGND _0770_ sg13g2_nand2b_2
XFILLER_3_819 VPWR VGND sg13g2_decap_8
X_2779_ videogen.test_lut_thingy.pixel_feeder_inst.row\[19\]\[0\] net805 _0758_ _0604_
+ VPWR VGND sg13g2_mux2_1
X_4518_ tmds_blue.dc_balancing_reg\[0\] tmds_blue.dc_balancing_reg\[1\] tmds_blue.dc_balancing_reg\[3\]
+ _2136_ VGND VPWR tmds_blue.dc_balancing_reg\[2\] sg13g2_nor4_2
X_4449_ tmds_green.dc_balancing_reg\[1\] _2060_ _2075_ VPWR VGND sg13g2_nor2_2
Xfanout633 videogen.test_lut_thingy.pixel_feeder_inst.h_pix\[3\] net633 VPWR VGND
+ sg13g2_buf_8
Xfanout611 _0684_ net611 VPWR VGND sg13g2_buf_8
Xfanout600 net603 net600 VPWR VGND sg13g2_buf_8
Xfanout622 display_enable net622 VPWR VGND sg13g2_buf_8
Xfanout644 clk_video net644 VPWR VGND sg13g2_buf_1
Xfanout655 net661 net655 VPWR VGND sg13g2_buf_8
Xfanout666 _0883_ net666 VPWR VGND sg13g2_buf_8
Xfanout688 net694 net688 VPWR VGND sg13g2_buf_8
Xfanout677 net681 net677 VPWR VGND sg13g2_buf_8
Xfanout699 net704 net699 VPWR VGND sg13g2_buf_8
XFILLER_37_45 VPWR VGND sg13g2_decap_4
XFILLER_2_1023 VPWR VGND sg13g2_decap_4
XFILLER_37_78 VPWR VGND sg13g2_decap_4
XFILLER_26_230 VPWR VGND sg13g2_fill_2
XFILLER_27_731 VPWR VGND sg13g2_decap_8
X_5060__364 VPWR VGND net364 sg13g2_tiehi
XFILLER_42_701 VPWR VGND sg13g2_decap_4
XFILLER_26_263 VPWR VGND sg13g2_decap_4
XFILLER_15_959 VPWR VGND sg13g2_decap_8
XFILLER_10_631 VPWR VGND sg13g2_decap_8
XFILLER_10_653 VPWR VGND sg13g2_fill_2
XFILLER_2_841 VPWR VGND sg13g2_decap_8
XFILLER_49_377 VPWR VGND sg13g2_decap_8
XFILLER_18_731 VPWR VGND sg13g2_decap_8
X_5106__294 VPWR VGND net294 sg13g2_tiehi
XFILLER_32_200 VPWR VGND sg13g2_fill_1
XFILLER_32_211 VPWR VGND sg13g2_fill_1
XFILLER_21_929 VPWR VGND sg13g2_decap_8
X_3820_ net627 _1461_ _1472_ _1473_ VPWR VGND sg13g2_nor3_1
X_3751_ _1400_ _1401_ _1402_ _1403_ _1404_ VPWR VGND sg13g2_nor4_1
XFILLER_14_981 VPWR VGND sg13g2_decap_8
X_2702_ VGND VPWR _0709_ videogen.fancy_shader.video_y\[0\] videogen.fancy_shader.video_y\[1\]
+ sg13g2_or2_1
X_3682_ net607 _1329_ _1334_ _1335_ VPWR VGND sg13g2_nor3_1
X_4303_ _1948_ _1646_ _1947_ VPWR VGND sg13g2_nand2_1
X_5283_ net313 VGND VPWR _0611_ videogen.test_lut_thingy.pixel_feeder_inst.row\[39\]\[3\]
+ _0240_ sg13g2_dfrbpq_1
X_4234_ _1880_ _1871_ _1876_ VPWR VGND sg13g2_xnor2_1
X_4165_ VGND VPWR _1791_ _1798_ _1811_ _1810_ sg13g2_a21oi_1
X_3116_ _0857_ videogen.fancy_shader.video_y\[3\] videogen.fancy_shader.video_y\[2\]
+ VPWR VGND sg13g2_nand2_1
XFILLER_28_528 VPWR VGND sg13g2_fill_1
X_4096_ _1745_ _1351_ _1547_ VPWR VGND sg13g2_nand2_1
X_3047_ videogen.test_lut_thingy.pixel_feeder_inst.row\[36\]\[3\] net770 _0825_ _0336_
+ VPWR VGND sg13g2_mux2_1
XFILLER_23_200 VPWR VGND sg13g2_decap_4
XFILLER_24_723 VPWR VGND sg13g2_decap_8
XFILLER_12_907 VPWR VGND sg13g2_decap_8
XFILLER_24_767 VPWR VGND sg13g2_fill_2
X_4998_ net49 VGND VPWR _0330_ videogen.test_lut_thingy.pixel_feeder_inst.row\[35\]\[1\]
+ _0026_ sg13g2_dfrbpq_1
XFILLER_23_25 VPWR VGND sg13g2_decap_4
X_5157__192 VPWR VGND net192 sg13g2_tiehi
X_3949_ videogen.test_lut_thingy.pixel_feeder_inst.row\[53\]\[0\] net569 _1601_ VPWR
+ VGND sg13g2_nor2_1
XFILLER_20_984 VPWR VGND sg13g2_decap_8
XFILLER_2_104 VPWR VGND sg13g2_decap_8
XFILLER_2_137 VPWR VGND sg13g2_decap_8
XFILLER_2_148 VPWR VGND sg13g2_fill_2
X_5182__92 VPWR VGND net92 sg13g2_tiehi
X_5164__174 VPWR VGND net174 sg13g2_tiehi
XFILLER_24_1024 VPWR VGND sg13g2_decap_4
XFILLER_19_517 VPWR VGND sg13g2_decap_8
XFILLER_46_347 VPWR VGND sg13g2_decap_8
XFILLER_14_233 VPWR VGND sg13g2_fill_1
XFILLER_14_277 VPWR VGND sg13g2_fill_1
XFILLER_14_288 VPWR VGND sg13g2_fill_2
XFILLER_11_940 VPWR VGND sg13g2_decap_8
XFILLER_7_933 VPWR VGND sg13g2_decap_8
XFILLER_49_152 VPWR VGND sg13g2_decap_4
X_4921_ net677 net722 _0254_ VPWR VGND sg13g2_nor2_1
X_4852_ net689 net734 _0187_ VPWR VGND sg13g2_nor2_1
X_3803_ net607 VPWR _1456_ VGND videogen.test_lut_thingy.pixel_feeder_inst.row\[32\]\[3\]
+ net595 sg13g2_o21ai_1
XFILLER_21_737 VPWR VGND sg13g2_decap_8
X_4783_ net675 net720 _0118_ VPWR VGND sg13g2_nor2_1
XFILLER_20_236 VPWR VGND sg13g2_fill_2
X_3734_ videogen.test_lut_thingy.pixel_feeder_inst.row\[7\]\[1\] net576 _1387_ VPWR
+ VGND sg13g2_nor2_1
X_3665_ _1314_ _1315_ _1316_ _1317_ _1318_ VPWR VGND sg13g2_nor4_1
Xheichips25_bagel_29 VPWR VGND uio_out[1] sg13g2_tielo
X_3596_ _1249_ _1248_ _1243_ _1247_ _1246_ VPWR VGND sg13g2_a22oi_1
X_5335_ net161 VGND VPWR _0663_ serialize.shift_reg_r\[5\] clknet_3_4_0_clk_regs sg13g2_dfrbpq_1
X_5266_ net74 VGND VPWR _0594_ videogen.test_lut_thingy.pixel_feeder_inst.row\[59\]\[2\]
+ _0223_ sg13g2_dfrbpq_1
X_4217_ _1672_ _1778_ _1671_ _1863_ VPWR VGND sg13g2_nand3_1
X_5197_ net44 VGND VPWR _0525_ videogen.test_lut_thingy.pixel_feeder_inst.row\[26\]\[1\]
+ _0154_ sg13g2_dfrbpq_1
X_4148_ _1783_ _1785_ _1794_ VPWR VGND sg13g2_nor2_1
X_4944__139 VPWR VGND net139 sg13g2_tiehi
X_4079_ _1711_ VPWR _1728_ VGND _1716_ _1720_ sg13g2_o21ai_1
XFILLER_37_892 VPWR VGND sg13g2_decap_8
XFILLER_11_203 VPWR VGND sg13g2_decap_8
XFILLER_24_575 VPWR VGND sg13g2_decap_4
XFILLER_11_225 VPWR VGND sg13g2_decap_4
XFILLER_12_759 VPWR VGND sg13g2_decap_8
XFILLER_7_218 VPWR VGND sg13g2_decap_4
XFILLER_11_258 VPWR VGND sg13g2_decap_8
Xclkload1 VPWR clkload1/Y clknet_3_1_0_clk_regs VGND sg13g2_inv_1
XFILLER_20_792 VPWR VGND sg13g2_decap_4
XFILLER_4_958 VPWR VGND sg13g2_decap_8
XFILLER_47_612 VPWR VGND sg13g2_decap_8
XFILLER_27_391 VPWR VGND sg13g2_decap_4
XFILLER_43_895 VPWR VGND sg13g2_fill_1
XFILLER_24_90 VPWR VGND sg13g2_fill_2
X_3450_ VGND VPWR _1057_ _1098_ _1103_ _1056_ sg13g2_a21oi_1
X_3381_ _1026_ _1033_ _1034_ VPWR VGND sg13g2_and2_1
X_5120_ net266 VGND VPWR _0448_ videogen.test_lut_thingy.pixel_feeder_inst.row\[6\]\[0\]
+ _0085_ sg13g2_dfrbpq_1
X_5051_ net379 VGND VPWR _0383_ green_tmds_par\[0\] net659 sg13g2_dfrbpq_1
XFILLER_27_2 VPWR VGND sg13g2_fill_1
X_4002_ _1450_ _1646_ _1652_ VPWR VGND sg13g2_nor2_1
XFILLER_38_656 VPWR VGND sg13g2_fill_1
XFILLER_26_829 VPWR VGND sg13g2_decap_8
XFILLER_21_501 VPWR VGND sg13g2_fill_2
X_4904_ net682 net727 _0239_ VPWR VGND sg13g2_nor2_1
X_4835_ net693 net737 _0170_ VPWR VGND sg13g2_nor2_1
X_4766_ net712 net759 _0101_ VPWR VGND sg13g2_nor2_1
X_4975__95 VPWR VGND net95 sg13g2_tiehi
XFILLER_14_1023 VPWR VGND sg13g2_decap_4
X_3717_ videogen.test_lut_thingy.pixel_feeder_inst.row\[27\]\[1\] net575 _1370_ VPWR
+ VGND sg13g2_nor2_1
X_4697_ net688 net731 _0034_ VPWR VGND sg13g2_nor2_1
X_4990__65 VPWR VGND net65 sg13g2_tiehi
X_3648_ net625 _1300_ _1301_ VPWR VGND sg13g2_nor2_1
X_3579_ _1232_ _1029_ _1226_ VPWR VGND sg13g2_nand2_1
X_5318_ net350 VGND VPWR _0646_ serialize.shift_reg_b\[4\] clknet_3_1_0_clk_regs sg13g2_dfrbpq_1
XFILLER_48_409 VPWR VGND sg13g2_decap_8
Xhold13 serialize.shift_reg_c\[6\] VPWR VGND net458 sg13g2_dlygate4sd3_1
XFILLER_29_35 VPWR VGND sg13g2_fill_2
X_5249_ net211 VGND VPWR _0577_ videogen.test_lut_thingy.pixel_feeder_inst.row\[42\]\[1\]
+ _0206_ sg13g2_dfrbpq_1
Xhold35 serialize.shift_reg_g\[2\] VPWR VGND net480 sg13g2_dlygate4sd3_1
X_5306__165 VPWR VGND net165 sg13g2_tiehi
Xhold46 clockdiv.q0 VPWR VGND net491 sg13g2_dlygate4sd3_1
Xhold24 serialize.shift_reg_r\[4\] VPWR VGND net469 sg13g2_dlygate4sd3_1
XFILLER_21_1027 VPWR VGND sg13g2_fill_2
XFILLER_43_125 VPWR VGND sg13g2_decap_8
XFILLER_43_158 VPWR VGND sg13g2_fill_2
XFILLER_12_512 VPWR VGND sg13g2_decap_8
X_5237__259 VPWR VGND net259 sg13g2_tiehi
XFILLER_8_516 VPWR VGND sg13g2_decap_8
XFILLER_6_39 VPWR VGND sg13g2_decap_4
XFILLER_4_788 VPWR VGND sg13g2_fill_2
X_5029__405 VPWR VGND net405 sg13g2_tiehi
XFILLER_0_972 VPWR VGND sg13g2_decap_8
XFILLER_48_943 VPWR VGND sg13g2_decap_8
XFILLER_13_8 VPWR VGND sg13g2_decap_4
XFILLER_19_90 VPWR VGND sg13g2_fill_1
XFILLER_19_155 VPWR VGND sg13g2_decap_8
XFILLER_37_1023 VPWR VGND sg13g2_decap_4
XFILLER_16_884 VPWR VGND sg13g2_fill_1
X_2950_ _0761_ _0763_ _0805_ VPWR VGND sg13g2_nor2b_2
XFILLER_42_180 VPWR VGND sg13g2_decap_4
XFILLER_30_320 VPWR VGND sg13g2_decap_4
X_2881_ videogen.test_lut_thingy.pixel_feeder_inst.row\[53\]\[1\] net797 _0789_ _0533_
+ VPWR VGND sg13g2_mux2_1
X_4620_ _2225_ net663 net476 net668 blue_tmds_par\[1\] VPWR VGND sg13g2_a22oi_1
XFILLER_30_342 VPWR VGND sg13g2_decap_8
XFILLER_30_353 VPWR VGND sg13g2_fill_1
X_4551_ _2168_ net618 _2165_ VPWR VGND sg13g2_nand2_1
X_4482_ _2104_ _2102_ _2106_ VPWR VGND sg13g2_nor2b_1
XFILLER_7_571 VPWR VGND sg13g2_fill_1
X_3502_ VGND VPWR _1143_ _1155_ _1151_ _1149_ sg13g2_a21oi_2
X_3433_ VGND VPWR _1074_ _1085_ _1086_ _1073_ sg13g2_a21oi_1
X_5103_ net300 VGND VPWR _0431_ videogen.test_lut_thingy.pixel_feeder_inst.row\[9\]\[3\]
+ _0068_ sg13g2_dfrbpq_1
XFILLER_44_1027 VPWR VGND sg13g2_fill_2
X_3364_ VGND VPWR _0695_ _1016_ _0360_ _1018_ sg13g2_a21oi_1
XFILLER_32_0 VPWR VGND sg13g2_decap_4
X_3295_ VGND VPWR _0969_ videogen.fancy_shader.video_x\[3\] videogen.fancy_shader.n646\[3\]
+ sg13g2_or2_1
X_5034_ net400 VGND VPWR _0366_ blue\[7\] net650 sg13g2_dfrbpq_2
XFILLER_25_103 VPWR VGND sg13g2_fill_1
XFILLER_40_117 VPWR VGND sg13g2_fill_1
XFILLER_22_810 VPWR VGND sg13g2_decap_4
X_5336__136 VPWR VGND net136 sg13g2_tiehi
X_5314__412 VPWR VGND net412 sg13g2_tiehi
X_4818_ net697 net742 _0153_ VPWR VGND sg13g2_nor2_1
XFILLER_22_898 VPWR VGND sg13g2_decap_8
XFILLER_31_14 VPWR VGND sg13g2_decap_4
X_4749_ net713 net758 _0084_ VPWR VGND sg13g2_nor2_1
XFILLER_5_519 VPWR VGND sg13g2_fill_2
Xoutput14 net14 uo_out[1] VPWR VGND sg13g2_buf_1
XFILLER_0_213 VPWR VGND sg13g2_decap_4
XFILLER_5_1021 VPWR VGND sg13g2_decap_8
XFILLER_45_913 VPWR VGND sg13g2_decap_8
XFILLER_17_604 VPWR VGND sg13g2_fill_1
XFILLER_44_412 VPWR VGND sg13g2_fill_2
XFILLER_29_486 VPWR VGND sg13g2_fill_1
XFILLER_40_651 VPWR VGND sg13g2_fill_2
XFILLER_12_353 VPWR VGND sg13g2_decap_8
XFILLER_13_865 VPWR VGND sg13g2_decap_8
XFILLER_9_869 VPWR VGND sg13g2_decap_8
XFILLER_8_368 VPWR VGND sg13g2_fill_2
XFILLER_8_357 VPWR VGND sg13g2_decap_8
XFILLER_4_552 VPWR VGND sg13g2_decap_8
X_3080_ videogen.test_lut_thingy.pixel_feeder_inst.row\[1\]\[0\] net808 _0831_ _0271_
+ VPWR VGND sg13g2_mux2_1
XFILLER_35_445 VPWR VGND sg13g2_fill_1
XFILLER_16_670 VPWR VGND sg13g2_fill_2
X_3982_ _1630_ _1631_ _1632_ _1633_ _1634_ VPWR VGND sg13g2_nor4_1
X_2933_ _0764_ _0777_ _0800_ VPWR VGND sg13g2_nor2_2
XFILLER_16_692 VPWR VGND sg13g2_decap_8
X_2864_ videogen.test_lut_thingy.pixel_feeder_inst.row\[50\]\[3\] net775 _0786_ _0547_
+ VPWR VGND sg13g2_mux2_1
X_2795_ _0757_ _0764_ _0766_ VPWR VGND sg13g2_nor2_2
X_4603_ _2214_ _2142_ VPWR VGND _2138_ sg13g2_nand2b_2
X_5116__274 VPWR VGND net274 sg13g2_tiehi
X_4534_ net619 blue\[7\] blue\[1\] _2151_ VPWR VGND blue\[6\] sg13g2_nand4_1
X_4465_ _2089_ VPWR _2090_ VGND _2087_ _2088_ sg13g2_o21ai_1
X_3416_ _1069_ _1052_ _1067_ _1068_ VPWR VGND sg13g2_and3_1
Xfanout804 ui_in[4] net804 VPWR VGND sg13g2_buf_8
Xfanout815 rst_n net815 VPWR VGND sg13g2_buf_2
X_4396_ VGND VPWR _2000_ _2001_ _2035_ _2003_ sg13g2_a21oi_1
X_3347_ _0353_ net811 _1007_ _1008_ VPWR VGND sg13g2_and3_1
X_5268__58 VPWR VGND net58 sg13g2_tiehi
X_5017_ net425 VGND VPWR _0349_ videogen.fancy_shader.video_y\[2\] net648 sg13g2_dfrbpq_2
X_3278_ _0955_ net812 _0954_ VPWR VGND sg13g2_nand2_1
XFILLER_26_58 VPWR VGND sg13g2_decap_4
XFILLER_13_117 VPWR VGND sg13g2_decap_8
XFILLER_10_835 VPWR VGND sg13g2_decap_8
X_5189__76 VPWR VGND net76 sg13g2_tiehi
XFILLER_10_846 VPWR VGND sg13g2_fill_1
XFILLER_5_316 VPWR VGND sg13g2_decap_4
XFILLER_3_18 VPWR VGND sg13g2_decap_8
XFILLER_1_533 VPWR VGND sg13g2_decap_8
XFILLER_1_544 VPWR VGND sg13g2_fill_2
XFILLER_27_1011 VPWR VGND sg13g2_decap_8
XFILLER_49_504 VPWR VGND sg13g2_decap_8
X_5026__408 VPWR VGND net408 sg13g2_tiehi
XFILLER_18_902 VPWR VGND sg13g2_decap_8
XFILLER_29_250 VPWR VGND sg13g2_fill_1
XFILLER_18_979 VPWR VGND sg13g2_decap_8
XFILLER_13_640 VPWR VGND sg13g2_fill_1
XFILLER_12_161 VPWR VGND sg13g2_decap_8
XFILLER_34_1026 VPWR VGND sg13g2_fill_2
XFILLER_8_143 VPWR VGND sg13g2_decap_8
X_4970__102 VPWR VGND net102 sg13g2_tiehi
XFILLER_9_688 VPWR VGND sg13g2_decap_8
X_4250_ _1896_ _1892_ _1894_ VPWR VGND sg13g2_nand2b_1
X_3201_ videogen.fancy_shader.video_y\[2\] videogen.fancy_shader.video_y\[3\] _0900_
+ VPWR VGND sg13g2_nor2b_1
X_4181_ _1758_ _1814_ _1825_ _1827_ VPWR VGND sg13g2_nor3_1
X_3132_ _0871_ _0686_ _0867_ VPWR VGND sg13g2_xnor2_1
X_3063_ videogen.test_lut_thingy.pixel_feeder_inst.row\[20\]\[2\] net779 _0828_ _0292_
+ VPWR VGND sg13g2_mux2_1
XFILLER_48_592 VPWR VGND sg13g2_decap_8
XFILLER_35_297 VPWR VGND sg13g2_fill_1
X_3965_ _1616_ VPWR _1617_ VGND videogen.test_lut_thingy.pixel_feeder_inst.row\[63\]\[0\]
+ net571 sg13g2_o21ai_1
X_2916_ net790 videogen.test_lut_thingy.pixel_feeder_inst.row\[56\]\[1\] _0796_ _0497_
+ VPWR VGND sg13g2_mux2_1
X_3896_ net765 net1 _1549_ VPWR VGND sg13g2_nor2_1
XFILLER_31_470 VPWR VGND sg13g2_decap_4
X_2847_ videogen.test_lut_thingy.pixel_feeder_inst.row\[46\]\[0\] net802 _0782_ _0560_
+ VPWR VGND sg13g2_mux2_1
XFILLER_12_38 VPWR VGND sg13g2_decap_4
X_2778_ videogen.test_lut_thingy.pixel_feeder_inst.row\[19\]\[1\] net794 _0758_ _0605_
+ VPWR VGND sg13g2_mux2_1
X_4517_ VGND VPWR _2058_ _2135_ _0511_ net765 sg13g2_a21oi_1
XFILLER_2_308 VPWR VGND sg13g2_decap_8
XFILLER_2_319 VPWR VGND sg13g2_fill_1
X_4448_ net764 _2074_ _0419_ VPWR VGND sg13g2_nor2_1
Xfanout623 videogen.fancy_shader.video_y\[5\] net623 VPWR VGND sg13g2_buf_8
Xfanout612 _0684_ net612 VPWR VGND sg13g2_buf_8
Xfanout601 net603 net601 VPWR VGND sg13g2_buf_1
Xfanout645 net646 net645 VPWR VGND sg13g2_buf_8
Xfanout634 net638 net634 VPWR VGND sg13g2_buf_8
X_4379_ VPWR VGND _2013_ _2016_ _2018_ _2005_ _2019_ _2017_ sg13g2_a221oi_1
Xfanout656 net657 net656 VPWR VGND sg13g2_buf_8
Xfanout667 net668 net667 VPWR VGND sg13g2_buf_8
XFILLER_46_507 VPWR VGND sg13g2_fill_2
Xfanout689 net694 net689 VPWR VGND sg13g2_buf_8
XFILLER_37_24 VPWR VGND sg13g2_decap_8
Xfanout678 net681 net678 VPWR VGND sg13g2_buf_2
XFILLER_2_1002 VPWR VGND sg13g2_decap_8
XFILLER_37_68 VPWR VGND sg13g2_decap_4
XFILLER_15_938 VPWR VGND sg13g2_decap_8
XFILLER_41_256 VPWR VGND sg13g2_decap_4
XFILLER_14_459 VPWR VGND sg13g2_decap_8
XFILLER_41_289 VPWR VGND sg13g2_fill_1
XFILLER_23_993 VPWR VGND sg13g2_decap_8
XFILLER_10_665 VPWR VGND sg13g2_decap_8
XFILLER_6_647 VPWR VGND sg13g2_fill_1
XFILLER_5_179 VPWR VGND sg13g2_decap_4
XFILLER_5_168 VPWR VGND sg13g2_decap_4
XFILLER_2_820 VPWR VGND sg13g2_decap_8
XFILLER_49_323 VPWR VGND sg13g2_fill_1
XFILLER_49_312 VPWR VGND sg13g2_decap_8
XFILLER_2_897 VPWR VGND sg13g2_decap_8
XFILLER_49_356 VPWR VGND sg13g2_decap_8
XFILLER_37_529 VPWR VGND sg13g2_decap_8
XFILLER_45_584 VPWR VGND sg13g2_decap_8
XFILLER_17_297 VPWR VGND sg13g2_decap_4
XFILLER_14_960 VPWR VGND sg13g2_decap_8
XFILLER_21_908 VPWR VGND sg13g2_decap_8
X_5270__42 VPWR VGND net42 sg13g2_tiehi
XFILLER_32_256 VPWR VGND sg13g2_decap_4
X_3750_ videogen.test_lut_thingy.pixel_feeder_inst.row\[52\]\[1\] net602 _1403_ VPWR
+ VGND sg13g2_nor2_1
XFILLER_20_407 VPWR VGND sg13g2_decap_8
XFILLER_13_481 VPWR VGND sg13g2_fill_1
XFILLER_13_492 VPWR VGND sg13g2_fill_1
X_2701_ net624 _0707_ _0708_ VPWR VGND sg13g2_nor2b_1
XFILLER_9_474 VPWR VGND sg13g2_decap_8
XFILLER_9_485 VPWR VGND sg13g2_decap_4
X_3681_ _1330_ _1331_ _1332_ _1333_ _1334_ VPWR VGND sg13g2_nor4_1
X_4302_ _1550_ _1648_ _1947_ VPWR VGND sg13g2_nor2_1
X_5282_ net330 VGND VPWR _0610_ videogen.test_lut_thingy.pixel_feeder_inst.row\[39\]\[2\]
+ _0239_ sg13g2_dfrbpq_1
XFILLER_4_50 VPWR VGND sg13g2_decap_4
X_4233_ _1871_ _1878_ _1879_ VPWR VGND sg13g2_and2_1
X_4164_ VGND VPWR _1798_ _1799_ _1810_ _1791_ sg13g2_a21oi_1
X_3115_ _0704_ net556 _0856_ VPWR VGND sg13g2_and2_1
X_4095_ _1253_ VPWR _1744_ VGND _1742_ _1743_ sg13g2_o21ai_1
X_3046_ _0754_ _0778_ _0825_ VPWR VGND sg13g2_nor2_2
XFILLER_36_595 VPWR VGND sg13g2_decap_4
XFILLER_23_234 VPWR VGND sg13g2_decap_8
XFILLER_23_245 VPWR VGND sg13g2_fill_1
X_4997_ net51 VGND VPWR _0329_ videogen.test_lut_thingy.pixel_feeder_inst.row\[35\]\[0\]
+ _0025_ sg13g2_dfrbpq_1
XFILLER_23_15 VPWR VGND sg13g2_fill_2
X_3948_ videogen.test_lut_thingy.pixel_feeder_inst.row\[54\]\[0\] net590 _1600_ VPWR
+ VGND sg13g2_nor2_1
X_3879_ net631 VPWR _1532_ VGND videogen.test_lut_thingy.pixel_feeder_inst.row\[9\]\[3\]
+ net568 sg13g2_o21ai_1
XFILLER_20_963 VPWR VGND sg13g2_decap_8
XFILLER_24_1003 VPWR VGND sg13g2_decap_8
XFILLER_46_326 VPWR VGND sg13g2_fill_2
XFILLER_42_565 VPWR VGND sg13g2_decap_8
XFILLER_30_749 VPWR VGND sg13g2_fill_2
XFILLER_7_912 VPWR VGND sg13g2_decap_8
XFILLER_10_451 VPWR VGND sg13g2_decap_8
XFILLER_31_1018 VPWR VGND sg13g2_decap_8
XFILLER_11_996 VPWR VGND sg13g2_decap_8
XFILLER_7_989 VPWR VGND sg13g2_decap_8
XFILLER_49_131 VPWR VGND sg13g2_decap_8
XFILLER_45_381 VPWR VGND sg13g2_fill_1
X_4920_ net678 net723 _0253_ VPWR VGND sg13g2_nor2_1
XFILLER_33_510 VPWR VGND sg13g2_decap_4
X_4851_ net689 net734 _0186_ VPWR VGND sg13g2_nor2_1
X_4987__71 VPWR VGND net71 sg13g2_tiehi
X_3802_ _1451_ _1452_ _1453_ _1454_ _1455_ VPWR VGND sg13g2_nor4_1
X_4782_ net679 net725 _0117_ VPWR VGND sg13g2_nor2_1
X_3733_ net636 VPWR _1386_ VGND videogen.test_lut_thingy.pixel_feeder_inst.row\[6\]\[1\]
+ net587 sg13g2_o21ai_1
XFILLER_9_271 VPWR VGND sg13g2_decap_4
X_3664_ videogen.test_lut_thingy.pixel_feeder_inst.row\[53\]\[2\] net569 _1317_ VPWR
+ VGND sg13g2_nor2_1
X_3595_ _1171_ _1234_ _1239_ _1248_ VPWR VGND sg13g2_nor3_1
X_5230__287 VPWR VGND net287 sg13g2_tiehi
XFILLER_47_1014 VPWR VGND sg13g2_decap_8
X_5334_ net169 VGND VPWR _0662_ serialize.shift_reg_r\[4\] clknet_3_5_0_clk_regs sg13g2_dfrbpq_1
X_5265_ net98 VGND VPWR _0593_ videogen.test_lut_thingy.pixel_feeder_inst.row\[59\]\[1\]
+ _0222_ sg13g2_dfrbpq_1
X_5196_ net48 VGND VPWR _0524_ videogen.test_lut_thingy.pixel_feeder_inst.row\[26\]\[0\]
+ _0153_ sg13g2_dfrbpq_1
X_4216_ VGND VPWR _1671_ _1672_ _1862_ _1778_ sg13g2_a21oi_1
X_4147_ _1793_ _1783_ _1785_ _1792_ VPWR VGND sg13g2_and3_1
XFILLER_29_838 VPWR VGND sg13g2_fill_2
XFILLER_18_48 VPWR VGND sg13g2_fill_1
XFILLER_28_326 VPWR VGND sg13g2_fill_2
XFILLER_44_819 VPWR VGND sg13g2_decap_8
XFILLER_37_871 VPWR VGND sg13g2_fill_2
X_4078_ _1727_ _1725_ _1726_ VPWR VGND sg13g2_nand2_1
X_3029_ net794 videogen.test_lut_thingy.pixel_feeder_inst.row\[16\]\[1\] _0821_ _0400_
+ VPWR VGND sg13g2_mux2_1
XFILLER_34_25 VPWR VGND sg13g2_fill_1
XFILLER_34_47 VPWR VGND sg13g2_decap_8
Xclkload2 VPWR clkload2/Y clknet_3_3_0_clk_regs VGND sg13g2_inv_1
XFILLER_4_937 VPWR VGND sg13g2_decap_8
XFILLER_46_134 VPWR VGND sg13g2_decap_8
XFILLER_34_307 VPWR VGND sg13g2_fill_2
XFILLER_43_874 VPWR VGND sg13g2_fill_1
XFILLER_30_513 VPWR VGND sg13g2_decap_4
XFILLER_30_535 VPWR VGND sg13g2_decap_8
XFILLER_11_793 VPWR VGND sg13g2_decap_8
XFILLER_7_764 VPWR VGND sg13g2_decap_8
X_3380_ videogen.fancy_shader.n646\[3\] videogen.fancy_shader.video_y\[3\] _1033_
+ VPWR VGND sg13g2_xor2_1
XFILLER_3_981 VPWR VGND sg13g2_decap_8
X_5050_ net381 VGND VPWR _0382_ videogen.test_lut_thingy.pixel_feeder_inst.row\[33\]\[3\]
+ _0036_ sg13g2_dfrbpq_1
X_4001_ VPWR _1651_ _1650_ VGND sg13g2_inv_1
XFILLER_25_307 VPWR VGND sg13g2_fill_1
XFILLER_37_178 VPWR VGND sg13g2_fill_1
XFILLER_37_167 VPWR VGND sg13g2_decap_8
XFILLER_1_84 VPWR VGND sg13g2_decap_8
XFILLER_19_882 VPWR VGND sg13g2_fill_1
XFILLER_19_893 VPWR VGND sg13g2_decap_8
XFILLER_18_392 VPWR VGND sg13g2_fill_2
X_4903_ net682 net727 _0238_ VPWR VGND sg13g2_nor2_1
X_4834_ net708 net737 _0169_ VPWR VGND sg13g2_nor2_1
XFILLER_33_384 VPWR VGND sg13g2_fill_1
X_4765_ net707 net752 _0100_ VPWR VGND sg13g2_nor2_1
XFILLER_14_1002 VPWR VGND sg13g2_decap_8
XFILLER_21_557 VPWR VGND sg13g2_fill_1
X_3716_ videogen.test_lut_thingy.pixel_feeder_inst.row\[24\]\[1\] net598 _1369_ VPWR
+ VGND sg13g2_nor2_1
X_4696_ net685 net730 _0033_ VPWR VGND sg13g2_nor2_1
X_3647_ net628 _1288_ _1299_ _1300_ VPWR VGND sg13g2_nor3_1
X_3578_ _1218_ _1229_ _1029_ _1231_ VPWR VGND sg13g2_nand3_1
X_5317_ net363 VGND VPWR _0645_ serialize.shift_reg_b\[3\] clknet_3_2_0_clk_regs sg13g2_dfrbpq_1
XFILLER_0_417 VPWR VGND sg13g2_decap_8
Xhold14 _0283_ VPWR VGND net459 sg13g2_dlygate4sd3_1
X_5248_ net215 VGND VPWR _0576_ videogen.test_lut_thingy.pixel_feeder_inst.row\[42\]\[0\]
+ _0205_ sg13g2_dfrbpq_1
Xhold25 serialize.shift_reg_g\[7\] VPWR VGND net470 sg13g2_dlygate4sd3_1
Xhold36 serialize.shift_reg_b\[9\] VPWR VGND net481 sg13g2_dlygate4sd3_1
Xhold47 serialize.bit_cnt\[2\] VPWR VGND net492 sg13g2_dlygate4sd3_1
X_5126__254 VPWR VGND net254 sg13g2_tiehi
XFILLER_21_1006 VPWR VGND sg13g2_decap_8
XFILLER_28_112 VPWR VGND sg13g2_fill_1
X_5179_ net111 VGND VPWR _0507_ videogen.test_lut_thingy.pixel_feeder_inst.row\[55\]\[3\]
+ _0144_ sg13g2_dfrbpq_1
XFILLER_28_189 VPWR VGND sg13g2_decap_8
XFILLER_45_57 VPWR VGND sg13g2_decap_4
XFILLER_24_362 VPWR VGND sg13g2_fill_2
XFILLER_25_885 VPWR VGND sg13g2_decap_8
XFILLER_8_506 VPWR VGND sg13g2_decap_4
XFILLER_12_557 VPWR VGND sg13g2_fill_2
XFILLER_4_701 VPWR VGND sg13g2_decap_8
XFILLER_3_211 VPWR VGND sg13g2_fill_1
XFILLER_4_745 VPWR VGND sg13g2_decap_8
XFILLER_48_922 VPWR VGND sg13g2_decap_8
XFILLER_0_951 VPWR VGND sg13g2_decap_8
XFILLER_48_999 VPWR VGND sg13g2_decap_8
XFILLER_16_830 VPWR VGND sg13g2_decap_8
XFILLER_43_660 VPWR VGND sg13g2_fill_1
XFILLER_16_863 VPWR VGND sg13g2_decap_8
X_2880_ videogen.test_lut_thingy.pixel_feeder_inst.row\[53\]\[2\] net786 _0789_ _0534_
+ VPWR VGND sg13g2_mux2_1
XFILLER_31_899 VPWR VGND sg13g2_decap_8
XFILLER_11_590 VPWR VGND sg13g2_fill_2
X_4550_ VGND VPWR net618 _2145_ _2167_ _2166_ sg13g2_a21oi_1
X_4481_ _2105_ _2104_ _2102_ VPWR VGND sg13g2_nand2b_1
X_3501_ VGND VPWR _1144_ _1148_ _1154_ _1153_ sg13g2_a21oi_1
X_3432_ _1083_ VPWR _1085_ VGND _0973_ _1084_ sg13g2_o21ai_1
X_3363_ net813 VPWR _1018_ VGND _0695_ _1016_ sg13g2_o21ai_1
XFILLER_44_1006 VPWR VGND sg13g2_decap_8
X_5102_ net302 VGND VPWR _0430_ videogen.test_lut_thingy.pixel_feeder_inst.row\[9\]\[2\]
+ _0067_ sg13g2_dfrbpq_1
X_3294_ videogen.fancy_shader.n646\[3\] videogen.fancy_shader.video_x\[3\] _0968_
+ VPWR VGND sg13g2_and2_1
X_5033_ net401 VGND VPWR _0365_ blue\[6\] net651 sg13g2_dfrbpq_2
XFILLER_39_966 VPWR VGND sg13g2_fill_2
XFILLER_15_16 VPWR VGND sg13g2_decap_8
XFILLER_25_159 VPWR VGND sg13g2_decap_8
XFILLER_40_129 VPWR VGND sg13g2_fill_1
X_4817_ net695 net740 _0152_ VPWR VGND sg13g2_nor2_1
XFILLER_22_877 VPWR VGND sg13g2_decap_8
X_4748_ net713 net758 _0083_ VPWR VGND sg13g2_nor2_1
X_4679_ net697 net742 _0016_ VPWR VGND sg13g2_nor2_1
Xoutput15 net15 uo_out[2] VPWR VGND sg13g2_buf_1
XFILLER_0_203 VPWR VGND sg13g2_decap_4
XFILLER_1_704 VPWR VGND sg13g2_decap_8
XFILLER_0_225 VPWR VGND sg13g2_fill_1
XFILLER_1_748 VPWR VGND sg13g2_decap_8
XFILLER_1_759 VPWR VGND sg13g2_fill_1
XFILLER_5_1000 VPWR VGND sg13g2_decap_8
XFILLER_29_443 VPWR VGND sg13g2_fill_2
XFILLER_29_476 VPWR VGND sg13g2_decap_4
XFILLER_45_969 VPWR VGND sg13g2_decap_8
XFILLER_44_479 VPWR VGND sg13g2_decap_8
XFILLER_31_107 VPWR VGND sg13g2_fill_2
XFILLER_13_833 VPWR VGND sg13g2_decap_8
XFILLER_9_826 VPWR VGND sg13g2_decap_8
XFILLER_8_336 VPWR VGND sg13g2_fill_2
XFILLER_8_325 VPWR VGND sg13g2_fill_1
XFILLER_8_314 VPWR VGND sg13g2_fill_2
XFILLER_12_365 VPWR VGND sg13g2_fill_2
XFILLER_12_387 VPWR VGND sg13g2_fill_2
XFILLER_4_531 VPWR VGND sg13g2_decap_8
XFILLER_39_207 VPWR VGND sg13g2_decap_4
XFILLER_39_218 VPWR VGND sg13g2_fill_1
XFILLER_48_796 VPWR VGND sg13g2_decap_8
X_3981_ net635 VPWR _1633_ VGND videogen.test_lut_thingy.pixel_feeder_inst.row\[39\]\[0\]
+ net573 sg13g2_o21ai_1
X_2932_ videogen.test_lut_thingy.pixel_feeder_inst.row\[5\]\[0\] net806 _0799_ _0484_
+ VPWR VGND sg13g2_mux2_1
XFILLER_31_630 VPWR VGND sg13g2_fill_2
X_2863_ _0749_ _0774_ _0786_ VPWR VGND sg13g2_nor2_2
X_2794_ _0699_ _0732_ net613 _0765_ VPWR VGND sg13g2_nand3_1
X_4602_ _2211_ _2213_ _0618_ VPWR VGND sg13g2_nor2_1
X_4533_ blue\[1\] net619 blue\[6\] _2150_ VPWR VGND sg13g2_or3_1
XFILLER_7_83 VPWR VGND sg13g2_decap_8
X_4464_ VGND VPWR _2087_ _2088_ _2089_ _2064_ sg13g2_a21oi_1
Xfanout805 net806 net805 VPWR VGND sg13g2_buf_8
X_3415_ _1068_ videogen.fancy_shader.video_y\[9\] videogen.fancy_shader.n646\[9\]
+ VPWR VGND sg13g2_xnor2_1
X_4395_ _2034_ _2023_ _2032_ VPWR VGND sg13g2_xnor2_1
X_3346_ videogen.fancy_shader.video_y\[5\] _1005_ videogen.fancy_shader.video_y\[6\]
+ _1008_ VPWR VGND sg13g2_nand3_1
XFILLER_39_730 VPWR VGND sg13g2_fill_2
X_5016_ net427 VGND VPWR _0348_ videogen.fancy_shader.video_y\[1\] net655 sg13g2_dfrbpq_2
X_3277_ videogen.fancy_shader.n646\[0\] _0908_ videogen.fancy_shader.n646\[1\] _0954_
+ VPWR VGND sg13g2_nand3_1
XFILLER_38_251 VPWR VGND sg13g2_fill_2
XFILLER_27_969 VPWR VGND sg13g2_decap_8
XFILLER_42_917 VPWR VGND sg13g2_decap_4
XFILLER_41_427 VPWR VGND sg13g2_decap_4
XFILLER_42_14 VPWR VGND sg13g2_fill_1
XFILLER_22_685 VPWR VGND sg13g2_decap_8
XFILLER_5_306 VPWR VGND sg13g2_fill_1
XFILLER_1_501 VPWR VGND sg13g2_decap_4
XFILLER_45_755 VPWR VGND sg13g2_decap_4
XFILLER_44_210 VPWR VGND sg13g2_decap_8
XFILLER_18_958 VPWR VGND sg13g2_decap_8
XFILLER_44_254 VPWR VGND sg13g2_fill_1
XFILLER_44_243 VPWR VGND sg13g2_fill_2
XFILLER_17_457 VPWR VGND sg13g2_decap_8
XFILLER_13_652 VPWR VGND sg13g2_decap_4
XFILLER_34_1005 VPWR VGND sg13g2_decap_8
XFILLER_9_612 VPWR VGND sg13g2_fill_1
XFILLER_9_645 VPWR VGND sg13g2_fill_1
XFILLER_5_895 VPWR VGND sg13g2_decap_8
X_3200_ _0898_ _0899_ _0303_ VPWR VGND sg13g2_nor2b_1
X_4180_ _1758_ _1825_ _1826_ VPWR VGND sg13g2_nor2_1
X_3131_ _0686_ _0867_ _0870_ VPWR VGND sg13g2_nor2_1
XFILLER_48_571 VPWR VGND sg13g2_decap_8
X_3062_ videogen.test_lut_thingy.pixel_feeder_inst.row\[20\]\[3\] net768 _0828_ _0293_
+ VPWR VGND sg13g2_mux2_1
XFILLER_17_991 VPWR VGND sg13g2_decap_8
XFILLER_23_427 VPWR VGND sg13g2_fill_2
X_3964_ _1616_ _0738_ _0673_ _0730_ _0675_ VPWR VGND sg13g2_a22oi_1
X_2915_ net779 videogen.test_lut_thingy.pixel_feeder_inst.row\[56\]\[2\] _0796_ _0498_
+ VPWR VGND sg13g2_mux2_1
X_3895_ _0696_ _1547_ _1548_ VPWR VGND sg13g2_and2_1
XFILLER_32_994 VPWR VGND sg13g2_decap_8
X_2846_ videogen.test_lut_thingy.pixel_feeder_inst.row\[46\]\[1\] net791 _0782_ _0561_
+ VPWR VGND sg13g2_mux2_1
X_2777_ videogen.test_lut_thingy.pixel_feeder_inst.row\[19\]\[2\] net783 _0758_ _0606_
+ VPWR VGND sg13g2_mux2_1
X_4516_ display_enable _2062_ _2135_ VPWR VGND sg13g2_and2_1
X_4447_ _2067_ net622 _2074_ VPWR VGND sg13g2_nor2b_1
Xfanout613 net614 net613 VPWR VGND sg13g2_buf_8
Xfanout624 videogen.fancy_shader.video_y\[4\] net624 VPWR VGND sg13g2_buf_8
Xfanout602 net603 net602 VPWR VGND sg13g2_buf_8
Xfanout646 net661 net646 VPWR VGND sg13g2_buf_8
X_4378_ _1967_ _1994_ _2018_ VPWR VGND sg13g2_nor2_2
Xfanout635 net638 net635 VPWR VGND sg13g2_buf_8
Xfanout657 net660 net657 VPWR VGND sg13g2_buf_8
Xfanout679 net681 net679 VPWR VGND sg13g2_buf_8
X_3329_ _0994_ _0995_ _0348_ VPWR VGND sg13g2_nor2_1
Xfanout668 _0669_ net668 VPWR VGND sg13g2_buf_8
XFILLER_37_14 VPWR VGND sg13g2_fill_2
XFILLER_14_405 VPWR VGND sg13g2_fill_1
XFILLER_15_917 VPWR VGND sg13g2_decap_8
XFILLER_27_788 VPWR VGND sg13g2_fill_1
XFILLER_42_747 VPWR VGND sg13g2_decap_8
XFILLER_41_224 VPWR VGND sg13g2_decap_4
XFILLER_14_416 VPWR VGND sg13g2_decap_8
XFILLER_23_972 VPWR VGND sg13g2_decap_8
XFILLER_10_622 VPWR VGND sg13g2_decap_4
X_5032__402 VPWR VGND net402 sg13g2_tiehi
XFILLER_2_876 VPWR VGND sg13g2_decap_8
XFILLER_49_335 VPWR VGND sg13g2_decap_8
XFILLER_37_508 VPWR VGND sg13g2_decap_4
XFILLER_45_563 VPWR VGND sg13g2_decap_8
XFILLER_18_766 VPWR VGND sg13g2_decap_4
XFILLER_33_747 VPWR VGND sg13g2_decap_8
XFILLER_32_246 VPWR VGND sg13g2_fill_2
XFILLER_13_460 VPWR VGND sg13g2_fill_2
X_2700_ videogen.fancy_shader.video_y\[9\] _0677_ _0706_ _0707_ VPWR VGND sg13g2_nor3_1
XFILLER_40_290 VPWR VGND sg13g2_fill_2
X_3680_ videogen.test_lut_thingy.pixel_feeder_inst.row\[39\]\[2\] net573 _1333_ VPWR
+ VGND sg13g2_nor2_1
XFILLER_9_497 VPWR VGND sg13g2_fill_1
X_4301_ VPWR _0372_ _1946_ VGND sg13g2_inv_1
X_5281_ net338 VGND VPWR _0609_ videogen.test_lut_thingy.pixel_feeder_inst.row\[39\]\[1\]
+ _0238_ sg13g2_dfrbpq_1
X_4232_ _1878_ _1661_ _1766_ VPWR VGND sg13g2_xnor2_1
XFILLER_4_73 VPWR VGND sg13g2_fill_2
X_4163_ _1809_ _1806_ _1807_ _1804_ _1802_ VPWR VGND sg13g2_a22oi_1
X_3114_ VGND VPWR net604 net15 net556 _0705_ sg13g2_a21oi_2
X_4094_ _1743_ _1734_ _1738_ VPWR VGND sg13g2_xnor2_1
XFILLER_49_891 VPWR VGND sg13g2_decap_8
X_3045_ videogen.test_lut_thingy.pixel_feeder_inst.row\[33\]\[0\] net803 _0824_ _0379_
+ VPWR VGND sg13g2_mux2_1
XFILLER_23_213 VPWR VGND sg13g2_fill_1
XFILLER_24_747 VPWR VGND sg13g2_decap_8
X_4996_ net53 VGND VPWR _0328_ videogen.test_lut_thingy.pixel_feeder_inst.row\[37\]\[3\]
+ _0024_ sg13g2_dfrbpq_1
XFILLER_23_257 VPWR VGND sg13g2_fill_1
XFILLER_23_279 VPWR VGND sg13g2_fill_2
X_3947_ net638 VPWR _1599_ VGND videogen.test_lut_thingy.pixel_feeder_inst.row\[52\]\[0\]
+ net602 sg13g2_o21ai_1
XFILLER_20_942 VPWR VGND sg13g2_decap_8
XFILLER_23_49 VPWR VGND sg13g2_fill_2
X_5315__382 VPWR VGND net382 sg13g2_tiehi
X_3878_ net608 _1525_ _1530_ _1531_ VPWR VGND sg13g2_nor3_1
X_2829_ videogen.test_lut_thingy.pixel_feeder_inst.row\[43\]\[0\] net803 _0776_ _0572_
+ VPWR VGND sg13g2_mux2_1
XFILLER_3_607 VPWR VGND sg13g2_fill_1
X_5211__380 VPWR VGND net380 sg13g2_tiehi
XFILLER_48_35 VPWR VGND sg13g2_decap_8
XFILLER_47_839 VPWR VGND sg13g2_decap_8
XFILLER_46_316 VPWR VGND sg13g2_fill_2
XFILLER_27_552 VPWR VGND sg13g2_decap_8
XFILLER_14_202 VPWR VGND sg13g2_decap_8
XFILLER_14_213 VPWR VGND sg13g2_fill_2
X_5136__234 VPWR VGND net234 sg13g2_tiehi
XFILLER_23_780 VPWR VGND sg13g2_decap_8
XFILLER_11_975 VPWR VGND sg13g2_decap_8
XFILLER_7_968 VPWR VGND sg13g2_decap_8
XFILLER_6_434 VPWR VGND sg13g2_decap_8
X_5286__289 VPWR VGND net289 sg13g2_tiehi
XFILLER_9_1009 VPWR VGND sg13g2_decap_8
XFILLER_49_121 VPWR VGND sg13g2_fill_1
XFILLER_38_817 VPWR VGND sg13g2_decap_4
XFILLER_49_176 VPWR VGND sg13g2_decap_8
XFILLER_46_883 VPWR VGND sg13g2_decap_8
XFILLER_45_360 VPWR VGND sg13g2_fill_1
XFILLER_45_393 VPWR VGND sg13g2_decap_8
X_4850_ net689 net734 _0185_ VPWR VGND sg13g2_nor2_1
X_3801_ videogen.test_lut_thingy.pixel_feeder_inst.row\[37\]\[3\] net562 _1454_ VPWR
+ VGND sg13g2_nor2_1
XFILLER_20_238 VPWR VGND sg13g2_fill_1
X_4781_ net676 net721 _0116_ VPWR VGND sg13g2_nor2_1
XFILLER_13_290 VPWR VGND sg13g2_decap_8
X_3732_ net611 _1379_ _1384_ _1385_ VPWR VGND sg13g2_nor3_1
XFILLER_9_283 VPWR VGND sg13g2_fill_1
X_3663_ videogen.test_lut_thingy.pixel_feeder_inst.row\[54\]\[2\] net590 _1316_ VPWR
+ VGND sg13g2_nor2_1
X_5333_ net177 VGND VPWR _0661_ serialize.shift_reg_r\[3\] clknet_3_5_0_clk_regs sg13g2_dfrbpq_1
XFILLER_6_990 VPWR VGND sg13g2_decap_8
X_3594_ _1241_ _1242_ _1247_ VPWR VGND sg13g2_nor2_1
X_5264_ net117 VGND VPWR _0592_ videogen.test_lut_thingy.pixel_feeder_inst.row\[59\]\[0\]
+ _0221_ sg13g2_dfrbpq_1
X_4215_ _1859_ _1860_ _1861_ VPWR VGND sg13g2_and2_1
X_5195_ net52 VGND VPWR _0523_ videogen.test_lut_thingy.pixel_feeder_inst.row\[27\]\[3\]
+ _0152_ sg13g2_dfrbpq_1
X_4146_ _1785_ _1789_ _1774_ _1792_ VPWR VGND _1790_ sg13g2_nand4_1
XFILLER_18_16 VPWR VGND sg13g2_decap_8
XFILLER_18_27 VPWR VGND sg13g2_fill_1
XFILLER_37_850 VPWR VGND sg13g2_decap_8
X_4077_ _1656_ _1715_ _1726_ VPWR VGND sg13g2_nor2_1
X_3028_ net784 videogen.test_lut_thingy.pixel_feeder_inst.row\[16\]\[2\] _0821_ _0401_
+ VPWR VGND sg13g2_mux2_1
XFILLER_24_511 VPWR VGND sg13g2_fill_1
XFILLER_24_544 VPWR VGND sg13g2_fill_2
XFILLER_34_15 VPWR VGND sg13g2_decap_4
X_4979_ net87 VGND VPWR _0311_ videogen.test_lut_thingy.pixel_feeder_inst.h_pix\[0\]
+ net645 sg13g2_dfrbpq_1
XFILLER_12_739 VPWR VGND sg13g2_decap_8
XFILLER_24_599 VPWR VGND sg13g2_decap_8
Xclkload3 VPWR clkload3/Y clknet_3_5_0_clk_regs VGND sg13g2_inv_1
XFILLER_4_916 VPWR VGND sg13g2_decap_8
XFILLER_47_647 VPWR VGND sg13g2_decap_8
XFILLER_47_658 VPWR VGND sg13g2_fill_1
XFILLER_28_850 VPWR VGND sg13g2_decap_8
XFILLER_43_820 VPWR VGND sg13g2_decap_8
XFILLER_28_883 VPWR VGND sg13g2_decap_8
XFILLER_43_831 VPWR VGND sg13g2_fill_2
XFILLER_43_886 VPWR VGND sg13g2_decap_8
XFILLER_42_341 VPWR VGND sg13g2_fill_2
XFILLER_24_92 VPWR VGND sg13g2_fill_1
X_5073__343 VPWR VGND net343 sg13g2_tiehi
XFILLER_7_710 VPWR VGND sg13g2_fill_2
XFILLER_6_231 VPWR VGND sg13g2_decap_4
XFILLER_3_960 VPWR VGND sg13g2_decap_8
X_4000_ _1449_ _1646_ _1650_ VPWR VGND sg13g2_nor2_1
XFILLER_38_647 VPWR VGND sg13g2_decap_8
XFILLER_1_63 VPWR VGND sg13g2_decap_8
XFILLER_19_861 VPWR VGND sg13g2_decap_8
XFILLER_26_809 VPWR VGND sg13g2_fill_2
XFILLER_46_680 VPWR VGND sg13g2_decap_4
X_4943__141 VPWR VGND net141 sg13g2_tiehi
XFILLER_19_872 VPWR VGND sg13g2_fill_1
XFILLER_45_190 VPWR VGND sg13g2_decap_8
X_4902_ net674 net720 _0237_ VPWR VGND sg13g2_nor2_1
X_4833_ net707 net754 _0168_ VPWR VGND sg13g2_nor2_1
XFILLER_21_536 VPWR VGND sg13g2_decap_8
XFILLER_33_374 VPWR VGND sg13g2_decap_4
X_4764_ net707 net752 _0099_ VPWR VGND sg13g2_nor2_1
X_3715_ net608 VPWR _1368_ VGND videogen.test_lut_thingy.pixel_feeder_inst.row\[25\]\[1\]
+ net565 sg13g2_o21ai_1
X_4695_ net683 net728 _0032_ VPWR VGND sg13g2_nor2_1
X_3646_ net637 _1293_ _1298_ _1299_ VPWR VGND sg13g2_nor3_1
X_3577_ VGND VPWR _1230_ _1228_ _1223_ sg13g2_or2_1
X_5316_ net371 VGND VPWR _0644_ serialize.shift_reg_b\[2\] clknet_3_1_0_clk_regs sg13g2_dfrbpq_1
X_5247_ net219 VGND VPWR _0575_ videogen.test_lut_thingy.pixel_feeder_inst.row\[43\]\[3\]
+ _0204_ sg13g2_dfrbpq_1
Xhold26 serialize.shift_reg_g\[5\] VPWR VGND net471 sg13g2_dlygate4sd3_1
Xhold37 _2231_ VPWR VGND net482 sg13g2_dlygate4sd3_1
Xhold15 serialize.shift_reg_r\[9\] VPWR VGND net460 sg13g2_dlygate4sd3_1
XFILLER_29_48 VPWR VGND sg13g2_fill_2
X_5178_ net115 VGND VPWR _0506_ videogen.test_lut_thingy.pixel_feeder_inst.row\[55\]\[2\]
+ _0143_ sg13g2_dfrbpq_1
Xhold48 _0625_ VPWR VGND net493 sg13g2_dlygate4sd3_1
XFILLER_44_606 VPWR VGND sg13g2_fill_2
X_4129_ _1773_ _1107_ _1775_ VPWR VGND sg13g2_xor2_1
XFILLER_29_669 VPWR VGND sg13g2_decap_8
XFILLER_10_72 VPWR VGND sg13g2_fill_1
XFILLER_3_267 VPWR VGND sg13g2_decap_8
XFILLER_3_256 VPWR VGND sg13g2_decap_8
XFILLER_10_94 VPWR VGND sg13g2_fill_1
XFILLER_0_930 VPWR VGND sg13g2_decap_8
XFILLER_48_901 VPWR VGND sg13g2_decap_8
XFILLER_47_400 VPWR VGND sg13g2_decap_8
XFILLER_48_978 VPWR VGND sg13g2_decap_8
XFILLER_43_650 VPWR VGND sg13g2_fill_1
XFILLER_15_341 VPWR VGND sg13g2_decap_8
XFILLER_42_160 VPWR VGND sg13g2_fill_2
X_3500_ _1148_ _1152_ _1153_ VPWR VGND sg13g2_nor2_1
X_4480_ _2057_ _2083_ _2103_ _2104_ VPWR VGND sg13g2_nor3_1
XFILLER_7_562 VPWR VGND sg13g2_decap_8
X_3431_ _1084_ _1079_ _1081_ VPWR VGND sg13g2_nand2_1
X_3362_ _1015_ _1017_ _0359_ VPWR VGND sg13g2_nor2_1
X_5101_ net304 VGND VPWR _0429_ videogen.test_lut_thingy.pixel_feeder_inst.row\[9\]\[1\]
+ _0066_ sg13g2_dfrbpq_1
XFILLER_39_901 VPWR VGND sg13g2_fill_1
X_3293_ videogen.fancy_shader.video_x\[2\] videogen.fancy_shader.n646\[2\] _0967_
+ VPWR VGND sg13g2_xor2_1
X_5032_ net402 VGND VPWR _0364_ blue\[0\] net651 sg13g2_dfrbpq_1
XFILLER_38_455 VPWR VGND sg13g2_fill_2
XFILLER_26_639 VPWR VGND sg13g2_fill_2
XFILLER_25_149 VPWR VGND sg13g2_decap_4
XFILLER_34_694 VPWR VGND sg13g2_fill_2
X_4816_ net697 net740 _0151_ VPWR VGND sg13g2_nor2_1
XFILLER_21_366 VPWR VGND sg13g2_fill_1
X_4747_ net710 net755 _0082_ VPWR VGND sg13g2_nor2_1
X_4678_ net703 net742 _0015_ VPWR VGND sg13g2_nor2_1
X_3629_ _1278_ _1279_ _1280_ _1281_ _1282_ VPWR VGND sg13g2_nor4_1
Xoutput16 net16 uo_out[3] VPWR VGND sg13g2_buf_1
XFILLER_1_727 VPWR VGND sg13g2_decap_4
XFILLER_0_237 VPWR VGND sg13g2_decap_8
XFILLER_29_455 VPWR VGND sg13g2_fill_2
XFILLER_44_414 VPWR VGND sg13g2_fill_1
XFILLER_17_628 VPWR VGND sg13g2_decap_4
XFILLER_45_948 VPWR VGND sg13g2_decap_8
XFILLER_40_653 VPWR VGND sg13g2_fill_1
XFILLER_9_849 VPWR VGND sg13g2_fill_1
X_3980_ videogen.test_lut_thingy.pixel_feeder_inst.row\[37\]\[0\] net562 _1632_ VPWR
+ VGND sg13g2_nor2_1
XFILLER_44_992 VPWR VGND sg13g2_decap_8
X_2931_ videogen.test_lut_thingy.pixel_feeder_inst.row\[5\]\[1\] net795 _0799_ _0485_
+ VPWR VGND sg13g2_mux2_1
Xclkbuf_0_clk clk clknet_0_clk VPWR VGND sg13g2_buf_8
XFILLER_15_182 VPWR VGND sg13g2_fill_2
X_2862_ videogen.test_lut_thingy.pixel_feeder_inst.row\[4\]\[0\] net806 _0785_ _0548_
+ VPWR VGND sg13g2_mux2_1
X_4601_ _2213_ net815 _2207_ VPWR VGND sg13g2_nand2_1
X_2793_ _0764_ net613 _0763_ VPWR VGND sg13g2_nand2_1
XFILLER_30_174 VPWR VGND sg13g2_fill_2
XFILLER_11_1017 VPWR VGND sg13g2_decap_8
XFILLER_11_1028 VPWR VGND sg13g2_fill_1
X_4532_ _2143_ _2148_ blue\[6\] _2149_ VPWR VGND sg13g2_nand3_1
X_4463_ _2088_ net615 _2077_ VPWR VGND sg13g2_nand2_1
XFILLER_7_95 VPWR VGND sg13g2_decap_8
X_3414_ _1061_ _1066_ _1053_ _1067_ VPWR VGND sg13g2_nand3_1
X_4394_ VPWR _2033_ _2032_ VGND sg13g2_inv_1
Xfanout806 ui_in[4] net806 VPWR VGND sg13g2_buf_8
X_3345_ _1005_ net623 videogen.fancy_shader.video_y\[6\] _1007_ VPWR VGND sg13g2_a21o_1
X_3276_ _0337_ net812 _0952_ _0953_ VPWR VGND sg13g2_and3_1
X_5015_ net429 VGND VPWR _0347_ videogen.fancy_shader.video_y\[0\] net655 sg13g2_dfrbpq_2
XFILLER_26_16 VPWR VGND sg13g2_fill_1
XFILLER_41_406 VPWR VGND sg13g2_decap_8
XFILLER_41_439 VPWR VGND sg13g2_fill_2
XFILLER_42_26 VPWR VGND sg13g2_fill_2
XFILLER_22_653 VPWR VGND sg13g2_fill_2
XFILLER_1_546 VPWR VGND sg13g2_fill_1
XFILLER_49_539 VPWR VGND sg13g2_decap_8
XFILLER_18_937 VPWR VGND sg13g2_decap_8
XFILLER_45_745 VPWR VGND sg13g2_decap_4
XFILLER_32_406 VPWR VGND sg13g2_decap_8
XFILLER_44_266 VPWR VGND sg13g2_decap_4
XFILLER_26_992 VPWR VGND sg13g2_decap_8
XFILLER_41_951 VPWR VGND sg13g2_fill_1
XFILLER_13_675 VPWR VGND sg13g2_decap_4
XFILLER_34_1028 VPWR VGND sg13g2_fill_1
X_5254__191 VPWR VGND net191 sg13g2_tiehi
XFILLER_40_494 VPWR VGND sg13g2_fill_2
XFILLER_40_483 VPWR VGND sg13g2_decap_8
XFILLER_8_134 VPWR VGND sg13g2_fill_1
XFILLER_12_185 VPWR VGND sg13g2_fill_2
XFILLER_8_189 VPWR VGND sg13g2_decap_8
X_5146__214 VPWR VGND net214 sg13g2_tiehi
X_3130_ VGND VPWR _0863_ _0869_ net17 _0864_ sg13g2_a21oi_1
XFILLER_0_590 VPWR VGND sg13g2_decap_8
XFILLER_48_550 VPWR VGND sg13g2_decap_8
X_3061_ _0729_ _0777_ _0828_ VPWR VGND sg13g2_nor2_2
XFILLER_36_701 VPWR VGND sg13g2_fill_1
XFILLER_35_222 VPWR VGND sg13g2_fill_1
XFILLER_17_970 VPWR VGND sg13g2_decap_8
X_3963_ net634 VPWR _1615_ VGND videogen.test_lut_thingy.pixel_feeder_inst.row\[60\]\[0\]
+ net597 sg13g2_o21ai_1
X_2914_ net767 videogen.test_lut_thingy.pixel_feeder_inst.row\[56\]\[3\] _0796_ _0499_
+ VPWR VGND sg13g2_mux2_1
X_3894_ _1546_ VPWR _1547_ VGND net2 _0695_ sg13g2_o21ai_1
XFILLER_32_973 VPWR VGND sg13g2_decap_8
X_2845_ videogen.test_lut_thingy.pixel_feeder_inst.row\[46\]\[2\] net780 _0782_ _0562_
+ VPWR VGND sg13g2_mux2_1
X_5233__275 VPWR VGND net275 sg13g2_tiehi
X_2776_ videogen.test_lut_thingy.pixel_feeder_inst.row\[19\]\[3\] net772 _0758_ _0607_
+ VPWR VGND sg13g2_mux2_1
X_4515_ VGND VPWR net617 net622 _0510_ net764 sg13g2_a21oi_1
X_4446_ VGND VPWR net622 net552 _0418_ net764 sg13g2_a21oi_1
Xfanout614 videogen.mem_read net614 VPWR VGND sg13g2_buf_8
Xfanout603 _0700_ net603 VPWR VGND sg13g2_buf_8
X_4377_ net552 _1994_ _2017_ VPWR VGND sg13g2_nor2_1
Xfanout658 net659 net658 VPWR VGND sg13g2_buf_8
Xfanout625 videogen.test_lut_thingy.pixel_feeder_inst.h_pix\[5\] net625 VPWR VGND
+ sg13g2_buf_8
Xfanout647 net648 net647 VPWR VGND sg13g2_buf_8
Xfanout636 net637 net636 VPWR VGND sg13g2_buf_8
X_3328_ net812 VPWR _0995_ VGND videogen.fancy_shader.video_y\[1\] _0992_ sg13g2_o21ai_1
Xfanout669 net671 net669 VPWR VGND sg13g2_buf_8
XFILLER_39_550 VPWR VGND sg13g2_decap_8
X_3259_ VGND VPWR videogen.test_lut_thingy.pixel_feeder_inst.v_counter\[2\] _0942_
+ _0943_ _0936_ sg13g2_a21oi_1
XFILLER_27_701 VPWR VGND sg13g2_decap_4
XFILLER_39_583 VPWR VGND sg13g2_fill_2
XFILLER_14_428 VPWR VGND sg13g2_decap_8
XFILLER_23_951 VPWR VGND sg13g2_decap_8
XFILLER_26_299 VPWR VGND sg13g2_decap_8
XFILLER_10_601 VPWR VGND sg13g2_decap_8
Xclkbuf_3_5_0_clk_regs clknet_0_clk_regs clknet_3_5_0_clk_regs VPWR VGND sg13g2_buf_8
XFILLER_5_126 VPWR VGND sg13g2_decap_8
XFILLER_2_855 VPWR VGND sg13g2_decap_8
XFILLER_1_343 VPWR VGND sg13g2_decap_4
XFILLER_17_211 VPWR VGND sg13g2_fill_2
XFILLER_18_778 VPWR VGND sg13g2_fill_2
XFILLER_9_410 VPWR VGND sg13g2_fill_2
XFILLER_14_995 VPWR VGND sg13g2_decap_8
X_5332__185 VPWR VGND net185 sg13g2_tiehi
X_5280_ net346 VGND VPWR _0608_ videogen.test_lut_thingy.pixel_feeder_inst.row\[39\]\[0\]
+ _0237_ sg13g2_dfrbpq_1
X_4300_ net812 VPWR _1946_ VGND _1941_ _1945_ sg13g2_o21ai_1
X_4231_ _1875_ _1861_ _1877_ VPWR VGND sg13g2_xor2_1
XFILLER_4_192 VPWR VGND sg13g2_fill_1
X_4162_ _1808_ _1806_ _1807_ VPWR VGND sg13g2_nand2_1
XFILLER_49_870 VPWR VGND sg13g2_decap_8
X_3113_ VGND VPWR net604 net14 _0725_ net556 sg13g2_a21oi_2
X_4093_ _1249_ _1722_ _1739_ _1741_ _1742_ VPWR VGND sg13g2_or4_1
XFILLER_28_509 VPWR VGND sg13g2_fill_2
X_3044_ videogen.test_lut_thingy.pixel_feeder_inst.row\[33\]\[1\] net792 _0824_ _0380_
+ VPWR VGND sg13g2_mux2_1
XFILLER_24_737 VPWR VGND sg13g2_decap_4
X_4995_ net55 VGND VPWR _0327_ videogen.test_lut_thingy.pixel_feeder_inst.row\[37\]\[2\]
+ _0023_ sg13g2_dfrbpq_1
X_3946_ videogen.test_lut_thingy.pixel_feeder_inst.h_pix\[5\] _1574_ _1597_ _1598_
+ VPWR VGND sg13g2_nor3_1
XFILLER_17_1012 VPWR VGND sg13g2_decap_8
XFILLER_20_921 VPWR VGND sg13g2_decap_8
X_3877_ _1526_ _1527_ _1528_ _1529_ _1530_ VPWR VGND sg13g2_nor4_1
X_2828_ videogen.test_lut_thingy.pixel_feeder_inst.row\[43\]\[1\] net792 _0776_ _0573_
+ VPWR VGND sg13g2_mux2_1
XFILLER_20_998 VPWR VGND sg13g2_decap_8
X_2759_ net636 _0720_ net587 _0750_ VPWR VGND sg13g2_nor3_1
XFILLER_2_118 VPWR VGND sg13g2_decap_8
X_4429_ _2063_ green\[6\] _2065_ VPWR VGND sg13g2_xor2_1
XFILLER_48_14 VPWR VGND sg13g2_decap_8
XFILLER_47_818 VPWR VGND sg13g2_decap_8
XFILLER_46_328 VPWR VGND sg13g2_fill_1
X_4960__114 VPWR VGND net114 sg13g2_tiehi
XFILLER_6_402 VPWR VGND sg13g2_decap_8
XFILLER_11_954 VPWR VGND sg13g2_decap_8
X_5171__159 VPWR VGND net159 sg13g2_tiehi
XFILLER_7_947 VPWR VGND sg13g2_decap_8
XFILLER_13_83 VPWR VGND sg13g2_fill_2
X_5247__219 VPWR VGND net219 sg13g2_tiehi
XFILLER_49_100 VPWR VGND sg13g2_decap_8
XFILLER_2_696 VPWR VGND sg13g2_decap_8
XFILLER_37_306 VPWR VGND sg13g2_fill_2
XFILLER_49_188 VPWR VGND sg13g2_decap_8
XFILLER_46_862 VPWR VGND sg13g2_decap_8
X_4780_ net676 net721 _0115_ VPWR VGND sg13g2_nor2_1
X_3800_ videogen.test_lut_thingy.pixel_feeder_inst.row\[38\]\[3\] net584 _1453_ VPWR
+ VGND sg13g2_nor2_1
X_3731_ _1380_ _1381_ _1382_ _1383_ _1384_ VPWR VGND sg13g2_nor4_1
XFILLER_9_251 VPWR VGND sg13g2_decap_8
X_3662_ videogen.test_lut_thingy.pixel_feeder_inst.row\[52\]\[2\] net602 _1315_ VPWR
+ VGND sg13g2_nor2_1
X_3593_ _1234_ VPWR _1246_ VGND _1240_ _1245_ sg13g2_o21ai_1
X_5332_ net185 VGND VPWR _0660_ serialize.shift_reg_r\[2\] clknet_3_5_0_clk_regs sg13g2_dfrbpq_1
XFILLER_48_0 VPWR VGND sg13g2_decap_8
X_5263_ net125 VGND VPWR _0591_ videogen.test_lut_thingy.pixel_feeder_inst.row\[3\]\[3\]
+ _0220_ sg13g2_dfrbpq_1
X_4214_ _1860_ _1667_ _1765_ VPWR VGND sg13g2_nand2_1
X_5194_ net56 VGND VPWR _0522_ videogen.test_lut_thingy.pixel_feeder_inst.row\[27\]\[2\]
+ _0151_ sg13g2_dfrbpq_1
X_4145_ _1791_ _1789_ _1790_ _1786_ _1783_ VPWR VGND sg13g2_a22oi_1
XFILLER_28_339 VPWR VGND sg13g2_fill_2
X_4076_ _1720_ _1716_ _1725_ VPWR VGND sg13g2_xor2_1
XFILLER_37_873 VPWR VGND sg13g2_fill_1
X_3027_ net772 videogen.test_lut_thingy.pixel_feeder_inst.row\[16\]\[3\] _0821_ _0402_
+ VPWR VGND sg13g2_mux2_1
XFILLER_36_372 VPWR VGND sg13g2_decap_4
XFILLER_24_523 VPWR VGND sg13g2_fill_2
X_4978_ net89 VGND VPWR _0310_ videogen.test_lut_thingy.pixel_feeder_inst.v_pix\[5\]
+ net643 sg13g2_dfrbpq_1
Xclkload4 VPWR clkload4/Y clknet_3_7_0_clk_regs VGND sg13g2_inv_1
X_3929_ videogen.test_lut_thingy.pixel_feeder_inst.row\[19\]\[0\] net575 _1581_ VPWR
+ VGND sg13g2_nor2_1
XFILLER_30_1020 VPWR VGND sg13g2_decap_8
XFILLER_3_416 VPWR VGND sg13g2_fill_1
XFILLER_47_626 VPWR VGND sg13g2_decap_8
XFILLER_42_386 VPWR VGND sg13g2_fill_1
XFILLER_7_733 VPWR VGND sg13g2_decap_4
XFILLER_10_250 VPWR VGND sg13g2_fill_1
XFILLER_11_773 VPWR VGND sg13g2_decap_4
XFILLER_6_243 VPWR VGND sg13g2_decap_8
XFILLER_6_287 VPWR VGND sg13g2_decap_8
XFILLER_38_637 VPWR VGND sg13g2_fill_2
XFILLER_1_42 VPWR VGND sg13g2_decap_8
X_4901_ net696 net741 _0236_ VPWR VGND sg13g2_nor2_1
XFILLER_18_394 VPWR VGND sg13g2_fill_1
XFILLER_34_876 VPWR VGND sg13g2_decap_8
XFILLER_21_515 VPWR VGND sg13g2_decap_8
X_4832_ net705 net750 _0167_ VPWR VGND sg13g2_nor2_1
X_4763_ net705 net751 _0098_ VPWR VGND sg13g2_nor2_1
X_3714_ _1363_ _1364_ _1365_ _1366_ _1367_ VPWR VGND sg13g2_nor4_1
X_4694_ net682 net727 _0031_ VPWR VGND sg13g2_nor2_1
X_5154__198 VPWR VGND net198 sg13g2_tiehi
X_3645_ _1294_ _1295_ _1296_ _1297_ _1298_ VPWR VGND sg13g2_nor4_1
XFILLER_1_909 VPWR VGND sg13g2_decap_8
X_3576_ _1223_ _1228_ _1229_ VPWR VGND sg13g2_nor2_1
X_5315_ net382 VGND VPWR _0643_ serialize.shift_reg_b\[1\] clknet_3_3_0_clk_regs sg13g2_dfrbpq_1
X_5246_ net223 VGND VPWR _0574_ videogen.test_lut_thingy.pixel_feeder_inst.row\[43\]\[2\]
+ _0203_ sg13g2_dfrbpq_1
Xhold38 serialize.shift_reg_b\[5\] VPWR VGND net483 sg13g2_dlygate4sd3_1
Xhold27 serialize.shift_reg_b\[8\] VPWR VGND net472 sg13g2_dlygate4sd3_1
Xhold16 serialize.shift_reg_r\[2\] VPWR VGND net461 sg13g2_dlygate4sd3_1
X_5177_ net119 VGND VPWR _0505_ videogen.test_lut_thingy.pixel_feeder_inst.row\[55\]\[1\]
+ _0142_ sg13g2_dfrbpq_1
XFILLER_29_615 VPWR VGND sg13g2_decap_8
XFILLER_29_626 VPWR VGND sg13g2_fill_2
Xhold49 serialize.shift_reg_b\[6\] VPWR VGND net494 sg13g2_dlygate4sd3_1
X_4128_ _1774_ _1107_ _1773_ VPWR VGND sg13g2_xnor2_1
X_4059_ _1693_ _1686_ _1689_ _1708_ VPWR VGND sg13g2_a21o_1
XFILLER_43_139 VPWR VGND sg13g2_decap_4
XFILLER_43_117 VPWR VGND sg13g2_fill_2
XFILLER_37_681 VPWR VGND sg13g2_fill_2
XFILLER_25_865 VPWR VGND sg13g2_decap_4
XFILLER_3_202 VPWR VGND sg13g2_decap_8
Xclkbuf_regs_0_clk clk clk_regs VPWR VGND sg13g2_buf_8
XFILLER_0_986 VPWR VGND sg13g2_decap_8
XFILLER_48_957 VPWR VGND sg13g2_decap_8
XFILLER_47_445 VPWR VGND sg13g2_fill_2
XFILLER_19_169 VPWR VGND sg13g2_decap_4
XFILLER_35_607 VPWR VGND sg13g2_fill_2
XFILLER_35_629 VPWR VGND sg13g2_decap_8
XFILLER_15_331 VPWR VGND sg13g2_decap_4
XFILLER_15_353 VPWR VGND sg13g2_fill_2
XFILLER_43_695 VPWR VGND sg13g2_decap_8
XFILLER_7_530 VPWR VGND sg13g2_fill_1
XFILLER_11_592 VPWR VGND sg13g2_fill_1
X_3430_ VPWR VGND _1080_ _1076_ _1079_ videogen.fancy_shader.n646\[7\] _1083_ videogen.fancy_shader.video_x\[7\]
+ sg13g2_a221oi_1
X_3361_ _1017_ net811 _1016_ VPWR VGND sg13g2_nand2_1
X_5100_ net306 VGND VPWR _0428_ videogen.test_lut_thingy.pixel_feeder_inst.row\[9\]\[0\]
+ _0065_ sg13g2_dfrbpq_1
X_5229__291 VPWR VGND net291 sg13g2_tiehi
X_3292_ videogen.fancy_shader.n646\[2\] videogen.fancy_shader.video_x\[2\] _0966_
+ VPWR VGND sg13g2_and2_1
X_5031_ net403 VGND VPWR _0363_ blue\[1\] net651 sg13g2_dfrbpq_2
XFILLER_39_979 VPWR VGND sg13g2_decap_8
XFILLER_25_128 VPWR VGND sg13g2_fill_2
X_4815_ net695 net740 _0150_ VPWR VGND sg13g2_nor2_1
XFILLER_22_846 VPWR VGND sg13g2_decap_8
XFILLER_33_183 VPWR VGND sg13g2_decap_8
XFILLER_21_378 VPWR VGND sg13g2_decap_8
XFILLER_21_389 VPWR VGND sg13g2_fill_1
X_5056__372 VPWR VGND net372 sg13g2_tiehi
X_4746_ net713 net756 _0081_ VPWR VGND sg13g2_nor2_1
X_4677_ net696 net741 _0014_ VPWR VGND sg13g2_nor2_1
X_3628_ videogen.test_lut_thingy.pixel_feeder_inst.row\[7\]\[2\] net576 _1281_ VPWR
+ VGND sg13g2_nor2_1
Xoutput17 net17 uo_out[4] VPWR VGND sg13g2_buf_1
X_3559_ _1210_ _1211_ _1212_ VPWR VGND sg13g2_and2_1
X_5229_ net291 VGND VPWR _0557_ videogen.test_lut_thingy.pixel_feeder_inst.row\[47\]\[1\]
+ _0186_ sg13g2_dfrbpq_1
XFILLER_45_927 VPWR VGND sg13g2_decap_8
XFILLER_25_673 VPWR VGND sg13g2_decap_8
XFILLER_40_665 VPWR VGND sg13g2_decap_8
XFILLER_8_305 VPWR VGND sg13g2_decap_4
XFILLER_12_367 VPWR VGND sg13g2_fill_1
XFILLER_13_879 VPWR VGND sg13g2_decap_4
XFILLER_8_338 VPWR VGND sg13g2_fill_1
XFILLER_21_50 VPWR VGND sg13g2_fill_1
XFILLER_21_72 VPWR VGND sg13g2_decap_8
XFILLER_4_566 VPWR VGND sg13g2_decap_4
XFILLER_0_783 VPWR VGND sg13g2_decap_8
X_5222__328 VPWR VGND net328 sg13g2_tiehi
XFILLER_35_404 VPWR VGND sg13g2_fill_1
XFILLER_35_415 VPWR VGND sg13g2_fill_2
XFILLER_36_949 VPWR VGND sg13g2_fill_1
XFILLER_44_971 VPWR VGND sg13g2_decap_8
X_2930_ videogen.test_lut_thingy.pixel_feeder_inst.row\[5\]\[2\] net784 _0799_ _0486_
+ VPWR VGND sg13g2_mux2_1
X_5272__440 VPWR VGND net440 sg13g2_tiehi
XFILLER_15_194 VPWR VGND sg13g2_decap_8
XFILLER_31_632 VPWR VGND sg13g2_fill_1
X_5335__161 VPWR VGND net161 sg13g2_tiehi
X_2861_ videogen.test_lut_thingy.pixel_feeder_inst.row\[4\]\[1\] net795 _0785_ _0549_
+ VPWR VGND sg13g2_mux2_1
XFILLER_31_665 VPWR VGND sg13g2_fill_1
X_4600_ _2211_ _2212_ _0617_ VPWR VGND sg13g2_nor2_1
X_2792_ _0741_ _0747_ _0763_ VPWR VGND sg13g2_nor2_2
XFILLER_30_197 VPWR VGND sg13g2_fill_1
XFILLER_8_883 VPWR VGND sg13g2_decap_8
X_4531_ _2148_ blue\[1\] net619 VPWR VGND sg13g2_nand2_1
X_4462_ _2087_ _2086_ _2085_ VPWR VGND sg13g2_nand2b_1
X_3413_ _1065_ VPWR _1066_ VGND _1035_ _1062_ sg13g2_o21ai_1
Xfanout807 net809 net807 VPWR VGND sg13g2_buf_8
X_4393_ _2032_ _1998_ _2024_ VPWR VGND sg13g2_nand2_1
X_3344_ net762 _1006_ _0352_ VPWR VGND sg13g2_nor2_1
X_3275_ _0953_ videogen.fancy_shader.n646\[0\] _0908_ VPWR VGND sg13g2_nand2_1
X_5014_ net431 VGND VPWR _0346_ videogen.fancy_shader.n646\[9\] net649 sg13g2_dfrbpq_2
XFILLER_38_253 VPWR VGND sg13g2_fill_1
XFILLER_26_28 VPWR VGND sg13g2_decap_8
XFILLER_35_971 VPWR VGND sg13g2_fill_1
XFILLER_35_993 VPWR VGND sg13g2_decap_8
XFILLER_10_805 VPWR VGND sg13g2_fill_2
X_4729_ net685 net730 _0064_ VPWR VGND sg13g2_nor2_1
XFILLER_1_558 VPWR VGND sg13g2_decap_8
XFILLER_27_1025 VPWR VGND sg13g2_decap_4
XFILLER_49_518 VPWR VGND sg13g2_decap_8
XFILLER_45_713 VPWR VGND sg13g2_fill_2
XFILLER_18_916 VPWR VGND sg13g2_decap_8
XFILLER_44_223 VPWR VGND sg13g2_decap_8
XFILLER_44_245 VPWR VGND sg13g2_fill_1
XFILLER_44_234 VPWR VGND sg13g2_fill_1
XFILLER_17_448 VPWR VGND sg13g2_fill_1
XFILLER_26_971 VPWR VGND sg13g2_decap_8
XFILLER_16_83 VPWR VGND sg13g2_decap_4
XFILLER_41_996 VPWR VGND sg13g2_decap_8
XFILLER_8_113 VPWR VGND sg13g2_decap_8
XFILLER_12_175 VPWR VGND sg13g2_fill_1
XFILLER_8_157 VPWR VGND sg13g2_decap_4
XFILLER_12_197 VPWR VGND sg13g2_decap_8
XFILLER_5_864 VPWR VGND sg13g2_decap_4
XFILLER_4_352 VPWR VGND sg13g2_decap_8
XFILLER_4_385 VPWR VGND sg13g2_decap_4
XFILLER_0_580 VPWR VGND sg13g2_decap_4
X_3060_ videogen.test_lut_thingy.pixel_feeder_inst.row\[37\]\[0\] net802 _0827_ _0325_
+ VPWR VGND sg13g2_mux2_1
XFILLER_24_919 VPWR VGND sg13g2_decap_8
XFILLER_35_267 VPWR VGND sg13g2_fill_2
XFILLER_16_481 VPWR VGND sg13g2_decap_8
X_3962_ _1610_ _1611_ _1612_ _1613_ _1614_ VPWR VGND sg13g2_nor4_1
X_2913_ _0796_ _0763_ VPWR VGND _0744_ sg13g2_nand2b_2
X_3893_ _1497_ _1545_ net2 _1546_ VPWR VGND sg13g2_nand3_1
X_2844_ videogen.test_lut_thingy.pixel_feeder_inst.row\[46\]\[3\] net769 _0782_ _0563_
+ VPWR VGND sg13g2_mux2_1
X_4514_ VGND VPWR net622 _2134_ _0509_ net764 sg13g2_a21oi_1
X_2775_ _0729_ _0757_ _0758_ VPWR VGND sg13g2_nor2_2
X_4445_ VGND VPWR net622 _2073_ _0417_ net764 sg13g2_a21oi_1
Xfanout615 net617 net615 VPWR VGND sg13g2_buf_8
Xfanout604 _0692_ net604 VPWR VGND sg13g2_buf_8
X_4376_ _1993_ _2014_ _2015_ _2016_ VPWR VGND sg13g2_nor3_1
Xfanout648 net649 net648 VPWR VGND sg13g2_buf_8
Xfanout626 net628 net626 VPWR VGND sg13g2_buf_8
Xfanout637 net638 net637 VPWR VGND sg13g2_buf_8
X_3327_ videogen.fancy_shader.video_y\[1\] _0992_ _0994_ VPWR VGND sg13g2_and2_1
Xfanout659 net660 net659 VPWR VGND sg13g2_buf_8
XFILLER_37_49 VPWR VGND sg13g2_fill_2
XFILLER_37_38 VPWR VGND sg13g2_decap_8
X_3258_ _0904_ _0938_ _0942_ VPWR VGND sg13g2_nor2_1
X_3189_ net642 _0841_ _0893_ VPWR VGND sg13g2_nor2_1
XFILLER_2_1027 VPWR VGND sg13g2_fill_2
XFILLER_2_1016 VPWR VGND sg13g2_decap_8
X_5240__247 VPWR VGND net247 sg13g2_tiehi
XFILLER_27_724 VPWR VGND sg13g2_decap_8
XFILLER_42_705 VPWR VGND sg13g2_fill_2
XFILLER_26_223 VPWR VGND sg13g2_decap_8
XFILLER_27_746 VPWR VGND sg13g2_fill_2
XFILLER_26_256 VPWR VGND sg13g2_decap_8
XFILLER_23_930 VPWR VGND sg13g2_decap_8
XFILLER_22_451 VPWR VGND sg13g2_fill_2
XFILLER_10_646 VPWR VGND sg13g2_decap_8
XFILLER_2_834 VPWR VGND sg13g2_decap_8
XFILLER_18_724 VPWR VGND sg13g2_decap_8
XFILLER_45_598 VPWR VGND sg13g2_decap_8
X_5007__31 VPWR VGND net31 sg13g2_tiehi
XFILLER_14_974 VPWR VGND sg13g2_decap_8
XFILLER_43_92 VPWR VGND sg13g2_decap_8
XFILLER_13_462 VPWR VGND sg13g2_fill_1
XFILLER_40_292 VPWR VGND sg13g2_fill_1
X_4230_ _1861_ _1875_ _1876_ VPWR VGND sg13g2_nor2_1
X_5340__38 VPWR VGND net38 sg13g2_tiehi
X_4161_ _1797_ VPWR _1807_ VGND _1796_ _1800_ sg13g2_o21ai_1
X_3112_ VGND VPWR net604 net13 net555 net556 sg13g2_a21oi_2
X_4092_ VGND VPWR _1725_ _1740_ _1741_ _1732_ sg13g2_a21oi_1
X_3043_ videogen.test_lut_thingy.pixel_feeder_inst.row\[33\]\[2\] net780 _0824_ _0381_
+ VPWR VGND sg13g2_mux2_1
XFILLER_48_381 VPWR VGND sg13g2_decap_8
XFILLER_24_705 VPWR VGND sg13g2_decap_4
X_4994_ net57 VGND VPWR _0326_ videogen.test_lut_thingy.pixel_feeder_inst.row\[37\]\[1\]
+ _0022_ sg13g2_dfrbpq_1
X_3945_ _0683_ _1585_ _1596_ _1597_ VPWR VGND sg13g2_nor3_2
XFILLER_20_900 VPWR VGND sg13g2_decap_8
XFILLER_32_760 VPWR VGND sg13g2_decap_4
XFILLER_23_29 VPWR VGND sg13g2_fill_2
XFILLER_20_977 VPWR VGND sg13g2_decap_8
X_3876_ videogen.test_lut_thingy.pixel_feeder_inst.row\[13\]\[3\] net567 _1529_ VPWR
+ VGND sg13g2_nor2_1
X_2827_ videogen.test_lut_thingy.pixel_feeder_inst.row\[43\]\[2\] net781 _0776_ _0574_
+ VPWR VGND sg13g2_mux2_1
X_2758_ _0749_ _0748_ VPWR VGND sg13g2_inv_8
X_4428_ VPWR _2064_ _2063_ VGND sg13g2_inv_1
X_2689_ VPWR _0697_ tmds_red.dc_balancing_reg\[3\] VGND sg13g2_inv_1
XFILLER_24_1017 VPWR VGND sg13g2_decap_8
X_4359_ _1999_ tmds_red.dc_balancing_reg\[2\] _1986_ VPWR VGND sg13g2_xnor2_1
X_5207__418 VPWR VGND net418 sg13g2_tiehi
XFILLER_24_1028 VPWR VGND sg13g2_fill_1
XFILLER_42_579 VPWR VGND sg13g2_decap_4
XFILLER_11_933 VPWR VGND sg13g2_decap_8
XFILLER_7_926 VPWR VGND sg13g2_decap_8
XFILLER_22_281 VPWR VGND sg13g2_decap_8
XFILLER_10_465 VPWR VGND sg13g2_fill_2
XFILLER_2_642 VPWR VGND sg13g2_decap_8
XFILLER_1_152 VPWR VGND sg13g2_fill_2
XFILLER_49_145 VPWR VGND sg13g2_decap_8
XFILLER_49_167 VPWR VGND sg13g2_decap_4
XFILLER_46_841 VPWR VGND sg13g2_decap_8
XFILLER_18_587 VPWR VGND sg13g2_decap_8
XFILLER_33_502 VPWR VGND sg13g2_decap_4
XFILLER_33_524 VPWR VGND sg13g2_decap_8
XFILLER_33_579 VPWR VGND sg13g2_fill_2
X_3730_ videogen.test_lut_thingy.pixel_feeder_inst.row\[14\]\[1\] net588 _1383_ VPWR
+ VGND sg13g2_nor2_1
X_3661_ net610 VPWR _1314_ VGND videogen.test_lut_thingy.pixel_feeder_inst.row\[55\]\[2\]
+ net579 sg13g2_o21ai_1
X_3592_ _1244_ VPWR _1245_ VGND _1232_ _1243_ sg13g2_o21ai_1
X_5331_ net197 VGND VPWR _0659_ serialize.shift_reg_r\[1\] clknet_3_5_0_clk_regs sg13g2_dfrbpq_1
XFILLER_47_1028 VPWR VGND sg13g2_fill_1
XFILLER_5_491 VPWR VGND sg13g2_fill_2
X_5262_ net140 VGND VPWR _0590_ videogen.test_lut_thingy.pixel_feeder_inst.row\[3\]\[2\]
+ _0219_ sg13g2_dfrbpq_1
X_4213_ VGND VPWR _1859_ _1765_ _1667_ sg13g2_or2_1
X_5193_ net60 VGND VPWR _0521_ videogen.test_lut_thingy.pixel_feeder_inst.row\[27\]\[1\]
+ _0150_ sg13g2_dfrbpq_1
X_4144_ _1788_ _1787_ _1779_ _1790_ VPWR VGND sg13g2_a21o_1
X_4075_ _1716_ _1720_ _1724_ VPWR VGND sg13g2_nor2_1
X_3026_ _0821_ _0728_ _0740_ VPWR VGND sg13g2_nand2_2
XFILLER_36_351 VPWR VGND sg13g2_decap_8
XFILLER_24_568 VPWR VGND sg13g2_decap_8
XFILLER_24_579 VPWR VGND sg13g2_fill_2
X_4977_ net91 VGND VPWR _0309_ videogen.test_lut_thingy.pixel_feeder_inst.v_pix\[4\]
+ net643 sg13g2_dfrbpq_1
XFILLER_11_218 VPWR VGND sg13g2_decap_8
X_3928_ net610 VPWR _1580_ VGND videogen.test_lut_thingy.pixel_feeder_inst.row\[18\]\[0\]
+ net586 sg13g2_o21ai_1
X_3859_ videogen.test_lut_thingy.pixel_feeder_inst.row\[31\]\[3\] net571 _1512_ VPWR
+ VGND sg13g2_nor2_1
XFILLER_20_763 VPWR VGND sg13g2_fill_2
XFILLER_20_774 VPWR VGND sg13g2_decap_4
XFILLER_20_796 VPWR VGND sg13g2_fill_1
XFILLER_1_7 VPWR VGND sg13g2_decap_8
XFILLER_47_605 VPWR VGND sg13g2_decap_8
XFILLER_46_159 VPWR VGND sg13g2_fill_2
XFILLER_27_340 VPWR VGND sg13g2_decap_8
XFILLER_15_535 VPWR VGND sg13g2_fill_2
XFILLER_27_384 VPWR VGND sg13g2_decap_8
XFILLER_27_395 VPWR VGND sg13g2_fill_1
XFILLER_42_354 VPWR VGND sg13g2_decap_8
XFILLER_42_365 VPWR VGND sg13g2_fill_1
X_5218__344 VPWR VGND net344 sg13g2_tiehi
X_4984__77 VPWR VGND net77 sg13g2_tiehi
XFILLER_24_83 VPWR VGND sg13g2_decap_8
XFILLER_7_712 VPWR VGND sg13g2_fill_1
XFILLER_6_211 VPWR VGND sg13g2_decap_8
XFILLER_3_995 VPWR VGND sg13g2_decap_8
XFILLER_2_494 VPWR VGND sg13g2_decap_8
XFILLER_1_21 VPWR VGND sg13g2_decap_8
XFILLER_1_98 VPWR VGND sg13g2_decap_8
XFILLER_18_340 VPWR VGND sg13g2_decap_8
XFILLER_34_811 VPWR VGND sg13g2_fill_2
X_4900_ net696 net741 _0235_ VPWR VGND sg13g2_nor2_1
XFILLER_33_310 VPWR VGND sg13g2_fill_2
XFILLER_34_855 VPWR VGND sg13g2_decap_4
X_4831_ net705 net751 _0166_ VPWR VGND sg13g2_nor2_1
XFILLER_33_398 VPWR VGND sg13g2_decap_8
X_4762_ net711 net751 _0097_ VPWR VGND sg13g2_nor2_1
X_3713_ videogen.test_lut_thingy.pixel_feeder_inst.row\[28\]\[1\] net594 _1366_ VPWR
+ VGND sg13g2_nor2_1
XFILLER_14_1016 VPWR VGND sg13g2_decap_8
XFILLER_14_1027 VPWR VGND sg13g2_fill_2
X_4693_ net683 net728 _0030_ VPWR VGND sg13g2_nor2_1
X_3644_ videogen.test_lut_thingy.pixel_feeder_inst.row\[1\]\[2\] net567 _1297_ VPWR
+ VGND sg13g2_nor2_1
X_3575_ _1142_ _1222_ _1228_ VPWR VGND sg13g2_and2_1
X_5314_ net412 VGND VPWR _0642_ serialize.shift_reg_b\[0\] clknet_3_3_0_clk_regs sg13g2_dfrbpq_1
X_5245_ net227 VGND VPWR _0573_ videogen.test_lut_thingy.pixel_feeder_inst.row\[43\]\[1\]
+ _0202_ sg13g2_dfrbpq_1
Xhold17 serialize.shift_reg_r\[7\] VPWR VGND net462 sg13g2_dlygate4sd3_1
Xhold28 _2230_ VPWR VGND net473 sg13g2_dlygate4sd3_1
Xhold39 _2227_ VPWR VGND net484 sg13g2_dlygate4sd3_1
X_5176_ net123 VGND VPWR _0504_ videogen.test_lut_thingy.pixel_feeder_inst.row\[55\]\[0\]
+ _0141_ sg13g2_dfrbpq_1
X_4127_ _1773_ _1771_ _1772_ VPWR VGND sg13g2_xnor2_1
X_4058_ _1707_ _1704_ _1705_ _1702_ _1700_ VPWR VGND sg13g2_a22oi_1
X_3009_ videogen.test_lut_thingy.pixel_feeder_inst.row\[32\]\[1\] net791 _0817_ _0425_
+ VPWR VGND sg13g2_mux2_1
XFILLER_4_715 VPWR VGND sg13g2_decap_4
XFILLER_0_965 VPWR VGND sg13g2_decap_8
XFILLER_48_936 VPWR VGND sg13g2_decap_8
XFILLER_19_104 VPWR VGND sg13g2_fill_2
XFILLER_19_50 VPWR VGND sg13g2_decap_8
XFILLER_28_660 VPWR VGND sg13g2_decap_8
XFILLER_37_1016 VPWR VGND sg13g2_decap_8
XFILLER_16_877 VPWR VGND sg13g2_decap_8
XFILLER_42_173 VPWR VGND sg13g2_decap_8
XFILLER_42_162 VPWR VGND sg13g2_fill_1
XFILLER_37_1027 VPWR VGND sg13g2_fill_2
XFILLER_30_313 VPWR VGND sg13g2_decap_8
XFILLER_31_836 VPWR VGND sg13g2_fill_1
XFILLER_35_82 VPWR VGND sg13g2_fill_1
XFILLER_42_195 VPWR VGND sg13g2_decap_4
XFILLER_42_184 VPWR VGND sg13g2_fill_1
XFILLER_7_597 VPWR VGND sg13g2_fill_1
XFILLER_7_586 VPWR VGND sg13g2_fill_1
X_5012__435 VPWR VGND net435 sg13g2_tiehi
X_3360_ videogen.test_lut_thingy.gol_counter_reg\[1\] videogen.test_lut_thingy.gol_counter_reg\[2\]
+ videogen.test_lut_thingy.gol_counter_reg\[0\] _1016_ VPWR VGND sg13g2_nand3_1
X_3291_ _0961_ VPWR _0965_ VGND _0962_ _0963_ sg13g2_o21ai_1
X_5030_ net404 VGND VPWR _0362_ display_enable net654 sg13g2_dfrbpq_2
XFILLER_22_803 VPWR VGND sg13g2_fill_2
X_4814_ net695 net740 _0149_ VPWR VGND sg13g2_nor2_1
X_4745_ net672 net717 _0080_ VPWR VGND sg13g2_nor2_1
X_5236__263 VPWR VGND net263 sg13g2_tiehi
XFILLER_30_891 VPWR VGND sg13g2_decap_4
XFILLER_31_18 VPWR VGND sg13g2_fill_2
X_4676_ net697 net742 _0013_ VPWR VGND sg13g2_nor2_1
X_3627_ videogen.test_lut_thingy.pixel_feeder_inst.row\[6\]\[2\] net587 _1280_ VPWR
+ VGND sg13g2_nor2_1
Xoutput18 net18 uo_out[5] VPWR VGND sg13g2_buf_1
X_3558_ _1211_ _1194_ _1197_ VPWR VGND sg13g2_xnor2_1
XFILLER_0_217 VPWR VGND sg13g2_fill_2
X_3489_ _1142_ _1139_ _1141_ VPWR VGND sg13g2_xnor2_1
XFILLER_5_1014 VPWR VGND sg13g2_decap_8
X_5228_ net295 VGND VPWR _0556_ videogen.test_lut_thingy.pixel_feeder_inst.row\[47\]\[0\]
+ _0185_ sg13g2_dfrbpq_1
X_5159_ net184 VGND VPWR _0487_ videogen.test_lut_thingy.pixel_feeder_inst.row\[5\]\[3\]
+ _0124_ sg13g2_dfrbpq_1
XFILLER_45_906 VPWR VGND sg13g2_decap_8
XFILLER_25_652 VPWR VGND sg13g2_decap_8
XFILLER_25_696 VPWR VGND sg13g2_decap_8
XFILLER_4_501 VPWR VGND sg13g2_fill_2
XFILLER_48_700 VPWR VGND sg13g2_fill_1
XFILLER_0_762 VPWR VGND sg13g2_decap_8
XFILLER_47_221 VPWR VGND sg13g2_fill_1
XFILLER_44_950 VPWR VGND sg13g2_decap_8
XFILLER_16_663 VPWR VGND sg13g2_decap_8
X_2860_ videogen.test_lut_thingy.pixel_feeder_inst.row\[4\]\[2\] net784 _0785_ _0550_
+ VPWR VGND sg13g2_mux2_1
XFILLER_31_655 VPWR VGND sg13g2_fill_2
XFILLER_8_840 VPWR VGND sg13g2_decap_4
X_2791_ videogen.test_lut_thingy.pixel_feeder_inst.row\[38\]\[0\] net802 _0762_ _0596_
+ VPWR VGND sg13g2_mux2_1
XFILLER_30_176 VPWR VGND sg13g2_fill_1
XFILLER_7_53 VPWR VGND sg13g2_decap_4
X_4530_ VGND VPWR _2139_ _2146_ _0512_ _2147_ sg13g2_a21oi_1
X_4461_ _2084_ VPWR _2086_ VGND _2057_ _2075_ sg13g2_o21ai_1
XFILLER_7_372 VPWR VGND sg13g2_decap_4
X_3412_ _1060_ _1064_ _1065_ VPWR VGND sg13g2_and2_1
X_4392_ _2030_ VPWR _2031_ VGND _2015_ _2028_ sg13g2_o21ai_1
Xfanout808 net809 net808 VPWR VGND sg13g2_buf_8
X_3343_ _1006_ net623 _1005_ VPWR VGND sg13g2_xnor2_1
X_3274_ VGND VPWR _0952_ _0908_ videogen.fancy_shader.n646\[0\] sg13g2_or2_1
X_5013_ net433 VGND VPWR _0345_ videogen.fancy_shader.n646\[8\] net646 sg13g2_dfrbpq_2
XFILLER_26_449 VPWR VGND sg13g2_fill_1
XFILLER_22_655 VPWR VGND sg13g2_fill_1
XFILLER_10_828 VPWR VGND sg13g2_decap_8
X_2989_ videogen.test_lut_thingy.pixel_feeder_inst.row\[30\]\[1\] net789 _0813_ _0441_
+ VPWR VGND sg13g2_mux2_1
XFILLER_22_699 VPWR VGND sg13g2_decap_8
X_4728_ net685 net730 _0063_ VPWR VGND sg13g2_nor2_1
X_4659_ VPWR _0662_ net468 VGND sg13g2_inv_1
XFILLER_27_1004 VPWR VGND sg13g2_decap_8
XFILLER_29_243 VPWR VGND sg13g2_decap_8
XFILLER_26_950 VPWR VGND sg13g2_decap_8
XFILLER_13_600 VPWR VGND sg13g2_decap_4
XFILLER_25_482 VPWR VGND sg13g2_decap_8
XFILLER_25_493 VPWR VGND sg13g2_fill_1
XFILLER_12_154 VPWR VGND sg13g2_decap_8
XFILLER_34_1019 VPWR VGND sg13g2_decap_8
XFILLER_13_699 VPWR VGND sg13g2_decap_8
X_5188__80 VPWR VGND net80 sg13g2_tiehi
XFILLER_5_821 VPWR VGND sg13g2_decap_8
XFILLER_5_810 VPWR VGND sg13g2_fill_1
XFILLER_48_585 VPWR VGND sg13g2_decap_8
X_3961_ videogen.test_lut_thingy.pixel_feeder_inst.row\[58\]\[0\] net586 _1613_ VPWR
+ VGND sg13g2_nor2_1
X_2912_ videogen.test_lut_thingy.pixel_feeder_inst.row\[54\]\[0\] net807 _0795_ _0500_
+ VPWR VGND sg13g2_mux2_1
X_3892_ _1544_ VPWR _1545_ VGND _1508_ _1520_ sg13g2_o21ai_1
X_2843_ _0761_ _0770_ _0782_ VPWR VGND sg13g2_nor2_2
XFILLER_31_474 VPWR VGND sg13g2_fill_1
X_2774_ _0757_ _0699_ _0732_ VPWR VGND sg13g2_nand2_2
X_4513_ _2134_ _2103_ _2056_ _2065_ _2059_ VPWR VGND sg13g2_a22oi_1
X_4444_ _2067_ _1955_ _2073_ VPWR VGND sg13g2_xor2_1
Xfanout605 _0689_ net605 VPWR VGND sg13g2_buf_8
X_4375_ _2009_ _2012_ _2015_ VPWR VGND sg13g2_and2_1
Xfanout616 net617 net616 VPWR VGND sg13g2_buf_1
Xfanout638 videogen.test_lut_thingy.pixel_feeder_inst.h_pix\[2\] net638 VPWR VGND
+ sg13g2_buf_8
Xfanout649 net661 net649 VPWR VGND sg13g2_buf_8
X_3326_ _0992_ _0993_ _0347_ VPWR VGND sg13g2_nor2_1
Xfanout627 net628 net627 VPWR VGND sg13g2_buf_1
X_3257_ _0909_ _0940_ _0941_ _0318_ VPWR VGND sg13g2_nor3_1
X_3188_ net762 _0841_ _0892_ _0298_ VPWR VGND sg13g2_nor3_1
XFILLER_27_769 VPWR VGND sg13g2_fill_1
XFILLER_22_463 VPWR VGND sg13g2_decap_4
XFILLER_23_986 VPWR VGND sg13g2_decap_8
XFILLER_22_496 VPWR VGND sg13g2_decap_4
XFILLER_49_305 VPWR VGND sg13g2_decap_8
XFILLER_40_1012 VPWR VGND sg13g2_decap_8
XFILLER_45_577 VPWR VGND sg13g2_decap_8
XFILLER_27_94 VPWR VGND sg13g2_decap_8
XFILLER_14_953 VPWR VGND sg13g2_decap_8
XFILLER_41_794 VPWR VGND sg13g2_fill_1
XFILLER_9_467 VPWR VGND sg13g2_decap_8
XFILLER_9_489 VPWR VGND sg13g2_fill_2
XFILLER_5_640 VPWR VGND sg13g2_fill_2
XFILLER_4_32 VPWR VGND sg13g2_decap_8
XFILLER_4_54 VPWR VGND sg13g2_fill_2
X_4160_ _1796_ _1797_ _1800_ _1806_ VPWR VGND sg13g2_or3_1
X_3111_ VGND VPWR net556 _0855_ net10 net604 sg13g2_a21oi_1
X_4091_ _1729_ _1730_ _1726_ _1740_ VPWR VGND sg13g2_nand3_1
X_3042_ videogen.test_lut_thingy.pixel_feeder_inst.row\[33\]\[3\] net770 _0824_ _0382_
+ VPWR VGND sg13g2_mux2_1
XFILLER_36_588 VPWR VGND sg13g2_decap_8
X_4993_ net59 VGND VPWR _0325_ videogen.test_lut_thingy.pixel_feeder_inst.row\[37\]\[0\]
+ _0021_ sg13g2_dfrbpq_1
XFILLER_36_599 VPWR VGND sg13g2_fill_2
X_3944_ net606 _1590_ _1595_ _1596_ VPWR VGND sg13g2_nor3_1
X_3875_ videogen.test_lut_thingy.pixel_feeder_inst.row\[14\]\[3\] net588 _1528_ VPWR
+ VGND sg13g2_nor2_1
X_2826_ videogen.test_lut_thingy.pixel_feeder_inst.row\[43\]\[3\] net771 _0776_ _0575_
+ VPWR VGND sg13g2_mux2_1
XFILLER_20_956 VPWR VGND sg13g2_decap_8
X_2757_ _0742_ _0747_ _0748_ VPWR VGND sg13g2_nor2_2
X_2688_ VPWR _0696_ net1 VGND sg13g2_inv_1
X_4427_ _2062_ VPWR _2063_ VGND _2055_ _2058_ sg13g2_o21ai_1
XFILLER_48_49 VPWR VGND sg13g2_decap_4
X_4358_ _1998_ tmds_red.dc_balancing_reg\[2\] _1986_ VPWR VGND sg13g2_nand2_1
X_3309_ VPWR VGND _0908_ net766 _0981_ _0681_ _0341_ _0960_ sg13g2_a221oi_1
X_4289_ VGND VPWR _1844_ _1934_ _1935_ _0696_ sg13g2_a21oi_1
XFILLER_39_371 VPWR VGND sg13g2_decap_8
XFILLER_27_566 VPWR VGND sg13g2_decap_4
XFILLER_15_739 VPWR VGND sg13g2_decap_4
XFILLER_27_599 VPWR VGND sg13g2_decap_8
X_4996__53 VPWR VGND net53 sg13g2_tiehi
XFILLER_11_912 VPWR VGND sg13g2_decap_8
XFILLER_23_794 VPWR VGND sg13g2_decap_8
XFILLER_7_905 VPWR VGND sg13g2_decap_8
XFILLER_10_444 VPWR VGND sg13g2_decap_8
XFILLER_11_989 VPWR VGND sg13g2_decap_8
XFILLER_2_654 VPWR VGND sg13g2_fill_2
XFILLER_46_820 VPWR VGND sg13g2_decap_8
XFILLER_45_330 VPWR VGND sg13g2_decap_8
XFILLER_46_897 VPWR VGND sg13g2_decap_8
XFILLER_33_569 VPWR VGND sg13g2_decap_4
XFILLER_14_761 VPWR VGND sg13g2_decap_8
XFILLER_9_220 VPWR VGND sg13g2_fill_1
X_3660_ net637 _1307_ _1312_ _1313_ VPWR VGND sg13g2_nor3_1
X_3591_ _1229_ _1233_ _1183_ _1244_ VPWR VGND sg13g2_nand3_1
X_5330_ net205 VGND VPWR _0658_ serialize.shift_reg_r\[0\] clknet_3_5_0_clk_regs sg13g2_dfrbpq_1
XFILLER_47_1007 VPWR VGND sg13g2_decap_8
X_5261_ net148 VGND VPWR _0589_ videogen.test_lut_thingy.pixel_feeder_inst.row\[3\]\[1\]
+ _0218_ sg13g2_dfrbpq_1
X_4212_ _1858_ _0979_ _1716_ VPWR VGND sg13g2_xnor2_1
X_5192_ net64 VGND VPWR _0520_ videogen.test_lut_thingy.pixel_feeder_inst.row\[27\]\[0\]
+ _0149_ sg13g2_dfrbpq_1
X_4143_ _1787_ _1788_ _1779_ _1789_ VPWR VGND sg13g2_nand3_1
X_5083__188 VPWR VGND net188 sg13g2_tiehi
X_4074_ _1721_ _1713_ _1723_ VPWR VGND sg13g2_xor2_1
X_3025_ net807 videogen.test_lut_thingy.pixel_feeder_inst.row\[15\]\[0\] _0820_ _0403_
+ VPWR VGND sg13g2_mux2_1
XFILLER_37_864 VPWR VGND sg13g2_decap_8
X_5022__415 VPWR VGND net415 sg13g2_tiehi
XFILLER_36_396 VPWR VGND sg13g2_decap_4
X_4976_ net93 VGND VPWR _0308_ videogen.test_lut_thingy.pixel_feeder_inst.v_pix\[3\]
+ net643 sg13g2_dfrbpq_2
X_3927_ _1575_ _1576_ _1577_ _1578_ _1579_ VPWR VGND sg13g2_nor4_1
XFILLER_32_591 VPWR VGND sg13g2_decap_8
X_3858_ videogen.test_lut_thingy.pixel_feeder_inst.row\[29\]\[3\] net560 _1511_ VPWR
+ VGND sg13g2_nor2_1
X_2809_ videogen.test_lut_thingy.pixel_feeder_inst.row\[40\]\[3\] net769 _0771_ _0587_
+ VPWR VGND sg13g2_mux2_1
X_3789_ net607 VPWR _1442_ VGND videogen.test_lut_thingy.pixel_feeder_inst.row\[32\]\[1\]
+ net595 sg13g2_o21ai_1
XFILLER_8_1023 VPWR VGND sg13g2_decap_4
XFILLER_46_105 VPWR VGND sg13g2_fill_1
XFILLER_46_127 VPWR VGND sg13g2_decap_8
XFILLER_43_867 VPWR VGND sg13g2_decap_8
XFILLER_42_322 VPWR VGND sg13g2_fill_2
XFILLER_30_528 VPWR VGND sg13g2_decap_8
XFILLER_42_399 VPWR VGND sg13g2_fill_2
XFILLER_11_786 VPWR VGND sg13g2_decap_8
XFILLER_40_61 VPWR VGND sg13g2_fill_2
XFILLER_40_83 VPWR VGND sg13g2_decap_4
XFILLER_3_974 VPWR VGND sg13g2_decap_8
XFILLER_49_70 VPWR VGND sg13g2_decap_8
XFILLER_37_149 VPWR VGND sg13g2_fill_2
XFILLER_1_77 VPWR VGND sg13g2_decap_8
XFILLER_45_171 VPWR VGND sg13g2_decap_8
XFILLER_45_160 VPWR VGND sg13g2_fill_1
X_4830_ net706 net750 _0165_ VPWR VGND sg13g2_nor2_1
X_4761_ net712 net759 _0096_ VPWR VGND sg13g2_nor2_1
X_3712_ videogen.test_lut_thingy.pixel_feeder_inst.row\[29\]\[1\] net560 _1365_ VPWR
+ VGND sg13g2_nor2_1
X_4692_ net683 net728 _0029_ VPWR VGND sg13g2_nor2_1
X_3643_ videogen.test_lut_thingy.pixel_feeder_inst.row\[2\]\[2\] net588 _1296_ VPWR
+ VGND sg13g2_nor2_1
X_5313_ net428 VGND VPWR _0641_ videogen.test_lut_thingy.pixel_feeder_inst.row\[21\]\[3\]
+ _0260_ sg13g2_dfrbpq_1
X_3574_ VGND VPWR _1227_ _1226_ _1029_ sg13g2_or2_1
X_5244_ net231 VGND VPWR _0572_ videogen.test_lut_thingy.pixel_feeder_inst.row\[43\]\[0\]
+ _0201_ sg13g2_dfrbpq_1
Xhold29 serialize.shift_reg_g\[9\] VPWR VGND net474 sg13g2_dlygate4sd3_1
X_5175_ net134 VGND VPWR _0503_ videogen.test_lut_thingy.pixel_feeder_inst.row\[54\]\[3\]
+ _0140_ sg13g2_dfrbpq_1
Xhold18 serialize.shift_reg_b\[2\] VPWR VGND net463 sg13g2_dlygate4sd3_1
X_4126_ _1044_ _1099_ _1761_ _1772_ VPWR VGND sg13g2_nor3_1
X_4057_ _1704_ _1705_ _1706_ VPWR VGND sg13g2_and2_1
XFILLER_37_683 VPWR VGND sg13g2_fill_1
X_3008_ videogen.test_lut_thingy.pixel_feeder_inst.row\[32\]\[2\] net780 _0817_ _0426_
+ VPWR VGND sg13g2_mux2_1
XFILLER_24_300 VPWR VGND sg13g2_fill_1
XFILLER_25_845 VPWR VGND sg13g2_decap_4
X_4959_ net116 VGND VPWR _0291_ videogen.test_lut_thingy.pixel_feeder_inst.row\[20\]\[1\]
+ _0018_ sg13g2_dfrbpq_1
XFILLER_10_20 VPWR VGND sg13g2_fill_1
XFILLER_10_53 VPWR VGND sg13g2_fill_1
XFILLER_0_944 VPWR VGND sg13g2_decap_8
XFILLER_48_915 VPWR VGND sg13g2_decap_8
XFILLER_47_414 VPWR VGND sg13g2_decap_4
XFILLER_19_62 VPWR VGND sg13g2_decap_8
XFILLER_35_609 VPWR VGND sg13g2_fill_1
XFILLER_16_823 VPWR VGND sg13g2_decap_8
XFILLER_15_355 VPWR VGND sg13g2_fill_1
XFILLER_31_815 VPWR VGND sg13g2_decap_4
XFILLER_15_388 VPWR VGND sg13g2_decap_8
XFILLER_11_550 VPWR VGND sg13g2_decap_8
XFILLER_11_572 VPWR VGND sg13g2_decap_8
X_3290_ videogen.fancy_shader.video_x\[1\] videogen.fancy_shader.n646\[1\] _0964_
+ VPWR VGND sg13g2_xor2_1
XFILLER_2_270 VPWR VGND sg13g2_fill_1
XFILLER_25_4 VPWR VGND sg13g2_decap_8
XFILLER_39_959 VPWR VGND sg13g2_decap_8
X_5299__225 VPWR VGND net225 sg13g2_tiehi
XFILLER_19_650 VPWR VGND sg13g2_fill_2
X_5160__182 VPWR VGND net182 sg13g2_tiehi
XFILLER_19_672 VPWR VGND sg13g2_fill_1
XFILLER_19_694 VPWR VGND sg13g2_decap_4
X_4813_ net672 net717 _0148_ VPWR VGND sg13g2_nor2_1
XFILLER_22_859 VPWR VGND sg13g2_fill_1
X_4744_ net672 net717 _0079_ VPWR VGND sg13g2_nor2_1
X_4675_ net703 net748 _0012_ VPWR VGND sg13g2_nor2_1
X_3626_ videogen.test_lut_thingy.pixel_feeder_inst.row\[4\]\[2\] net598 _1279_ VPWR
+ VGND sg13g2_nor2_1
Xoutput19 net19 uo_out[6] VPWR VGND sg13g2_buf_1
X_3557_ _1195_ VPWR _1210_ VGND _1199_ _1203_ sg13g2_o21ai_1
XFILLER_0_207 VPWR VGND sg13g2_fill_2
X_5227_ net299 VGND VPWR _0555_ videogen.test_lut_thingy.pixel_feeder_inst.row\[48\]\[3\]
+ _0184_ sg13g2_dfrbpq_1
X_3488_ _1141_ _0970_ _1140_ VPWR VGND sg13g2_xnor2_1
X_5243__235 VPWR VGND net235 sg13g2_tiehi
X_5158_ net190 VGND VPWR _0486_ videogen.test_lut_thingy.pixel_feeder_inst.row\[5\]\[2\]
+ _0123_ sg13g2_dfrbpq_1
X_4109_ _1169_ _0979_ _1755_ VPWR VGND sg13g2_xor2_1
XFILLER_29_469 VPWR VGND sg13g2_decap_8
X_5089_ net321 VGND VPWR _0417_ red_tmds_par\[6\] net657 sg13g2_dfrbpq_1
XFILLER_13_826 VPWR VGND sg13g2_decap_8
XFILLER_12_347 VPWR VGND sg13g2_fill_2
XFILLER_21_870 VPWR VGND sg13g2_fill_2
X_5070__349 VPWR VGND net349 sg13g2_tiehi
XFILLER_21_41 VPWR VGND sg13g2_decap_8
XFILLER_0_741 VPWR VGND sg13g2_decap_8
XFILLER_43_1021 VPWR VGND sg13g2_decap_8
XFILLER_48_745 VPWR VGND sg13g2_fill_1
XFILLER_48_789 VPWR VGND sg13g2_decap_8
XFILLER_29_992 VPWR VGND sg13g2_decap_8
XFILLER_35_417 VPWR VGND sg13g2_fill_1
XFILLER_46_93 VPWR VGND sg13g2_fill_1
XFILLER_16_631 VPWR VGND sg13g2_decap_8
X_4940__147 VPWR VGND net147 sg13g2_tiehi
XFILLER_31_623 VPWR VGND sg13g2_fill_2
XFILLER_12_870 VPWR VGND sg13g2_decap_8
X_2790_ videogen.test_lut_thingy.pixel_feeder_inst.row\[38\]\[1\] net791 _0762_ _0597_
+ VPWR VGND sg13g2_mux2_1
XFILLER_7_32 VPWR VGND sg13g2_decap_8
X_4460_ _2057_ _2075_ _2084_ _2085_ VPWR VGND sg13g2_nor3_1
XFILLER_7_76 VPWR VGND sg13g2_decap_8
X_3411_ VGND VPWR _1064_ _1063_ _1041_ sg13g2_or2_1
X_4391_ VGND VPWR _2015_ _2028_ _2030_ _1993_ sg13g2_a21oi_1
X_3342_ net763 _1003_ _1005_ _0351_ VPWR VGND sg13g2_nor3_1
Xfanout809 ui_in[4] net809 VPWR VGND sg13g2_buf_8
X_3273_ _0946_ _0951_ _0324_ VPWR VGND sg13g2_nor2_1
X_5012_ net435 VGND VPWR _0344_ videogen.fancy_shader.n646\[7\] net649 sg13g2_dfrbpq_2
XFILLER_27_918 VPWR VGND sg13g2_fill_2
X_5277__375 VPWR VGND net375 sg13g2_tiehi
XFILLER_35_984 VPWR VGND sg13g2_decap_4
X_5318__350 VPWR VGND net350 sg13g2_tiehi
XFILLER_10_807 VPWR VGND sg13g2_fill_1
XFILLER_22_678 VPWR VGND sg13g2_decap_8
X_2988_ videogen.test_lut_thingy.pixel_feeder_inst.row\[30\]\[2\] net778 _0813_ _0442_
+ VPWR VGND sg13g2_mux2_1
XFILLER_21_188 VPWR VGND sg13g2_decap_4
X_4727_ net686 net730 _0062_ VPWR VGND sg13g2_nor2_1
X_4658_ _2244_ net666 net467 net671 red_tmds_par\[4\] VPWR VGND sg13g2_a22oi_1
X_3609_ videogen.test_lut_thingy.pixel_feeder_inst.row\[24\]\[2\] net598 _1262_ VPWR
+ VGND sg13g2_nor2_1
X_4589_ _2204_ _2201_ _2203_ VPWR VGND sg13g2_xnor2_1
XFILLER_1_505 VPWR VGND sg13g2_fill_1
XFILLER_17_428 VPWR VGND sg13g2_decap_4
XFILLER_45_759 VPWR VGND sg13g2_fill_1
XFILLER_13_612 VPWR VGND sg13g2_decap_8
XFILLER_13_645 VPWR VGND sg13g2_decap_8
XFILLER_5_888 VPWR VGND sg13g2_decap_8
XFILLER_4_398 VPWR VGND sg13g2_decap_8
XFILLER_48_564 VPWR VGND sg13g2_decap_8
XFILLER_17_984 VPWR VGND sg13g2_decap_8
X_3960_ videogen.test_lut_thingy.pixel_feeder_inst.row\[59\]\[0\] net572 _1612_ VPWR
+ VGND sg13g2_nor2_1
XFILLER_32_910 VPWR VGND sg13g2_fill_1
XFILLER_35_269 VPWR VGND sg13g2_fill_1
X_2911_ videogen.test_lut_thingy.pixel_feeder_inst.row\[54\]\[1\] net797 _0795_ _0501_
+ VPWR VGND sg13g2_mux2_1
X_3891_ videogen.test_lut_thingy.pixel_feeder_inst.h_pix\[5\] _1543_ _1544_ VPWR VGND
+ sg13g2_nor2_1
X_2842_ videogen.test_lut_thingy.pixel_feeder_inst.row\[45\]\[0\] net803 _0781_ _0564_
+ VPWR VGND sg13g2_mux2_1
XFILLER_32_987 VPWR VGND sg13g2_decap_8
X_2773_ net802 videogen.test_lut_thingy.pixel_feeder_inst.row\[39\]\[0\] _0756_ _0608_
+ VPWR VGND sg13g2_mux2_1
X_4512_ VGND VPWR net605 net622 _0508_ net764 sg13g2_a21oi_1
X_5053__377 VPWR VGND net377 sg13g2_tiehi
X_4443_ VGND VPWR net622 _2072_ _0416_ net764 sg13g2_a21oi_1
Xfanout606 net609 net606 VPWR VGND sg13g2_buf_8
X_4374_ _2009_ _2013_ _2014_ VPWR VGND sg13g2_nor2_1
Xfanout639 videogen.test_lut_thingy.pixel_feeder_inst.h_pix\[1\] net639 VPWR VGND
+ sg13g2_buf_8
Xfanout628 videogen.test_lut_thingy.pixel_feeder_inst.h_pix\[4\] net628 VPWR VGND
+ sg13g2_buf_8
X_3325_ net812 VPWR _0993_ VGND videogen.fancy_shader.video_y\[0\] _0887_ sg13g2_o21ai_1
Xfanout617 green\[0\] net617 VPWR VGND sg13g2_buf_2
X_3256_ videogen.test_lut_thingy.pixel_feeder_inst.v_counter\[1\] _0904_ _0941_ VPWR
+ VGND sg13g2_nor2b_1
XFILLER_39_564 VPWR VGND sg13g2_decap_4
X_3187_ videogen.fancy_shader.video_x\[4\] _0840_ _0892_ VPWR VGND sg13g2_nor2_1
XFILLER_39_597 VPWR VGND sg13g2_decap_8
XFILLER_27_759 VPWR VGND sg13g2_decap_4
XFILLER_42_718 VPWR VGND sg13g2_fill_2
XFILLER_41_228 VPWR VGND sg13g2_fill_2
XFILLER_41_217 VPWR VGND sg13g2_decap_8
XFILLER_23_965 VPWR VGND sg13g2_decap_8
XFILLER_10_615 VPWR VGND sg13g2_fill_2
XFILLER_10_626 VPWR VGND sg13g2_fill_1
XFILLER_10_659 VPWR VGND sg13g2_fill_1
XFILLER_5_107 VPWR VGND sg13g2_fill_2
X_5069__351 VPWR VGND net351 sg13g2_tiehi
XFILLER_2_869 VPWR VGND sg13g2_decap_8
XFILLER_49_328 VPWR VGND sg13g2_decap_8
XFILLER_18_704 VPWR VGND sg13g2_fill_2
XFILLER_27_40 VPWR VGND sg13g2_fill_2
XFILLER_45_556 VPWR VGND sg13g2_decap_8
XFILLER_14_932 VPWR VGND sg13g2_decap_8
XFILLER_13_453 VPWR VGND sg13g2_decap_8
XFILLER_4_173 VPWR VGND sg13g2_decap_4
XFILLER_4_11 VPWR VGND sg13g2_decap_8
XFILLER_4_66 VPWR VGND sg13g2_decap_8
XFILLER_4_44 VPWR VGND sg13g2_fill_1
X_3110_ _0855_ net634 _0699_ VPWR VGND sg13g2_xnor2_1
XFILLER_0_390 VPWR VGND sg13g2_fill_2
X_4090_ _1725_ _1732_ _1739_ VPWR VGND sg13g2_and2_1
XFILLER_49_884 VPWR VGND sg13g2_decap_8
X_3041_ _0751_ _0754_ _0824_ VPWR VGND sg13g2_nor2_2
XFILLER_24_718 VPWR VGND sg13g2_fill_2
XFILLER_36_567 VPWR VGND sg13g2_decap_4
X_4992_ net61 VGND VPWR _0324_ videogen.test_lut_thingy.pixel_feeder_inst.h_counter\[3\]
+ net645 sg13g2_dfrbpq_1
XFILLER_17_781 VPWR VGND sg13g2_fill_2
XFILLER_17_792 VPWR VGND sg13g2_decap_4
X_3943_ _1591_ _1592_ _1593_ _1594_ _1595_ VPWR VGND sg13g2_nor4_1
XFILLER_17_1026 VPWR VGND sg13g2_fill_2
XFILLER_20_935 VPWR VGND sg13g2_decap_8
XFILLER_31_261 VPWR VGND sg13g2_decap_8
X_3874_ videogen.test_lut_thingy.pixel_feeder_inst.row\[15\]\[3\] net577 _1527_ VPWR
+ VGND sg13g2_nor2_1
X_2825_ _0765_ _0770_ _0776_ VPWR VGND sg13g2_nor2_2
X_2756_ _0747_ _0724_ _0746_ VPWR VGND sg13g2_nand2_2
X_2687_ VPWR _0695_ videogen.test_lut_thingy.gol_counter_reg\[3\] VGND sg13g2_inv_1
X_4426_ _2062_ tmds_green.dc_balancing_reg\[4\] net616 VPWR VGND sg13g2_nand2b_1
XFILLER_48_28 VPWR VGND sg13g2_decap_8
X_5281__338 VPWR VGND net338 sg13g2_tiehi
X_4357_ VGND VPWR _1976_ _1996_ _0375_ _1997_ sg13g2_a21oi_1
X_3308_ _0982_ _0977_ _0980_ VPWR VGND sg13g2_nand2_2
X_4288_ _1846_ _1837_ _1842_ _1934_ VPWR VGND sg13g2_a21o_1
X_3239_ net608 net580 _0924_ _0929_ VPWR VGND sg13g2_nor3_1
XFILLER_27_523 VPWR VGND sg13g2_fill_2
XFILLER_42_548 VPWR VGND sg13g2_decap_4
XFILLER_23_773 VPWR VGND sg13g2_decap_8
XFILLER_11_968 VPWR VGND sg13g2_decap_8
XFILLER_6_427 VPWR VGND sg13g2_decap_8
XFILLER_13_64 VPWR VGND sg13g2_decap_4
XFILLER_10_489 VPWR VGND sg13g2_decap_4
X_5112__282 VPWR VGND net282 sg13g2_tiehi
XFILLER_49_114 VPWR VGND sg13g2_decap_8
XFILLER_46_876 VPWR VGND sg13g2_decap_8
XFILLER_18_556 VPWR VGND sg13g2_fill_2
XFILLER_45_386 VPWR VGND sg13g2_decap_8
XFILLER_9_232 VPWR VGND sg13g2_fill_1
XFILLER_14_795 VPWR VGND sg13g2_decap_8
X_3590_ _1243_ _1183_ _1230_ VPWR VGND sg13g2_nand2_1
XFILLER_6_983 VPWR VGND sg13g2_decap_8
X_5260_ net163 VGND VPWR _0588_ videogen.test_lut_thingy.pixel_feeder_inst.row\[3\]\[0\]
+ _0217_ sg13g2_dfrbpq_1
X_4211_ _1716_ _0979_ _1857_ VPWR VGND sg13g2_xor2_1
X_5191_ net68 VGND VPWR _0519_ videogen.test_lut_thingy.pixel_feeder_inst.row\[28\]\[3\]
+ _0148_ sg13g2_dfrbpq_1
X_4142_ _1112_ _1111_ _1776_ _1788_ VPWR VGND sg13g2_a21o_1
X_4073_ _1722_ _1713_ _1721_ VPWR VGND sg13g2_xnor2_1
Xclkbuf_3_4_0_clk_regs clknet_0_clk_regs clknet_3_4_0_clk_regs VPWR VGND sg13g2_buf_8
XFILLER_37_843 VPWR VGND sg13g2_decap_8
X_3024_ net797 videogen.test_lut_thingy.pixel_feeder_inst.row\[15\]\[1\] _0820_ _0404_
+ VPWR VGND sg13g2_mux2_1
XFILLER_36_320 VPWR VGND sg13g2_decap_8
XFILLER_24_504 VPWR VGND sg13g2_decap_8
XFILLER_24_537 VPWR VGND sg13g2_decap_4
X_5239__251 VPWR VGND net251 sg13g2_tiehi
X_4975_ net95 VGND VPWR _0307_ videogen.test_lut_thingy.pixel_feeder_inst.v_pix\[2\]
+ net643 sg13g2_dfrbpq_1
X_3926_ videogen.test_lut_thingy.pixel_feeder_inst.row\[25\]\[0\] net565 _1578_ VPWR
+ VGND sg13g2_nor2_1
X_3857_ videogen.test_lut_thingy.pixel_feeder_inst.row\[28\]\[3\] net594 _1510_ VPWR
+ VGND sg13g2_nor2_1
XFILLER_20_765 VPWR VGND sg13g2_fill_1
X_2808_ _0744_ _0770_ _0771_ VPWR VGND sg13g2_nor2_2
X_3788_ videogen.test_lut_thingy.pixel_feeder_inst.row\[33\]\[1\] net562 _1441_ VPWR
+ VGND sg13g2_nor2_1
X_5170__162 VPWR VGND net162 sg13g2_tiehi
XFILLER_4_909 VPWR VGND sg13g2_decap_8
X_2739_ net768 videogen.test_lut_thingy.pixel_feeder_inst.row\[23\]\[3\] _0737_ _0633_
+ VPWR VGND sg13g2_mux2_1
XFILLER_8_1002 VPWR VGND sg13g2_decap_8
X_4409_ _2047_ _2046_ _1993_ VPWR VGND sg13g2_nand2b_1
XFILLER_46_117 VPWR VGND sg13g2_decap_4
XFILLER_39_180 VPWR VGND sg13g2_fill_2
XFILLER_15_504 VPWR VGND sg13g2_fill_2
XFILLER_43_879 VPWR VGND sg13g2_fill_2
XFILLER_15_537 VPWR VGND sg13g2_fill_1
XFILLER_30_507 VPWR VGND sg13g2_fill_2
XFILLER_7_703 VPWR VGND sg13g2_decap_8
XFILLER_10_242 VPWR VGND sg13g2_fill_2
X_4936__152 VPWR VGND net152 sg13g2_tiehi
XFILLER_6_257 VPWR VGND sg13g2_fill_2
XFILLER_3_953 VPWR VGND sg13g2_decap_8
XFILLER_2_441 VPWR VGND sg13g2_decap_8
XFILLER_49_93 VPWR VGND sg13g2_decap_8
XFILLER_1_56 VPWR VGND sg13g2_decap_8
X_5080__329 VPWR VGND net329 sg13g2_tiehi
XFILLER_19_854 VPWR VGND sg13g2_decap_8
XFILLER_46_684 VPWR VGND sg13g2_fill_1
XFILLER_46_673 VPWR VGND sg13g2_decap_8
XFILLER_18_375 VPWR VGND sg13g2_decap_8
XFILLER_19_887 VPWR VGND sg13g2_fill_1
XFILLER_33_312 VPWR VGND sg13g2_fill_1
XFILLER_33_367 VPWR VGND sg13g2_decap_8
X_4760_ net714 net758 _0095_ VPWR VGND sg13g2_nor2_1
XFILLER_14_581 VPWR VGND sg13g2_fill_1
XFILLER_21_529 VPWR VGND sg13g2_decap_8
X_4691_ net685 net731 _0028_ VPWR VGND sg13g2_nor2_1
X_3711_ videogen.test_lut_thingy.pixel_feeder_inst.row\[31\]\[1\] net571 _1364_ VPWR
+ VGND sg13g2_nor2_1
X_3642_ videogen.test_lut_thingy.pixel_feeder_inst.row\[3\]\[2\] net577 _1295_ VPWR
+ VGND sg13g2_nor2_1
X_5312_ net444 VGND VPWR _0640_ videogen.test_lut_thingy.pixel_feeder_inst.row\[21\]\[2\]
+ _0259_ sg13g2_dfrbpq_1
X_3573_ _1226_ _1207_ _1225_ VPWR VGND sg13g2_xnor2_1
X_5089__321 VPWR VGND net321 sg13g2_tiehi
XFILLER_46_0 VPWR VGND sg13g2_decap_8
X_5243_ net235 VGND VPWR _0571_ videogen.test_lut_thingy.pixel_feeder_inst.row\[44\]\[3\]
+ _0200_ sg13g2_dfrbpq_1
Xhold19 serialize.shift_reg_g\[8\] VPWR VGND net464 sg13g2_dlygate4sd3_1
X_5174_ net138 VGND VPWR _0502_ videogen.test_lut_thingy.pixel_feeder_inst.row\[54\]\[2\]
+ _0139_ sg13g2_dfrbpq_1
X_4125_ _0982_ _1049_ _1097_ _1771_ VPWR VGND sg13g2_nor3_2
X_4056_ _1691_ _1692_ _1695_ _1705_ VPWR VGND sg13g2_or3_1
X_3007_ videogen.test_lut_thingy.pixel_feeder_inst.row\[32\]\[3\] net770 _0817_ _0427_
+ VPWR VGND sg13g2_mux2_1
X_5096__314 VPWR VGND net314 sg13g2_tiehi
XFILLER_12_507 VPWR VGND sg13g2_fill_1
X_4958_ net118 VGND VPWR _0290_ videogen.test_lut_thingy.pixel_feeder_inst.row\[20\]\[0\]
+ _0017_ sg13g2_dfrbpq_1
X_4889_ net679 net725 _0224_ VPWR VGND sg13g2_nor2_1
X_3909_ _1557_ _1558_ _1559_ _1560_ _1561_ VPWR VGND sg13g2_nor4_1
XFILLER_3_249 VPWR VGND sg13g2_decap_8
XFILLER_10_87 VPWR VGND sg13g2_decap_8
XFILLER_10_65 VPWR VGND sg13g2_decap_8
XFILLER_0_923 VPWR VGND sg13g2_decap_8
XFILLER_19_106 VPWR VGND sg13g2_fill_1
XFILLER_15_301 VPWR VGND sg13g2_decap_8
XFILLER_43_643 VPWR VGND sg13g2_fill_2
XFILLER_42_153 VPWR VGND sg13g2_decap_8
XFILLER_15_367 VPWR VGND sg13g2_decap_4
XFILLER_31_827 VPWR VGND sg13g2_fill_1
XFILLER_24_890 VPWR VGND sg13g2_fill_1
XFILLER_30_337 VPWR VGND sg13g2_fill_1
XFILLER_3_783 VPWR VGND sg13g2_decap_4
XFILLER_2_282 VPWR VGND sg13g2_decap_8
XFILLER_18_4 VPWR VGND sg13g2_fill_1
X_5203__434 VPWR VGND net434 sg13g2_tiehi
XFILLER_47_993 VPWR VGND sg13g2_decap_8
XFILLER_33_142 VPWR VGND sg13g2_fill_2
XFILLER_34_687 VPWR VGND sg13g2_decap_8
X_4812_ net672 net717 _0147_ VPWR VGND sg13g2_nor2_1
XFILLER_33_164 VPWR VGND sg13g2_decap_8
XFILLER_33_175 VPWR VGND sg13g2_decap_4
XFILLER_33_197 VPWR VGND sg13g2_fill_1
X_4743_ net674 net719 _0078_ VPWR VGND sg13g2_nor2_1
XFILLER_21_359 VPWR VGND sg13g2_decap_8
X_4674_ net703 net748 _0011_ VPWR VGND sg13g2_nor2_1
X_3625_ net610 VPWR _1278_ VGND videogen.test_lut_thingy.pixel_feeder_inst.row\[5\]\[2\]
+ net566 sg13g2_o21ai_1
X_3556_ _1040_ _1195_ _1204_ _1205_ _1209_ VPWR VGND sg13g2_and4_1
X_5226_ net303 VGND VPWR _0554_ videogen.test_lut_thingy.pixel_feeder_inst.row\[48\]\[2\]
+ _0183_ sg13g2_dfrbpq_1
X_3487_ VGND VPWR _0965_ _0967_ _1140_ _0966_ sg13g2_a21oi_1
X_5157_ net192 VGND VPWR _0485_ videogen.test_lut_thingy.pixel_feeder_inst.row\[5\]\[1\]
+ _0122_ sg13g2_dfrbpq_1
X_4108_ VPWR _1754_ _1753_ VGND sg13g2_inv_1
X_5088_ net322 VGND VPWR _0416_ red_tmds_par\[4\] net658 sg13g2_dfrbpq_1
X_4039_ _1688_ _1666_ _1673_ VPWR VGND sg13g2_xnor2_1
XFILLER_25_621 VPWR VGND sg13g2_decap_8
X_5250__207 VPWR VGND net207 sg13g2_tiehi
XFILLER_4_503 VPWR VGND sg13g2_fill_1
XFILLER_21_86 VPWR VGND sg13g2_decap_8
XFILLER_21_97 VPWR VGND sg13g2_fill_2
X_4933__155 VPWR VGND net155 sg13g2_tiehi
XFILLER_0_720 VPWR VGND sg13g2_decap_8
XFILLER_43_1000 VPWR VGND sg13g2_decap_8
XFILLER_47_212 VPWR VGND sg13g2_decap_8
XFILLER_0_797 VPWR VGND sg13g2_decap_8
XFILLER_29_971 VPWR VGND sg13g2_decap_8
XFILLER_16_643 VPWR VGND sg13g2_decap_4
XFILLER_44_985 VPWR VGND sg13g2_decap_8
XFILLER_43_462 VPWR VGND sg13g2_fill_1
XFILLER_15_142 VPWR VGND sg13g2_decap_8
XFILLER_15_153 VPWR VGND sg13g2_fill_1
X_5079__331 VPWR VGND net331 sg13g2_tiehi
XFILLER_30_101 VPWR VGND sg13g2_fill_2
XFILLER_30_145 VPWR VGND sg13g2_fill_2
XFILLER_8_831 VPWR VGND sg13g2_fill_1
XFILLER_7_11 VPWR VGND sg13g2_decap_4
XFILLER_30_189 VPWR VGND sg13g2_decap_4
XFILLER_8_897 VPWR VGND sg13g2_decap_8
X_3410_ _1063_ videogen.fancy_shader.n646\[4\] net624 videogen.fancy_shader.n646\[5\]
+ net623 VPWR VGND sg13g2_a22oi_1
X_4390_ _2029_ _2015_ _2028_ VPWR VGND sg13g2_nand2_1
X_3341_ videogen.fancy_shader.video_y\[4\] _1002_ _1005_ VPWR VGND sg13g2_and2_1
X_3272_ VGND VPWR videogen.test_lut_thingy.pixel_feeder_inst.h_counter\[2\] _0949_
+ _0951_ videogen.test_lut_thingy.pixel_feeder_inst.h_counter\[3\] sg13g2_a21oi_1
X_5011_ net437 VGND VPWR _0343_ videogen.fancy_shader.n646\[6\] net649 sg13g2_dfrbpq_2
XFILLER_38_223 VPWR VGND sg13g2_fill_2
XFILLER_22_602 VPWR VGND sg13g2_fill_2
X_5093__317 VPWR VGND net317 sg13g2_tiehi
XFILLER_42_19 VPWR VGND sg13g2_decap_8
XFILLER_21_123 VPWR VGND sg13g2_decap_4
XFILLER_22_646 VPWR VGND sg13g2_fill_2
X_2987_ videogen.test_lut_thingy.pixel_feeder_inst.row\[30\]\[3\] net767 _0813_ _0443_
+ VPWR VGND sg13g2_mux2_1
X_4956__122 VPWR VGND net122 sg13g2_tiehi
X_4726_ net685 net730 _0061_ VPWR VGND sg13g2_nor2_1
X_4657_ VPWR _0661_ _2243_ VGND sg13g2_inv_1
X_3608_ videogen.test_lut_thingy.pixel_feeder_inst.row\[27\]\[2\] net575 _1261_ VPWR
+ VGND sg13g2_nor2_1
X_4588_ _2202_ tmds_blue.dc_balancing_reg\[4\] _2203_ VPWR VGND sg13g2_xor2_1
X_3539_ VGND VPWR _1192_ _1120_ _1095_ sg13g2_or2_1
X_5209_ net410 VGND VPWR _0537_ videogen.test_lut_thingy.pixel_feeder_inst.row\[52\]\[1\]
+ _0166_ sg13g2_dfrbpq_1
XFILLER_29_267 VPWR VGND sg13g2_fill_2
XFILLER_45_749 VPWR VGND sg13g2_fill_1
XFILLER_45_738 VPWR VGND sg13g2_decap_8
XFILLER_16_20 VPWR VGND sg13g2_fill_2
XFILLER_44_259 VPWR VGND sg13g2_decap_8
XFILLER_26_985 VPWR VGND sg13g2_decap_8
XFILLER_13_668 VPWR VGND sg13g2_decap_8
X_5174__138 VPWR VGND net138 sg13g2_tiehi
XFILLER_40_476 VPWR VGND sg13g2_decap_8
XFILLER_8_127 VPWR VGND sg13g2_decap_8
XFILLER_13_679 VPWR VGND sg13g2_fill_1
XFILLER_32_41 VPWR VGND sg13g2_fill_2
XFILLER_5_801 VPWR VGND sg13g2_decap_8
X_5289__269 VPWR VGND net269 sg13g2_tiehi
XFILLER_48_543 VPWR VGND sg13g2_decap_8
XFILLER_36_749 VPWR VGND sg13g2_fill_1
XFILLER_44_760 VPWR VGND sg13g2_fill_2
XFILLER_17_963 VPWR VGND sg13g2_decap_8
X_5122__262 VPWR VGND net262 sg13g2_tiehi
X_2910_ videogen.test_lut_thingy.pixel_feeder_inst.row\[54\]\[2\] net786 _0795_ _0502_
+ VPWR VGND sg13g2_mux2_1
XFILLER_32_933 VPWR VGND sg13g2_decap_4
X_3890_ net628 _1531_ _1542_ _1543_ VPWR VGND sg13g2_nor3_1
XFILLER_32_966 VPWR VGND sg13g2_decap_8
X_2841_ videogen.test_lut_thingy.pixel_feeder_inst.row\[45\]\[1\] net793 _0781_ _0565_
+ VPWR VGND sg13g2_mux2_1
X_2772_ net791 videogen.test_lut_thingy.pixel_feeder_inst.row\[39\]\[1\] _0756_ _0609_
+ VPWR VGND sg13g2_mux2_1
X_4511_ VGND VPWR _2127_ _2133_ _0423_ net559 sg13g2_a21oi_1
X_4442_ _2067_ _1956_ _2072_ VPWR VGND sg13g2_xor2_1
X_4373_ _2012_ _1976_ _2013_ VPWR VGND sg13g2_xor2_1
Xfanout629 net633 net629 VPWR VGND sg13g2_buf_8
X_3324_ videogen.fancy_shader.video_y\[0\] _0887_ _0992_ VPWR VGND sg13g2_and2_1
Xfanout618 net619 net618 VPWR VGND sg13g2_buf_8
Xfanout607 net609 net607 VPWR VGND sg13g2_buf_8
X_3255_ VGND VPWR _0938_ _0939_ _0940_ _0904_ sg13g2_a21oi_1
X_3186_ net762 _0840_ _0891_ _0297_ VPWR VGND sg13g2_nor3_1
XFILLER_27_738 VPWR VGND sg13g2_fill_2
XFILLER_23_944 VPWR VGND sg13g2_decap_8
XFILLER_33_1010 VPWR VGND sg13g2_decap_8
XFILLER_10_638 VPWR VGND sg13g2_fill_2
X_4709_ VGND VPWR _1954_ _1996_ _0397_ _2069_ sg13g2_a21oi_1
XFILLER_2_848 VPWR VGND sg13g2_decap_8
X_4930__158 VPWR VGND net158 sg13g2_tiehi
XFILLER_17_204 VPWR VGND sg13g2_fill_2
XFILLER_18_738 VPWR VGND sg13g2_fill_2
XFILLER_14_911 VPWR VGND sg13g2_decap_8
XFILLER_43_62 VPWR VGND sg13g2_decap_8
XFILLER_9_403 VPWR VGND sg13g2_decap_8
XFILLER_14_988 VPWR VGND sg13g2_decap_8
XFILLER_1_881 VPWR VGND sg13g2_decap_8
XFILLER_49_863 VPWR VGND sg13g2_decap_8
X_3040_ videogen.test_lut_thingy.pixel_feeder_inst.row\[12\]\[0\] net808 _0823_ _0386_
+ VPWR VGND sg13g2_mux2_1
XFILLER_48_395 VPWR VGND sg13g2_decap_8
X_4991_ net63 VGND VPWR _0323_ videogen.test_lut_thingy.pixel_feeder_inst.h_counter\[2\]
+ net645 sg13g2_dfrbpq_1
XFILLER_23_218 VPWR VGND sg13g2_decap_8
X_3942_ videogen.test_lut_thingy.pixel_feeder_inst.row\[23\]\[0\] net575 _1594_ VPWR
+ VGND sg13g2_nor2_1
XFILLER_17_1005 VPWR VGND sg13g2_decap_8
XFILLER_20_914 VPWR VGND sg13g2_decap_8
X_3873_ net631 VPWR _1526_ VGND videogen.test_lut_thingy.pixel_feeder_inst.row\[12\]\[3\]
+ net600 sg13g2_o21ai_1
XFILLER_31_240 VPWR VGND sg13g2_fill_2
X_2824_ videogen.test_lut_thingy.pixel_feeder_inst.row\[42\]\[0\] net803 _0775_ _0576_
+ VPWR VGND sg13g2_mux2_1
XFILLER_9_981 VPWR VGND sg13g2_decap_8
X_2755_ _0746_ _0725_ net554 VPWR VGND sg13g2_nand2b_1
X_2686_ VPWR _0694_ videogen.test_lut_thingy.gol_counter_reg\[2\] VGND sg13g2_inv_1
X_4425_ green\[7\] _2060_ _2059_ _2061_ VPWR VGND sg13g2_mux2_1
X_4356_ _0879_ VPWR _1997_ VGND _1976_ _1996_ sg13g2_o21ai_1
X_3307_ _0977_ _0980_ _0981_ VPWR VGND sg13g2_and2_1
X_4287_ _1933_ _1182_ _1931_ VPWR VGND sg13g2_nand2_1
X_3238_ _0849_ _0927_ _0928_ _0312_ VPWR VGND sg13g2_nor3_1
X_3169_ net456 net666 _0280_ VPWR VGND sg13g2_and2_1
XFILLER_39_384 VPWR VGND sg13g2_fill_2
XFILLER_11_947 VPWR VGND sg13g2_decap_8
XFILLER_22_295 VPWR VGND sg13g2_fill_1
X_5004__37 VPWR VGND net37 sg13g2_tiehi
XFILLER_13_98 VPWR VGND sg13g2_fill_2
XFILLER_2_623 VPWR VGND sg13g2_fill_2
XFILLER_2_612 VPWR VGND sg13g2_decap_8
XFILLER_49_126 VPWR VGND sg13g2_fill_1
XFILLER_45_310 VPWR VGND sg13g2_fill_1
XFILLER_46_855 VPWR VGND sg13g2_decap_8
XFILLER_45_365 VPWR VGND sg13g2_fill_2
XFILLER_13_251 VPWR VGND sg13g2_decap_8
XFILLER_41_582 VPWR VGND sg13g2_decap_4
XFILLER_9_244 VPWR VGND sg13g2_decap_8
XFILLER_9_288 VPWR VGND sg13g2_fill_2
XFILLER_6_962 VPWR VGND sg13g2_decap_8
X_4210_ _1856_ _1854_ _1855_ VPWR VGND sg13g2_nand2_1
X_5190_ net72 VGND VPWR _0518_ videogen.test_lut_thingy.pixel_feeder_inst.row\[28\]\[2\]
+ _0147_ sg13g2_dfrbpq_1
X_4141_ _1112_ _1776_ _1111_ _1787_ VPWR VGND sg13g2_nand3_1
X_4072_ _1717_ VPWR _1721_ VGND _1713_ _1719_ sg13g2_o21ai_1
XFILLER_49_693 VPWR VGND sg13g2_decap_8
X_3023_ net786 videogen.test_lut_thingy.pixel_feeder_inst.row\[15\]\[2\] _0820_ _0405_
+ VPWR VGND sg13g2_mux2_1
XFILLER_36_343 VPWR VGND sg13g2_decap_4
XFILLER_37_899 VPWR VGND sg13g2_fill_2
XFILLER_36_365 VPWR VGND sg13g2_decap_8
XFILLER_36_376 VPWR VGND sg13g2_fill_2
X_4974_ net97 VGND VPWR _0306_ videogen.test_lut_thingy.pixel_feeder_inst.v_pix\[1\]
+ net643 sg13g2_dfrbpq_2
X_3925_ videogen.test_lut_thingy.pixel_feeder_inst.row\[26\]\[0\] net586 _1577_ VPWR
+ VGND sg13g2_nor2_1
XFILLER_32_560 VPWR VGND sg13g2_fill_1
X_3856_ net629 VPWR _1509_ VGND videogen.test_lut_thingy.pixel_feeder_inst.row\[30\]\[3\]
+ net582 sg13g2_o21ai_1
X_3787_ videogen.test_lut_thingy.pixel_feeder_inst.row\[35\]\[1\] net573 _1440_ VPWR
+ VGND sg13g2_nor2_1
X_2807_ _0770_ _0753_ VPWR VGND net555 sg13g2_nand2b_2
XFILLER_30_1013 VPWR VGND sg13g2_decap_8
X_2738_ _0737_ _0701_ _0728_ VPWR VGND sg13g2_nand2_2
X_2669_ VPWR _0677_ videogen.fancy_shader.video_y\[8\] VGND sg13g2_inv_1
X_4408_ _2046_ _2029_ _2045_ VPWR VGND sg13g2_xnor2_1
X_5246__223 VPWR VGND net223 sg13g2_tiehi
X_4339_ _1977_ VPWR _1980_ VGND _1969_ _1979_ sg13g2_o21ai_1
XFILLER_47_619 VPWR VGND sg13g2_decap_8
X_4929__160 VPWR VGND net160 sg13g2_tiehi
XFILLER_39_170 VPWR VGND sg13g2_decap_4
XFILLER_39_192 VPWR VGND sg13g2_decap_4
XFILLER_42_335 VPWR VGND sg13g2_fill_2
XFILLER_42_379 VPWR VGND sg13g2_decap_8
XFILLER_11_744 VPWR VGND sg13g2_fill_2
XFILLER_11_766 VPWR VGND sg13g2_decap_8
XFILLER_24_97 VPWR VGND sg13g2_decap_8
XFILLER_7_737 VPWR VGND sg13g2_fill_2
XFILLER_6_225 VPWR VGND sg13g2_fill_1
XFILLER_11_777 VPWR VGND sg13g2_fill_1
XFILLER_40_63 VPWR VGND sg13g2_fill_1
XFILLER_40_74 VPWR VGND sg13g2_decap_4
XFILLER_3_932 VPWR VGND sg13g2_decap_8
X_5225__307 VPWR VGND net307 sg13g2_tiehi
XFILLER_38_608 VPWR VGND sg13g2_decap_8
XFILLER_1_35 VPWR VGND sg13g2_decap_8
XFILLER_19_822 VPWR VGND sg13g2_decap_8
XFILLER_19_833 VPWR VGND sg13g2_fill_1
Xfanout790 net793 net790 VPWR VGND sg13g2_buf_8
XFILLER_46_652 VPWR VGND sg13g2_decap_8
XFILLER_18_365 VPWR VGND sg13g2_decap_4
XFILLER_18_387 VPWR VGND sg13g2_fill_1
XFILLER_34_869 VPWR VGND sg13g2_decap_8
X_3710_ net634 VPWR _1363_ VGND videogen.test_lut_thingy.pixel_feeder_inst.row\[30\]\[1\]
+ net582 sg13g2_o21ai_1
X_4690_ net685 net730 _0027_ VPWR VGND sg13g2_nor2_1
XFILLER_41_390 VPWR VGND sg13g2_decap_4
X_3641_ net611 VPWR _1294_ VGND videogen.test_lut_thingy.pixel_feeder_inst.row\[0\]\[2\]
+ net601 sg13g2_o21ai_1
X_3572_ VGND VPWR _1218_ _1223_ _1225_ _1215_ sg13g2_a21oi_1
X_5311_ net46 VGND VPWR _0639_ videogen.test_lut_thingy.pixel_feeder_inst.row\[21\]\[1\]
+ _0258_ sg13g2_dfrbpq_1
X_5242_ net239 VGND VPWR _0570_ videogen.test_lut_thingy.pixel_feeder_inst.row\[44\]\[2\]
+ _0199_ sg13g2_dfrbpq_1
XFILLER_39_0 VPWR VGND sg13g2_decap_8
X_5173_ net142 VGND VPWR _0501_ videogen.test_lut_thingy.pixel_feeder_inst.row\[54\]\[1\]
+ _0138_ sg13g2_dfrbpq_1
X_4124_ VPWR _1770_ _1769_ VGND sg13g2_inv_1
Xinput1 ui_in[0] net1 VPWR VGND sg13g2_buf_2
XFILLER_49_490 VPWR VGND sg13g2_decap_8
X_4055_ _1691_ VPWR _1704_ VGND _1692_ _1695_ sg13g2_o21ai_1
X_3006_ _0744_ _0754_ _0817_ VPWR VGND sg13g2_nor2_2
XFILLER_36_162 VPWR VGND sg13g2_fill_2
XFILLER_25_858 VPWR VGND sg13g2_decap_8
XFILLER_40_806 VPWR VGND sg13g2_fill_2
XFILLER_12_519 VPWR VGND sg13g2_fill_2
X_4957_ net120 VGND VPWR _0289_ videogen.test_lut_thingy.pixel_feeder_inst.row\[18\]\[3\]
+ _0016_ sg13g2_dfrbpq_1
X_4888_ net680 net724 _0223_ VPWR VGND sg13g2_nor2_1
X_3908_ videogen.test_lut_thingy.pixel_feeder_inst.row\[0\]\[0\] net601 _1560_ VPWR
+ VGND sg13g2_nor2_1
X_3839_ VGND VPWR _0674_ _0730_ _1492_ _1491_ sg13g2_a21oi_1
XFILLER_20_574 VPWR VGND sg13g2_decap_8
XFILLER_4_729 VPWR VGND sg13g2_fill_2
XFILLER_0_902 VPWR VGND sg13g2_decap_8
XFILLER_0_979 VPWR VGND sg13g2_decap_8
XFILLER_19_86 VPWR VGND sg13g2_decap_4
XFILLER_28_630 VPWR VGND sg13g2_fill_1
XFILLER_27_162 VPWR VGND sg13g2_decap_8
XFILLER_28_674 VPWR VGND sg13g2_decap_4
XFILLER_43_622 VPWR VGND sg13g2_decap_8
XFILLER_15_324 VPWR VGND sg13g2_decap_8
XFILLER_15_335 VPWR VGND sg13g2_fill_1
XFILLER_42_132 VPWR VGND sg13g2_decap_8
XFILLER_43_688 VPWR VGND sg13g2_decap_8
XFILLER_30_349 VPWR VGND sg13g2_decap_4
XFILLER_38_416 VPWR VGND sg13g2_fill_2
X_5049__383 VPWR VGND net383 sg13g2_tiehi
XFILLER_20_1012 VPWR VGND sg13g2_decap_8
XFILLER_47_972 VPWR VGND sg13g2_decap_8
X_4811_ net674 net719 _0146_ VPWR VGND sg13g2_nor2_1
XFILLER_33_154 VPWR VGND sg13g2_decap_4
XFILLER_22_839 VPWR VGND sg13g2_decap_8
X_4742_ net672 net717 _0077_ VPWR VGND sg13g2_nor2_1
X_4673_ net696 net741 _0010_ VPWR VGND sg13g2_nor2_1
X_3624_ _1277_ net626 _1276_ VPWR VGND sg13g2_nand2b_1
X_5132__242 VPWR VGND net242 sg13g2_tiehi
X_3555_ _1204_ _1205_ _1040_ _1208_ VPWR VGND sg13g2_nand3_1
X_3486_ _1139_ _1033_ _1138_ VPWR VGND sg13g2_xnor2_1
X_5225_ net307 VGND VPWR _0553_ videogen.test_lut_thingy.pixel_feeder_inst.row\[48\]\[1\]
+ _0182_ sg13g2_dfrbpq_1
XFILLER_5_1028 VPWR VGND sg13g2_fill_1
X_5156_ net194 VGND VPWR _0484_ videogen.test_lut_thingy.pixel_feeder_inst.row\[5\]\[0\]
+ _0121_ sg13g2_dfrbpq_1
X_4107_ _1752_ _1169_ _1753_ VPWR VGND sg13g2_xor2_1
X_5087_ net323 VGND VPWR _0415_ red_tmds_par\[2\] net658 sg13g2_dfrbpq_1
X_4038_ _1662_ _1676_ _1681_ _1687_ VPWR VGND sg13g2_or3_1
XFILLER_25_666 VPWR VGND sg13g2_decap_8
XFILLER_40_614 VPWR VGND sg13g2_fill_2
XFILLER_12_316 VPWR VGND sg13g2_decap_4
XFILLER_40_658 VPWR VGND sg13g2_decap_8
XFILLER_20_393 VPWR VGND sg13g2_decap_8
XFILLER_21_894 VPWR VGND sg13g2_decap_8
XFILLER_4_559 VPWR VGND sg13g2_decap_8
XFILLER_21_65 VPWR VGND sg13g2_decap_8
XFILLER_48_725 VPWR VGND sg13g2_decap_4
XFILLER_0_776 VPWR VGND sg13g2_decap_8
X_5109__288 VPWR VGND net288 sg13g2_tiehi
XFILLER_16_600 VPWR VGND sg13g2_fill_2
XFILLER_16_611 VPWR VGND sg13g2_decap_8
XFILLER_44_964 VPWR VGND sg13g2_decap_8
XFILLER_43_430 VPWR VGND sg13g2_fill_1
XFILLER_15_121 VPWR VGND sg13g2_fill_1
XFILLER_15_132 VPWR VGND sg13g2_fill_1
XFILLER_43_485 VPWR VGND sg13g2_decap_8
XFILLER_16_699 VPWR VGND sg13g2_decap_8
XFILLER_31_625 VPWR VGND sg13g2_fill_1
XFILLER_8_876 VPWR VGND sg13g2_decap_8
X_3340_ _0862_ _0887_ net624 _1004_ VPWR VGND sg13g2_nand3_1
X_5086__325 VPWR VGND net325 sg13g2_tiehi
X_3271_ _0946_ _0950_ _0323_ VPWR VGND sg13g2_nor2_1
X_5010_ net439 VGND VPWR _0342_ videogen.fancy_shader.n646\[5\] net648 sg13g2_dfrbpq_2
XFILLER_38_202 VPWR VGND sg13g2_decap_8
XFILLER_39_758 VPWR VGND sg13g2_fill_2
XFILLER_34_474 VPWR VGND sg13g2_decap_4
X_2986_ _0743_ _0761_ _0813_ VPWR VGND sg13g2_nor2_2
X_5200__32 VPWR VGND net32 sg13g2_tiehi
X_4725_ net710 net755 _0060_ VPWR VGND sg13g2_nor2_1
X_4656_ _2243_ net664 net475 net669 red_tmds_par\[3\] VPWR VGND sg13g2_a22oi_1
X_3607_ net632 VPWR _1260_ VGND videogen.test_lut_thingy.pixel_feeder_inst.row\[25\]\[2\]
+ net565 sg13g2_o21ai_1
X_4587_ _2175_ VPWR _2202_ VGND blue\[7\] _2150_ sg13g2_o21ai_1
X_3538_ _1182_ _1187_ _1181_ _1191_ VPWR VGND sg13g2_nand3_1
XFILLER_27_1018 VPWR VGND sg13g2_decap_8
X_3469_ VGND VPWR _1096_ _1121_ _1122_ _1113_ sg13g2_a21oi_1
X_5167__168 VPWR VGND net168 sg13g2_tiehi
X_5208_ net414 VGND VPWR _0536_ videogen.test_lut_thingy.pixel_feeder_inst.row\[52\]\[0\]
+ _0165_ sg13g2_dfrbpq_1
X_5139_ net228 VGND VPWR _0467_ videogen.test_lut_thingy.pixel_feeder_inst.row\[8\]\[3\]
+ _0104_ sg13g2_dfrbpq_1
XFILLER_18_909 VPWR VGND sg13g2_decap_8
X_5221__332 VPWR VGND net332 sg13g2_tiehi
XFILLER_38_780 VPWR VGND sg13g2_fill_1
XFILLER_16_32 VPWR VGND sg13g2_fill_2
XFILLER_26_964 VPWR VGND sg13g2_decap_8
XFILLER_12_102 VPWR VGND sg13g2_fill_1
XFILLER_41_989 VPWR VGND sg13g2_decap_8
XFILLER_12_168 VPWR VGND sg13g2_decap_8
XFILLER_5_835 VPWR VGND sg13g2_fill_2
XFILLER_5_868 VPWR VGND sg13g2_fill_1
XFILLER_4_389 VPWR VGND sg13g2_fill_1
XFILLER_0_573 VPWR VGND sg13g2_decap_8
XFILLER_48_522 VPWR VGND sg13g2_decap_8
XFILLER_0_584 VPWR VGND sg13g2_fill_2
XFILLER_48_599 VPWR VGND sg13g2_decap_8
XFILLER_35_227 VPWR VGND sg13g2_fill_2
XFILLER_16_430 VPWR VGND sg13g2_fill_2
XFILLER_17_942 VPWR VGND sg13g2_decap_8
XFILLER_31_400 VPWR VGND sg13g2_decap_8
XFILLER_43_282 VPWR VGND sg13g2_decap_8
X_2840_ videogen.test_lut_thingy.pixel_feeder_inst.row\[45\]\[2\] net780 _0781_ _0566_
+ VPWR VGND sg13g2_mux2_1
XFILLER_12_691 VPWR VGND sg13g2_fill_1
X_2771_ net780 videogen.test_lut_thingy.pixel_feeder_inst.row\[39\]\[2\] _0756_ _0610_
+ VPWR VGND sg13g2_mux2_1
X_4510_ _2056_ _2132_ _2133_ VPWR VGND sg13g2_nor2_1
X_4441_ VGND VPWR net622 _2071_ _0415_ net764 sg13g2_a21oi_1
X_4372_ _2012_ _1999_ _2010_ VPWR VGND sg13g2_xnor2_1
X_3323_ VGND VPWR _0678_ _0990_ _0346_ _0991_ sg13g2_a21oi_1
Xfanout608 net609 net608 VPWR VGND sg13g2_buf_8
Xfanout619 blue\[0\] net619 VPWR VGND sg13g2_buf_8
X_3254_ videogen.test_lut_thingy.pixel_feeder_inst.v_counter\[3\] _0902_ _0939_ VPWR
+ VGND sg13g2_nor2b_1
XFILLER_2_1009 VPWR VGND sg13g2_decap_8
X_3185_ VGND VPWR videogen.fancy_shader.video_x\[2\] _0839_ _0891_ videogen.fancy_shader.video_x\[3\]
+ sg13g2_a21oi_1
XFILLER_26_205 VPWR VGND sg13g2_fill_1
XFILLER_26_249 VPWR VGND sg13g2_decap_8
XFILLER_23_923 VPWR VGND sg13g2_decap_8
XFILLER_34_260 VPWR VGND sg13g2_decap_8
XFILLER_10_617 VPWR VGND sg13g2_fill_1
X_2969_ videogen.test_lut_thingy.pixel_feeder_inst.row\[10\]\[1\] net798 _0809_ _0457_
+ VPWR VGND sg13g2_mux2_1
X_4708_ net707 net752 _0044_ VPWR VGND sg13g2_nor2_1
X_4639_ VPWR _0652_ _2234_ VGND sg13g2_inv_1
X_5185__86 VPWR VGND net86 sg13g2_tiehi
XFILLER_2_805 VPWR VGND sg13g2_fill_1
XFILLER_2_827 VPWR VGND sg13g2_decap_8
XFILLER_49_319 VPWR VGND sg13g2_decap_4
XFILLER_40_1026 VPWR VGND sg13g2_fill_2
XFILLER_45_525 VPWR VGND sg13g2_decap_4
XFILLER_45_514 VPWR VGND sg13g2_fill_1
XFILLER_27_42 VPWR VGND sg13g2_fill_1
XFILLER_14_967 VPWR VGND sg13g2_decap_8
XFILLER_40_241 VPWR VGND sg13g2_decap_4
XFILLER_5_610 VPWR VGND sg13g2_decap_4
XFILLER_5_676 VPWR VGND sg13g2_decap_8
XFILLER_1_860 VPWR VGND sg13g2_decap_8
XFILLER_49_842 VPWR VGND sg13g2_decap_8
XFILLER_0_392 VPWR VGND sg13g2_fill_1
XFILLER_24_709 VPWR VGND sg13g2_fill_1
X_4990_ net65 VGND VPWR _0322_ videogen.test_lut_thingy.pixel_feeder_inst.h_counter\[1\]
+ net645 sg13g2_dfrbpq_1
XFILLER_17_783 VPWR VGND sg13g2_fill_1
XFILLER_23_208 VPWR VGND sg13g2_fill_1
X_3941_ videogen.test_lut_thingy.pixel_feeder_inst.row\[22\]\[0\] net583 _1593_ VPWR
+ VGND sg13g2_nor2_1
XFILLER_32_720 VPWR VGND sg13g2_decap_4
XFILLER_17_1028 VPWR VGND sg13g2_fill_1
X_3872_ _1521_ _1522_ _1523_ _1524_ _1525_ VPWR VGND sg13g2_nor4_1
XFILLER_32_753 VPWR VGND sg13g2_decap_8
XFILLER_32_764 VPWR VGND sg13g2_fill_1
X_2823_ videogen.test_lut_thingy.pixel_feeder_inst.row\[42\]\[1\] net792 _0775_ _0577_
+ VPWR VGND sg13g2_mux2_1
X_2754_ videogen.test_lut_thingy.pixel_feeder_inst.row\[24\]\[0\] net805 _0745_ _0626_
+ VPWR VGND sg13g2_mux2_1
XFILLER_9_960 VPWR VGND sg13g2_decap_8
XFILLER_8_492 VPWR VGND sg13g2_fill_1
X_2685_ VPWR _0693_ videogen.test_lut_thingy.gol_counter_reg\[1\] VGND sg13g2_inv_1
X_4424_ green\[7\] net615 _2060_ VPWR VGND sg13g2_xor2_1
X_4355_ _1993_ _1995_ net552 _1996_ VPWR VGND sg13g2_mux2_1
X_3306_ _0980_ _0964_ _0971_ _0978_ VPWR VGND sg13g2_and3_2
X_4286_ VGND VPWR _1932_ _1931_ _1930_ sg13g2_or2_1
X_3237_ VGND VPWR net641 _0925_ _0928_ videogen.test_lut_thingy.pixel_feeder_inst.h_pix\[1\]
+ sg13g2_a21oi_1
X_3168_ net454 net666 _0279_ VPWR VGND sg13g2_and2_1
XFILLER_27_503 VPWR VGND sg13g2_fill_2
X_3099_ net762 videogen.test_lut_thingy.pixel_feeder_inst.state\[0\] _0848_ VPWR VGND
+ sg13g2_nor2_2
XFILLER_35_591 VPWR VGND sg13g2_fill_1
XFILLER_11_926 VPWR VGND sg13g2_decap_8
XFILLER_7_919 VPWR VGND sg13g2_decap_8
XFILLER_10_458 VPWR VGND sg13g2_decap_8
XFILLER_8_4 VPWR VGND sg13g2_fill_2
XFILLER_1_112 VPWR VGND sg13g2_decap_8
XFILLER_49_138 VPWR VGND sg13g2_decap_8
XFILLER_38_30 VPWR VGND sg13g2_decap_8
XFILLER_46_834 VPWR VGND sg13g2_decap_8
XFILLER_38_96 VPWR VGND sg13g2_decap_4
X_5008__443 VPWR VGND net443 sg13g2_tiehi
XFILLER_45_344 VPWR VGND sg13g2_fill_1
XFILLER_14_775 VPWR VGND sg13g2_decap_4
XFILLER_13_274 VPWR VGND sg13g2_decap_4
XFILLER_10_981 VPWR VGND sg13g2_decap_8
XFILLER_6_941 VPWR VGND sg13g2_decap_8
XFILLER_5_451 VPWR VGND sg13g2_fill_1
X_4140_ _1774_ _1785_ _1786_ VPWR VGND sg13g2_and2_1
XFILLER_1_690 VPWR VGND sg13g2_decap_8
X_4071_ VGND VPWR _1719_ _1720_ _1717_ _1713_ sg13g2_a21oi_2
XFILLER_23_1021 VPWR VGND sg13g2_decap_8
X_5206__422 VPWR VGND net422 sg13g2_tiehi
XFILLER_49_672 VPWR VGND sg13g2_decap_8
XFILLER_37_812 VPWR VGND sg13g2_decap_4
X_3022_ net775 videogen.test_lut_thingy.pixel_feeder_inst.row\[15\]\[3\] _0820_ _0406_
+ VPWR VGND sg13g2_mux2_1
XFILLER_24_517 VPWR VGND sg13g2_fill_1
X_4973_ net99 VGND VPWR _0305_ videogen.test_lut_thingy.pixel_feeder_inst.v_pix\[0\]
+ net643 sg13g2_dfrbpq_2
X_4978__89 VPWR VGND net89 sg13g2_tiehi
X_3924_ videogen.test_lut_thingy.pixel_feeder_inst.row\[27\]\[0\] net575 _1576_ VPWR
+ VGND sg13g2_nor2_1
XFILLER_20_734 VPWR VGND sg13g2_decap_4
X_4993__59 VPWR VGND net59 sg13g2_tiehi
X_3855_ net636 _1502_ _1507_ _1508_ VPWR VGND sg13g2_nor3_1
XFILLER_20_756 VPWR VGND sg13g2_decap_8
X_3786_ videogen.test_lut_thingy.pixel_feeder_inst.row\[34\]\[1\] net584 _1439_ VPWR
+ VGND sg13g2_nor2_1
XFILLER_20_778 VPWR VGND sg13g2_fill_1
X_2806_ videogen.test_lut_thingy.pixel_feeder_inst.row\[3\]\[0\] net808 _0769_ _0588_
+ VPWR VGND sg13g2_mux2_1
X_2737_ videogen.test_lut_thingy.pixel_feeder_inst.row\[22\]\[0\] net801 _0736_ _0634_
+ VPWR VGND sg13g2_mux2_1
X_2668_ VPWR _0676_ videogen.fancy_shader.video_y\[9\] VGND sg13g2_inv_1
X_4407_ _2045_ _2042_ _2044_ VPWR VGND sg13g2_xnor2_1
X_4338_ VGND VPWR _1979_ net552 red\[0\] sg13g2_or2_1
X_5066__356 VPWR VGND net356 sg13g2_tiehi
X_4269_ _1857_ _1910_ _1911_ _1912_ _1915_ VPWR VGND sg13g2_nor4_1
X_5142__222 VPWR VGND net222 sg13g2_tiehi
XFILLER_27_300 VPWR VGND sg13g2_decap_8
XFILLER_39_182 VPWR VGND sg13g2_fill_1
XFILLER_15_506 VPWR VGND sg13g2_fill_1
XFILLER_42_314 VPWR VGND sg13g2_decap_4
XFILLER_42_347 VPWR VGND sg13g2_decap_8
XFILLER_11_701 VPWR VGND sg13g2_fill_2
XFILLER_11_712 VPWR VGND sg13g2_fill_2
XFILLER_24_76 VPWR VGND sg13g2_decap_8
XFILLER_10_211 VPWR VGND sg13g2_decap_4
XFILLER_10_244 VPWR VGND sg13g2_fill_1
XFILLER_6_259 VPWR VGND sg13g2_fill_1
XFILLER_3_911 VPWR VGND sg13g2_decap_8
XFILLER_3_988 VPWR VGND sg13g2_decap_8
XFILLER_49_84 VPWR VGND sg13g2_decap_4
XFILLER_1_14 VPWR VGND sg13g2_decap_8
Xfanout791 net792 net791 VPWR VGND sg13g2_buf_8
XFILLER_19_801 VPWR VGND sg13g2_fill_1
Xfanout780 net781 net780 VPWR VGND sg13g2_buf_8
XFILLER_46_631 VPWR VGND sg13g2_decap_8
XFILLER_18_333 VPWR VGND sg13g2_decap_8
XFILLER_33_303 VPWR VGND sg13g2_decap_8
XFILLER_34_804 VPWR VGND sg13g2_decap_8
XFILLER_45_185 VPWR VGND sg13g2_fill_1
XFILLER_18_399 VPWR VGND sg13g2_decap_8
XFILLER_33_325 VPWR VGND sg13g2_fill_2
XFILLER_14_572 VPWR VGND sg13g2_decap_8
X_5119__268 VPWR VGND net268 sg13g2_tiehi
XFILLER_14_1009 VPWR VGND sg13g2_decap_8
X_3640_ _1289_ _1290_ _1291_ _1292_ _1293_ VPWR VGND sg13g2_nor4_1
X_3571_ _1224_ _1218_ _1223_ VPWR VGND sg13g2_nand2_1
XFILLER_6_760 VPWR VGND sg13g2_decap_8
X_5310_ net62 VGND VPWR _0638_ videogen.test_lut_thingy.pixel_feeder_inst.row\[21\]\[0\]
+ _0257_ sg13g2_dfrbpq_1
XFILLER_5_281 VPWR VGND sg13g2_fill_1
X_5241_ net243 VGND VPWR _0569_ videogen.test_lut_thingy.pixel_feeder_inst.row\[44\]\[1\]
+ _0198_ sg13g2_dfrbpq_1
X_5172_ net146 VGND VPWR _0500_ videogen.test_lut_thingy.pixel_feeder_inst.row\[54\]\[0\]
+ _0137_ sg13g2_dfrbpq_1
X_4123_ _1769_ _1766_ _1768_ VPWR VGND sg13g2_xnor2_1
XFILLER_29_609 VPWR VGND sg13g2_fill_2
X_4054_ _1700_ _1702_ _1703_ VPWR VGND sg13g2_and2_1
Xinput2 ui_in[1] net2 VPWR VGND sg13g2_buf_2
X_3005_ videogen.test_lut_thingy.pixel_feeder_inst.row\[9\]\[0\] net809 _0816_ _0428_
+ VPWR VGND sg13g2_mux2_1
XFILLER_37_664 VPWR VGND sg13g2_fill_2
X_4956_ net122 VGND VPWR _0288_ videogen.test_lut_thingy.pixel_feeder_inst.row\[18\]\[2\]
+ _0015_ sg13g2_dfrbpq_1
X_4887_ net680 net725 _0222_ VPWR VGND sg13g2_nor2_1
X_3907_ videogen.test_lut_thingy.pixel_feeder_inst.row\[3\]\[0\] net578 _1559_ VPWR
+ VGND sg13g2_nor2_1
X_3838_ videogen.test_lut_thingy.pixel_feeder_inst.row\[63\]\[3\] net571 _1491_ VPWR
+ VGND sg13g2_nor2_1
XFILLER_4_708 VPWR VGND sg13g2_decap_8
XFILLER_10_12 VPWR VGND sg13g2_fill_2
XFILLER_4_719 VPWR VGND sg13g2_fill_2
X_3769_ _1422_ net626 _1421_ VPWR VGND sg13g2_nand2b_1
XFILLER_0_958 VPWR VGND sg13g2_decap_8
XFILLER_19_21 VPWR VGND sg13g2_fill_2
XFILLER_48_929 VPWR VGND sg13g2_decap_8
XFILLER_19_76 VPWR VGND sg13g2_fill_2
XFILLER_43_645 VPWR VGND sg13g2_fill_1
XFILLER_43_612 VPWR VGND sg13g2_decap_4
XFILLER_16_837 VPWR VGND sg13g2_fill_2
XFILLER_16_848 VPWR VGND sg13g2_fill_2
XFILLER_43_656 VPWR VGND sg13g2_decap_4
XFILLER_42_199 VPWR VGND sg13g2_fill_1
XFILLER_23_391 VPWR VGND sg13g2_fill_2
XFILLER_11_564 VPWR VGND sg13g2_fill_2
XFILLER_2_240 VPWR VGND sg13g2_decap_4
XFILLER_3_796 VPWR VGND sg13g2_decap_4
XFILLER_47_951 VPWR VGND sg13g2_decap_8
X_5305__173 VPWR VGND net173 sg13g2_tiehi
XFILLER_34_601 VPWR VGND sg13g2_fill_2
XFILLER_18_185 VPWR VGND sg13g2_fill_2
XFILLER_34_612 VPWR VGND sg13g2_decap_4
X_4810_ net672 net717 _0145_ VPWR VGND sg13g2_nor2_1
X_4741_ net686 net731 _0076_ VPWR VGND sg13g2_nor2_1
XFILLER_21_339 VPWR VGND sg13g2_fill_2
X_4672_ net696 net741 _0009_ VPWR VGND sg13g2_nor2_1
X_3623_ net606 _1270_ _1275_ _1276_ VPWR VGND sg13g2_nor3_1
XFILLER_30_895 VPWR VGND sg13g2_fill_1
X_3554_ VPWR _1207_ _1206_ VGND sg13g2_inv_1
X_3485_ VGND VPWR _1024_ _1026_ _1138_ _1025_ sg13g2_a21oi_1
X_5224_ net311 VGND VPWR _0552_ videogen.test_lut_thingy.pixel_feeder_inst.row\[48\]\[0\]
+ _0181_ sg13g2_dfrbpq_1
XFILLER_5_1007 VPWR VGND sg13g2_decap_8
X_5155_ net196 VGND VPWR _0483_ videogen.test_lut_thingy.pixel_feeder_inst.row\[60\]\[3\]
+ _0120_ sg13g2_dfrbpq_1
X_5086_ net325 VGND VPWR _0001_ videogen.test_lut_thingy.pixel_feeder_inst.state\[3\]
+ net646 sg13g2_dfrbpq_1
X_4106_ _0979_ VPWR _1752_ VGND _0978_ _1170_ sg13g2_o21ai_1
X_5063__359 VPWR VGND net359 sg13g2_tiehi
X_4037_ _1679_ _1685_ _1686_ VPWR VGND sg13g2_and2_1
XFILLER_2_90 VPWR VGND sg13g2_decap_8
XFILLER_37_483 VPWR VGND sg13g2_fill_1
XFILLER_25_689 VPWR VGND sg13g2_decap_8
X_4939_ net149 VGND VPWR _0271_ videogen.test_lut_thingy.pixel_feeder_inst.row\[1\]\[0\]
+ _0005_ sg13g2_dfrbpq_1
XFILLER_21_851 VPWR VGND sg13g2_decap_8
XFILLER_21_862 VPWR VGND sg13g2_fill_1
XFILLER_21_22 VPWR VGND sg13g2_decap_8
XFILLER_0_755 VPWR VGND sg13g2_decap_8
XFILLER_29_940 VPWR VGND sg13g2_fill_1
XFILLER_44_943 VPWR VGND sg13g2_decap_8
XFILLER_16_623 VPWR VGND sg13g2_decap_4
XFILLER_28_472 VPWR VGND sg13g2_fill_2
XFILLER_16_656 VPWR VGND sg13g2_decap_8
XFILLER_12_840 VPWR VGND sg13g2_fill_2
XFILLER_31_648 VPWR VGND sg13g2_decap_8
XFILLER_11_350 VPWR VGND sg13g2_decap_8
XFILLER_8_844 VPWR VGND sg13g2_fill_2
XFILLER_7_46 VPWR VGND sg13g2_decap_8
XFILLER_7_365 VPWR VGND sg13g2_decap_8
XFILLER_7_57 VPWR VGND sg13g2_fill_2
XFILLER_11_394 VPWR VGND sg13g2_decap_8
XFILLER_7_376 VPWR VGND sg13g2_fill_2
XFILLER_3_571 VPWR VGND sg13g2_decap_4
X_3270_ _0950_ videogen.test_lut_thingy.pixel_feeder_inst.h_counter\[2\] _0949_ VPWR
+ VGND sg13g2_xnor2_1
X_4949__131 VPWR VGND net131 sg13g2_tiehi
XFILLER_23_4 VPWR VGND sg13g2_decap_8
XFILLER_38_225 VPWR VGND sg13g2_fill_1
XFILLER_34_442 VPWR VGND sg13g2_decap_4
XFILLER_35_943 VPWR VGND sg13g2_fill_1
XFILLER_22_604 VPWR VGND sg13g2_fill_1
XFILLER_21_114 VPWR VGND sg13g2_decap_4
X_4724_ net710 net755 _0059_ VPWR VGND sg13g2_nor2_1
X_2985_ videogen.test_lut_thingy.pixel_feeder_inst.row\[2\]\[0\] net808 _0812_ _0444_
+ VPWR VGND sg13g2_mux2_1
X_4655_ VPWR _0660_ _2242_ VGND sg13g2_inv_1
X_4586_ _2184_ VPWR _2201_ VGND _2182_ _2185_ sg13g2_o21ai_1
X_3606_ _1255_ _1256_ _1257_ _1258_ _1259_ VPWR VGND sg13g2_nor4_1
X_5284__305 VPWR VGND net305 sg13g2_tiehi
X_3537_ _1190_ _1182_ _1189_ _1181_ _1168_ VPWR VGND sg13g2_a22oi_1
X_3468_ _1100_ net553 _1121_ VPWR VGND sg13g2_and2_1
X_3399_ _1052_ videogen.fancy_shader.video_y\[8\] videogen.fancy_shader.n646\[8\]
+ VPWR VGND sg13g2_nand2_1
XFILLER_29_203 VPWR VGND sg13g2_fill_1
X_5207_ net418 VGND VPWR _0535_ videogen.test_lut_thingy.pixel_feeder_inst.row\[53\]\[3\]
+ _0164_ sg13g2_dfrbpq_1
X_5138_ net230 VGND VPWR _0466_ videogen.test_lut_thingy.pixel_feeder_inst.row\[8\]\[2\]
+ _0103_ sg13g2_dfrbpq_1
X_5267__66 VPWR VGND net66 sg13g2_tiehi
XFILLER_29_269 VPWR VGND sg13g2_fill_1
XFILLER_44_217 VPWR VGND sg13g2_fill_2
X_5069_ net351 VGND VPWR _0401_ videogen.test_lut_thingy.pixel_feeder_inst.row\[16\]\[2\]
+ _0047_ sg13g2_dfrbpq_1
XFILLER_26_932 VPWR VGND sg13g2_fill_2
XFILLER_41_935 VPWR VGND sg13g2_fill_1
XFILLER_13_626 VPWR VGND sg13g2_decap_8
XFILLER_9_608 VPWR VGND sg13g2_decap_4
XFILLER_12_114 VPWR VGND sg13g2_fill_2
XFILLER_32_43 VPWR VGND sg13g2_fill_1
XFILLER_10_1023 VPWR VGND sg13g2_decap_4
XFILLER_48_501 VPWR VGND sg13g2_decap_8
XFILLER_0_552 VPWR VGND sg13g2_decap_8
XFILLER_48_578 VPWR VGND sg13g2_decap_8
XFILLER_17_921 VPWR VGND sg13g2_decap_8
XFILLER_16_442 VPWR VGND sg13g2_fill_2
XFILLER_44_762 VPWR VGND sg13g2_fill_1
XFILLER_17_998 VPWR VGND sg13g2_decap_8
XFILLER_43_294 VPWR VGND sg13g2_decap_4
XFILLER_31_412 VPWR VGND sg13g2_decap_8
XFILLER_31_434 VPWR VGND sg13g2_fill_2
XFILLER_31_456 VPWR VGND sg13g2_fill_1
XFILLER_12_670 VPWR VGND sg13g2_decap_4
X_5018__423 VPWR VGND net423 sg13g2_tiehi
X_2770_ net770 videogen.test_lut_thingy.pixel_feeder_inst.row\[39\]\[3\] _0756_ _0611_
+ VPWR VGND sg13g2_mux2_1
XFILLER_8_696 VPWR VGND sg13g2_decap_8
XFILLER_7_173 VPWR VGND sg13g2_fill_1
X_4440_ _2071_ red\[2\] _2067_ VPWR VGND sg13g2_xnor2_1
X_4371_ _1999_ _2010_ _2011_ VPWR VGND sg13g2_nor2b_1
X_3322_ net811 VPWR _0991_ VGND _0678_ _0990_ sg13g2_o21ai_1
Xfanout609 _0685_ net609 VPWR VGND sg13g2_buf_8
X_3253_ _0938_ videogen.test_lut_thingy.pixel_feeder_inst.v_counter\[1\] videogen.test_lut_thingy.pixel_feeder_inst.v_counter\[0\]
+ VPWR VGND sg13g2_nand2_1
X_3184_ VGND VPWR videogen.fancy_shader.video_x\[2\] _0839_ _0296_ _0890_ sg13g2_a21oi_1
X_5101__304 VPWR VGND net304 sg13g2_tiehi
XFILLER_23_902 VPWR VGND sg13g2_decap_8
XFILLER_35_773 VPWR VGND sg13g2_fill_1
XFILLER_22_412 VPWR VGND sg13g2_decap_4
XFILLER_22_467 VPWR VGND sg13g2_fill_2
XFILLER_23_979 VPWR VGND sg13g2_decap_8
X_2968_ videogen.test_lut_thingy.pixel_feeder_inst.row\[10\]\[2\] net787 _0809_ _0458_
+ VPWR VGND sg13g2_mux2_1
XFILLER_31_990 VPWR VGND sg13g2_decap_8
X_4707_ net712 net752 _0043_ VPWR VGND sg13g2_nor2_1
X_4638_ _2234_ net665 net466 net670 green_tmds_par\[2\] VPWR VGND sg13g2_a22oi_1
X_2899_ videogen.test_lut_thingy.pixel_feeder_inst.row\[28\]\[3\] net767 _0793_ _0519_
+ VPWR VGND sg13g2_mux2_1
X_5249__211 VPWR VGND net211 sg13g2_tiehi
X_4569_ _2185_ _2176_ _2183_ VPWR VGND sg13g2_xnor2_1
XFILLER_40_1005 VPWR VGND sg13g2_decap_8
XFILLER_17_239 VPWR VGND sg13g2_decap_4
XFILLER_14_946 VPWR VGND sg13g2_decap_8
XFILLER_41_765 VPWR VGND sg13g2_fill_2
X_5152__202 VPWR VGND net202 sg13g2_tiehi
X_5191__68 VPWR VGND net68 sg13g2_tiehi
XFILLER_4_25 VPWR VGND sg13g2_decap_8
XFILLER_49_821 VPWR VGND sg13g2_decap_8
XFILLER_49_898 VPWR VGND sg13g2_decap_8
XFILLER_36_526 VPWR VGND sg13g2_decap_8
XFILLER_1_1021 VPWR VGND sg13g2_decap_8
X_3940_ videogen.test_lut_thingy.pixel_feeder_inst.row\[21\]\[0\] net561 _1592_ VPWR
+ VGND sg13g2_nor2_1
XFILLER_16_250 VPWR VGND sg13g2_decap_4
XFILLER_17_762 VPWR VGND sg13g2_decap_8
XFILLER_44_592 VPWR VGND sg13g2_decap_8
X_3871_ videogen.test_lut_thingy.pixel_feeder_inst.row\[6\]\[3\] net587 _1524_ VPWR
+ VGND sg13g2_nor2_1
XFILLER_31_242 VPWR VGND sg13g2_fill_1
X_2822_ videogen.test_lut_thingy.pixel_feeder_inst.row\[42\]\[2\] net781 _0775_ _0578_
+ VPWR VGND sg13g2_mux2_1
XFILLER_20_949 VPWR VGND sg13g2_decap_8
X_2753_ videogen.test_lut_thingy.pixel_feeder_inst.row\[24\]\[1\] net794 _0745_ _0627_
+ VPWR VGND sg13g2_mux2_1
X_4953__127 VPWR VGND net127 sg13g2_tiehi
X_2684_ VPWR _0692_ videogen.mem_read VGND sg13g2_inv_1
X_4423_ _2059_ net616 _2056_ VPWR VGND sg13g2_nand2_1
X_4354_ _1995_ _1993_ _1994_ VPWR VGND sg13g2_nand2_2
X_5129__248 VPWR VGND net248 sg13g2_tiehi
X_3305_ _0979_ _0964_ _0978_ VPWR VGND sg13g2_nand2_2
X_4285_ VGND VPWR _1916_ _1922_ _1931_ _1926_ sg13g2_a21oi_1
XFILLER_39_342 VPWR VGND sg13g2_decap_8
X_3236_ net580 _0924_ _0927_ VPWR VGND sg13g2_nor2_1
XFILLER_39_364 VPWR VGND sg13g2_decap_8
X_3167_ VGND VPWR net765 _0883_ _0882_ net492 sg13g2_a21oi_2
X_3098_ VGND VPWR _0692_ _0847_ _0003_ net762 sg13g2_a21oi_1
XFILLER_27_559 VPWR VGND sg13g2_decap_8
XFILLER_14_209 VPWR VGND sg13g2_decap_4
XFILLER_23_710 VPWR VGND sg13g2_decap_8
XFILLER_11_905 VPWR VGND sg13g2_decap_8
XFILLER_22_220 VPWR VGND sg13g2_fill_2
XFILLER_13_12 VPWR VGND sg13g2_fill_2
XFILLER_23_787 VPWR VGND sg13g2_decap_8
XFILLER_46_813 VPWR VGND sg13g2_decap_8
XFILLER_45_323 VPWR VGND sg13g2_decap_8
XFILLER_45_367 VPWR VGND sg13g2_fill_1
XFILLER_45_356 VPWR VGND sg13g2_decap_4
XFILLER_14_732 VPWR VGND sg13g2_decap_8
XFILLER_41_540 VPWR VGND sg13g2_decap_8
XFILLER_13_242 VPWR VGND sg13g2_fill_2
XFILLER_9_213 VPWR VGND sg13g2_decap_8
XFILLER_13_297 VPWR VGND sg13g2_decap_8
XFILLER_6_920 VPWR VGND sg13g2_decap_8
XFILLER_9_279 VPWR VGND sg13g2_decap_4
XFILLER_10_960 VPWR VGND sg13g2_decap_8
XFILLER_6_997 VPWR VGND sg13g2_decap_8
XFILLER_49_651 VPWR VGND sg13g2_decap_8
X_4070_ _1707_ _1718_ _1719_ VPWR VGND sg13g2_nor2b_1
XFILLER_23_1000 VPWR VGND sg13g2_decap_8
X_3021_ _0820_ _0755_ VPWR VGND _0806_ sg13g2_nand2b_2
XFILLER_36_301 VPWR VGND sg13g2_decap_4
XFILLER_37_857 VPWR VGND sg13g2_fill_2
XFILLER_17_570 VPWR VGND sg13g2_fill_2
X_4972_ net100 VGND VPWR _0304_ tmds_blue.vsync net650 sg13g2_dfrbpq_1
X_3923_ net632 VPWR _1575_ VGND videogen.test_lut_thingy.pixel_feeder_inst.row\[24\]\[0\]
+ net598 sg13g2_o21ai_1
X_3854_ _1503_ _1504_ _1505_ _1506_ _1507_ VPWR VGND sg13g2_nor4_1
XFILLER_32_584 VPWR VGND sg13g2_decap_8
X_2805_ videogen.test_lut_thingy.pixel_feeder_inst.row\[3\]\[1\] net796 _0769_ _0589_
+ VPWR VGND sg13g2_mux2_1
X_3785_ _1434_ _1435_ _1436_ _1437_ _1438_ VPWR VGND sg13g2_nor4_1
X_2736_ videogen.test_lut_thingy.pixel_feeder_inst.row\[22\]\[1\] net790 _0736_ _0635_
+ VPWR VGND sg13g2_mux2_1
X_2667_ VPWR _0675_ videogen.test_lut_thingy.pixel_feeder_inst.row\[62\]\[0\] VGND
+ sg13g2_inv_1
X_4406_ _2044_ tmds_red.dc_balancing_reg\[4\] _2043_ VPWR VGND sg13g2_xnor2_1
XFILLER_8_1027 VPWR VGND sg13g2_fill_2
XFILLER_8_1016 VPWR VGND sg13g2_decap_8
X_4337_ VGND VPWR _1970_ _1971_ _1978_ _1973_ sg13g2_a21oi_1
X_4268_ VGND VPWR _1914_ _1912_ _1911_ sg13g2_or2_1
X_3219_ videogen.test_lut_thingy.pixel_feeder_inst.v_pix\[2\] _0914_ _0915_ VPWR VGND
+ sg13g2_nor2_1
X_4199_ _1830_ VPWR _1845_ VGND _1823_ _1827_ sg13g2_o21ai_1
XFILLER_28_857 VPWR VGND sg13g2_fill_2
XFILLER_43_827 VPWR VGND sg13g2_decap_4
XFILLER_24_11 VPWR VGND sg13g2_decap_4
XFILLER_40_54 VPWR VGND sg13g2_decap_8
XFILLER_40_87 VPWR VGND sg13g2_fill_2
XFILLER_3_967 VPWR VGND sg13g2_decap_8
XFILLER_49_63 VPWR VGND sg13g2_decap_8
XFILLER_46_610 VPWR VGND sg13g2_decap_8
Xfanout792 net793 net792 VPWR VGND sg13g2_buf_8
Xfanout770 net771 net770 VPWR VGND sg13g2_buf_8
Xfanout781 net782 net781 VPWR VGND sg13g2_buf_8
XFILLER_19_868 VPWR VGND sg13g2_decap_4
XFILLER_46_698 VPWR VGND sg13g2_decap_8
XFILLER_27_890 VPWR VGND sg13g2_fill_1
XFILLER_45_197 VPWR VGND sg13g2_decap_4
X_3570_ VGND VPWR _1142_ _1223_ _1222_ _1219_ sg13g2_a21oi_2
XFILLER_6_794 VPWR VGND sg13g2_decap_4
XFILLER_5_271 VPWR VGND sg13g2_fill_2
XFILLER_5_260 VPWR VGND sg13g2_decap_8
X_5240_ net247 VGND VPWR _0568_ videogen.test_lut_thingy.pixel_feeder_inst.row\[44\]\[0\]
+ _0197_ sg13g2_dfrbpq_1
X_5171_ net159 VGND VPWR _0499_ videogen.test_lut_thingy.pixel_feeder_inst.row\[56\]\[3\]
+ _0136_ sg13g2_dfrbpq_1
X_4122_ _1761_ _1044_ _1768_ VPWR VGND sg13g2_xor2_1
X_4053_ _1682_ _1699_ _1702_ VPWR VGND sg13g2_and2_1
X_3004_ videogen.test_lut_thingy.pixel_feeder_inst.row\[9\]\[1\] net798 _0816_ _0429_
+ VPWR VGND sg13g2_mux2_1
XFILLER_37_676 VPWR VGND sg13g2_fill_1
XFILLER_25_838 VPWR VGND sg13g2_decap_8
XFILLER_25_849 VPWR VGND sg13g2_fill_2
XFILLER_36_164 VPWR VGND sg13g2_fill_1
XFILLER_40_808 VPWR VGND sg13g2_fill_1
X_4955_ net124 VGND VPWR _0287_ videogen.test_lut_thingy.pixel_feeder_inst.row\[18\]\[1\]
+ _0014_ sg13g2_dfrbpq_1
X_3906_ videogen.test_lut_thingy.pixel_feeder_inst.row\[1\]\[0\] net567 _1558_ VPWR
+ VGND sg13g2_nor2_1
X_4886_ net680 net724 _0221_ VPWR VGND sg13g2_nor2_1
XFILLER_32_370 VPWR VGND sg13g2_fill_2
X_3837_ net634 VPWR _1490_ VGND videogen.test_lut_thingy.pixel_feeder_inst.row\[60\]\[3\]
+ net597 sg13g2_o21ai_1
XFILLER_20_543 VPWR VGND sg13g2_decap_8
XFILLER_20_554 VPWR VGND sg13g2_decap_4
X_3768_ net612 _1415_ _1420_ _1421_ VPWR VGND sg13g2_nor3_1
X_2719_ _0724_ _0725_ _0726_ VPWR VGND sg13g2_nor2_2
XFILLER_10_46 VPWR VGND sg13g2_decap_8
X_3699_ videogen.test_lut_thingy.pixel_feeder_inst.row\[20\]\[1\] net593 _1352_ VPWR
+ VGND sg13g2_nor2_1
XFILLER_0_937 VPWR VGND sg13g2_decap_8
XFILLER_48_908 VPWR VGND sg13g2_decap_8
XFILLER_47_407 VPWR VGND sg13g2_decap_8
XFILLER_28_621 VPWR VGND sg13g2_decap_8
XFILLER_28_643 VPWR VGND sg13g2_fill_1
XFILLER_43_602 VPWR VGND sg13g2_decap_4
XFILLER_15_348 VPWR VGND sg13g2_fill_1
XFILLER_31_808 VPWR VGND sg13g2_decap_8
Xclkbuf_3_3_0_clk_regs clknet_0_clk_regs clknet_3_3_0_clk_regs VPWR VGND sg13g2_buf_8
XFILLER_7_569 VPWR VGND sg13g2_fill_2
X_4980__85 VPWR VGND net85 sg13g2_tiehi
XFILLER_2_296 VPWR VGND sg13g2_fill_2
XFILLER_47_930 VPWR VGND sg13g2_decap_8
XFILLER_19_621 VPWR VGND sg13g2_decap_8
XFILLER_19_632 VPWR VGND sg13g2_decap_8
XFILLER_46_440 VPWR VGND sg13g2_fill_2
XFILLER_19_665 VPWR VGND sg13g2_decap_8
XFILLER_46_462 VPWR VGND sg13g2_decap_8
XFILLER_33_123 VPWR VGND sg13g2_decap_4
XFILLER_34_657 VPWR VGND sg13g2_fill_2
X_4740_ net687 net732 _0075_ VPWR VGND sg13g2_nor2_1
X_4671_ net713 net758 _0008_ VPWR VGND sg13g2_nor2_1
XFILLER_30_852 VPWR VGND sg13g2_decap_8
XFILLER_30_863 VPWR VGND sg13g2_fill_2
X_3622_ _1271_ _1272_ _1273_ _1274_ _1275_ VPWR VGND sg13g2_nor4_1
X_3553_ _1206_ _1204_ _1205_ VPWR VGND sg13g2_nand2_1
XFILLER_44_0 VPWR VGND sg13g2_decap_8
X_3484_ _1137_ _1039_ _1135_ VPWR VGND sg13g2_xnor2_1
X_5223_ net324 VGND VPWR _0551_ videogen.test_lut_thingy.pixel_feeder_inst.row\[4\]\[3\]
+ _0180_ sg13g2_dfrbpq_1
X_5154_ net198 VGND VPWR _0482_ videogen.test_lut_thingy.pixel_feeder_inst.row\[60\]\[2\]
+ _0119_ sg13g2_dfrbpq_1
X_4105_ _1744_ VPWR _0369_ VGND _1750_ _1751_ sg13g2_o21ai_1
X_5085_ net420 VGND VPWR _0000_ videogen.mem_read net645 sg13g2_dfrbpq_2
X_4036_ _1680_ _1678_ _1674_ _1685_ VPWR VGND sg13g2_a21o_1
XFILLER_37_473 VPWR VGND sg13g2_fill_2
XFILLER_25_635 VPWR VGND sg13g2_decap_4
XFILLER_36_1021 VPWR VGND sg13g2_decap_8
X_4938_ net150 VGND VPWR _0270_ serialize.shift_reg_b\[9\] clknet_3_2_0_clk_regs sg13g2_dfrbpq_1
XFILLER_21_830 VPWR VGND sg13g2_decap_8
X_4869_ net692 net736 _0204_ VPWR VGND sg13g2_nor2_1
XFILLER_43_1014 VPWR VGND sg13g2_decap_8
XFILLER_0_734 VPWR VGND sg13g2_decap_8
XFILLER_28_451 VPWR VGND sg13g2_fill_2
XFILLER_44_922 VPWR VGND sg13g2_decap_4
XFILLER_15_101 VPWR VGND sg13g2_fill_2
XFILLER_16_602 VPWR VGND sg13g2_fill_1
XFILLER_29_985 VPWR VGND sg13g2_decap_8
XFILLER_43_443 VPWR VGND sg13g2_decap_4
XFILLER_44_999 VPWR VGND sg13g2_decap_8
XFILLER_31_605 VPWR VGND sg13g2_fill_2
XFILLER_31_616 VPWR VGND sg13g2_decap_8
XFILLER_7_25 VPWR VGND sg13g2_decap_8
XFILLER_7_69 VPWR VGND sg13g2_decap_8
XFILLER_3_550 VPWR VGND sg13g2_decap_8
XFILLER_16_4 VPWR VGND sg13g2_decap_4
XFILLER_19_451 VPWR VGND sg13g2_decap_4
XFILLER_47_782 VPWR VGND sg13g2_decap_8
XFILLER_35_933 VPWR VGND sg13g2_fill_1
X_5062__360 VPWR VGND net360 sg13g2_tiehi
XFILLER_35_988 VPWR VGND sg13g2_fill_1
XFILLER_15_690 VPWR VGND sg13g2_decap_8
X_2984_ videogen.test_lut_thingy.pixel_feeder_inst.row\[2\]\[1\] net796 _0812_ _0445_
+ VPWR VGND sg13g2_mux2_1
X_4723_ net710 net755 _0058_ VPWR VGND sg13g2_nor2_1
X_4654_ _2242_ net664 net469 net669 red_tmds_par\[2\] VPWR VGND sg13g2_a22oi_1
X_4585_ _2199_ VPWR _2200_ VGND _2180_ _2189_ sg13g2_o21ai_1
X_3605_ videogen.test_lut_thingy.pixel_feeder_inst.row\[16\]\[2\] net599 _1258_ VPWR
+ VGND sg13g2_nor2_1
X_3536_ _1188_ _1187_ _1185_ _1189_ VPWR VGND sg13g2_a21o_1
X_3467_ net553 _1113_ _1120_ VPWR VGND sg13g2_nor2_2
X_5206_ net422 VGND VPWR _0534_ videogen.test_lut_thingy.pixel_feeder_inst.row\[53\]\[2\]
+ _0163_ sg13g2_dfrbpq_1
X_3398_ _1051_ _1044_ _1049_ VPWR VGND sg13g2_xnor2_1
X_5137_ net232 VGND VPWR _0465_ videogen.test_lut_thingy.pixel_feeder_inst.row\[8\]\[1\]
+ _0102_ sg13g2_dfrbpq_1
XFILLER_29_226 VPWR VGND sg13g2_decap_8
X_5068_ net353 VGND VPWR _0400_ videogen.test_lut_thingy.pixel_feeder_inst.row\[16\]\[1\]
+ _0046_ sg13g2_dfrbpq_1
X_5108__290 VPWR VGND net290 sg13g2_tiehi
X_4019_ VPWR _1668_ _1667_ VGND sg13g2_inv_1
X_5139__228 VPWR VGND net228 sg13g2_tiehi
XFILLER_16_45 VPWR VGND sg13g2_decap_8
XFILLER_26_999 VPWR VGND sg13g2_decap_8
XFILLER_40_457 VPWR VGND sg13g2_decap_4
XFILLER_21_671 VPWR VGND sg13g2_decap_4
X_5039__395 VPWR VGND net395 sg13g2_tiehi
XFILLER_10_1002 VPWR VGND sg13g2_decap_8
XFILLER_0_531 VPWR VGND sg13g2_decap_8
XFILLER_0_597 VPWR VGND sg13g2_decap_8
XFILLER_48_557 VPWR VGND sg13g2_decap_8
X_5046__388 VPWR VGND net388 sg13g2_tiehi
XFILLER_35_218 VPWR VGND sg13g2_decap_4
XFILLER_35_229 VPWR VGND sg13g2_fill_1
XFILLER_16_410 VPWR VGND sg13g2_decap_8
XFILLER_28_281 VPWR VGND sg13g2_fill_2
XFILLER_16_476 VPWR VGND sg13g2_fill_1
XFILLER_17_977 VPWR VGND sg13g2_decap_8
XFILLER_40_991 VPWR VGND sg13g2_decap_8
XFILLER_8_653 VPWR VGND sg13g2_fill_2
XFILLER_7_185 VPWR VGND sg13g2_decap_4
X_4370_ tmds_red.dc_balancing_reg\[1\] _1985_ _1974_ _2010_ VPWR VGND sg13g2_mux2_1
X_3321_ _0345_ net811 _0989_ _0990_ VPWR VGND sg13g2_and3_1
X_5209__410 VPWR VGND net410 sg13g2_tiehi
XFILLER_4_881 VPWR VGND sg13g2_decap_8
X_3252_ _0936_ _0937_ _0317_ VPWR VGND sg13g2_nor2_1
X_5166__170 VPWR VGND net170 sg13g2_tiehi
XFILLER_26_1020 VPWR VGND sg13g2_decap_8
X_3183_ net810 VPWR _0890_ VGND videogen.fancy_shader.video_x\[2\] _0839_ sg13g2_o21ai_1
XFILLER_39_568 VPWR VGND sg13g2_fill_2
XFILLER_39_557 VPWR VGND sg13g2_decap_8
XFILLER_23_958 VPWR VGND sg13g2_decap_8
XFILLER_10_608 VPWR VGND sg13g2_decap_8
X_2967_ videogen.test_lut_thingy.pixel_feeder_inst.row\[10\]\[3\] net776 _0809_ _0459_
+ VPWR VGND sg13g2_mux2_1
XFILLER_33_1024 VPWR VGND sg13g2_decap_4
X_4706_ net714 net752 _0042_ VPWR VGND sg13g2_nor2_1
X_2898_ _0743_ _0778_ _0793_ VPWR VGND sg13g2_nor2_2
X_4637_ VPWR _0651_ _2233_ VGND sg13g2_inv_1
X_4568_ _2184_ _2176_ _2183_ VPWR VGND sg13g2_nand2_1
X_4499_ VGND VPWR _2123_ _2122_ _2116_ sg13g2_or2_1
X_3519_ _1170_ _1169_ _1172_ VPWR VGND sg13g2_xor2_1
XFILLER_40_1028 VPWR VGND sg13g2_fill_1
XFILLER_26_730 VPWR VGND sg13g2_fill_1
XFILLER_27_66 VPWR VGND sg13g2_fill_2
XFILLER_25_251 VPWR VGND sg13g2_decap_8
XFILLER_26_752 VPWR VGND sg13g2_fill_2
XFILLER_43_32 VPWR VGND sg13g2_fill_2
XFILLER_14_925 VPWR VGND sg13g2_decap_8
XFILLER_13_446 VPWR VGND sg13g2_decap_8
X_5076__337 VPWR VGND net337 sg13g2_tiehi
XFILLER_43_76 VPWR VGND sg13g2_fill_2
XFILLER_40_276 VPWR VGND sg13g2_fill_1
XFILLER_13_479 VPWR VGND sg13g2_fill_2
XFILLER_21_490 VPWR VGND sg13g2_decap_8
XFILLER_4_166 VPWR VGND sg13g2_decap_8
XFILLER_49_800 VPWR VGND sg13g2_decap_8
XFILLER_1_895 VPWR VGND sg13g2_decap_8
XFILLER_49_877 VPWR VGND sg13g2_decap_8
XFILLER_0_383 VPWR VGND sg13g2_decap_8
X_4946__135 VPWR VGND net135 sg13g2_tiehi
XFILLER_48_376 VPWR VGND sg13g2_fill_1
XFILLER_1_1000 VPWR VGND sg13g2_decap_8
XFILLER_17_730 VPWR VGND sg13g2_fill_2
XFILLER_44_571 VPWR VGND sg13g2_decap_8
XFILLER_17_796 VPWR VGND sg13g2_fill_1
XFILLER_17_1019 VPWR VGND sg13g2_decap_8
X_3870_ videogen.test_lut_thingy.pixel_feeder_inst.row\[5\]\[3\] net566 _1523_ VPWR
+ VGND sg13g2_nor2_1
XFILLER_31_221 VPWR VGND sg13g2_decap_8
X_2821_ videogen.test_lut_thingy.pixel_feeder_inst.row\[42\]\[3\] net769 _0775_ _0579_
+ VPWR VGND sg13g2_mux2_1
XFILLER_20_928 VPWR VGND sg13g2_decap_8
XFILLER_31_254 VPWR VGND sg13g2_decap_8
X_2752_ videogen.test_lut_thingy.pixel_feeder_inst.row\[24\]\[2\] net783 _0745_ _0628_
+ VPWR VGND sg13g2_mux2_1
XFILLER_13_991 VPWR VGND sg13g2_decap_8
XFILLER_9_995 VPWR VGND sg13g2_decap_8
X_4422_ _2058_ net617 net605 VPWR VGND sg13g2_nand2_1
X_2683_ _0691_ net814 VPWR VGND sg13g2_inv_2
X_4353_ _1994_ _1991_ _0698_ _1989_ _1986_ VPWR VGND sg13g2_a22oi_1
X_3304_ videogen.fancy_shader.video_x\[0\] videogen.fancy_shader.n646\[0\] _0978_
+ VPWR VGND sg13g2_xor2_1
X_4284_ _1930_ _1183_ _1918_ _1929_ VPWR VGND sg13g2_and3_1
X_3235_ _0849_ _0926_ _0311_ VPWR VGND sg13g2_nor2_1
X_3166_ serialize.tmds_parallel_b\[9\] net667 _0270_ VPWR VGND sg13g2_and2_1
X_3097_ net810 _0833_ _0362_ VPWR VGND sg13g2_and2_1
XFILLER_35_560 VPWR VGND sg13g2_decap_8
XFILLER_23_766 VPWR VGND sg13g2_decap_8
X_3999_ _1254_ VPWR _0365_ VGND _1551_ _1647_ sg13g2_o21ai_1
XFILLER_13_57 VPWR VGND sg13g2_decap_8
XFILLER_13_68 VPWR VGND sg13g2_fill_1
X_5036__398 VPWR VGND net398 sg13g2_tiehi
XFILLER_1_158 VPWR VGND sg13g2_fill_2
XFILLER_49_107 VPWR VGND sg13g2_decap_8
XFILLER_46_869 VPWR VGND sg13g2_decap_8
XFILLER_18_549 VPWR VGND sg13g2_decap_8
XFILLER_26_582 VPWR VGND sg13g2_decap_8
XFILLER_13_232 VPWR VGND sg13g2_decap_4
XFILLER_6_976 VPWR VGND sg13g2_decap_8
XFILLER_48_7 VPWR VGND sg13g2_decap_8
XFILLER_49_630 VPWR VGND sg13g2_decap_8
X_3020_ videogen.test_lut_thingy.pixel_feeder_inst.row\[14\]\[0\] net808 _0819_ _0407_
+ VPWR VGND sg13g2_mux2_1
X_4971_ net101 VGND VPWR _0303_ videogen.fancy_shader.video_x\[9\] net649 sg13g2_dfrbpq_2
X_3922_ videogen.test_lut_thingy.pixel_feeder_inst.h_pix\[4\] _1562_ _1573_ _1574_
+ VPWR VGND sg13g2_nor3_1
X_3853_ videogen.test_lut_thingy.pixel_feeder_inst.row\[16\]\[3\] net599 _1506_ VPWR
+ VGND sg13g2_nor2_1
X_2804_ videogen.test_lut_thingy.pixel_feeder_inst.row\[3\]\[2\] net785 _0769_ _0590_
+ VPWR VGND sg13g2_mux2_1
XFILLER_9_770 VPWR VGND sg13g2_decap_8
X_3784_ videogen.test_lut_thingy.pixel_feeder_inst.row\[36\]\[1\] net595 _1437_ VPWR
+ VGND sg13g2_nor2_1
X_2735_ videogen.test_lut_thingy.pixel_feeder_inst.row\[22\]\[2\] net779 _0736_ _0636_
+ VPWR VGND sg13g2_mux2_1
XFILLER_30_1027 VPWR VGND sg13g2_fill_2
X_2666_ VPWR _0674_ videogen.test_lut_thingy.pixel_feeder_inst.row\[62\]\[3\] VGND
+ sg13g2_inv_1
X_4405_ _1988_ VPWR _2043_ VGND tmds_red.dc_balancing_reg\[3\] _2021_ sg13g2_o21ai_1
X_4336_ _1977_ red\[4\] _1952_ VPWR VGND sg13g2_nand2_2
X_5285__297 VPWR VGND net297 sg13g2_tiehi
X_4267_ _1911_ _1912_ _1913_ VPWR VGND sg13g2_nor2_1
X_3218_ _0909_ _0913_ _0914_ _0306_ VPWR VGND sg13g2_nor3_1
X_4198_ _1844_ _1837_ _1842_ VPWR VGND sg13g2_nand2_1
XFILLER_39_162 VPWR VGND sg13g2_decap_4
X_3149_ _0878_ net810 _0846_ VPWR VGND sg13g2_nand2_1
X_5292__257 VPWR VGND net257 sg13g2_tiehi
X_4977__91 VPWR VGND net91 sg13g2_tiehi
XFILLER_11_703 VPWR VGND sg13g2_fill_1
X_4992__61 VPWR VGND net61 sg13g2_tiehi
XFILLER_40_99 VPWR VGND sg13g2_fill_2
XFILLER_3_946 VPWR VGND sg13g2_decap_8
XFILLER_2_412 VPWR VGND sg13g2_decap_4
XFILLER_46_1023 VPWR VGND sg13g2_decap_4
XFILLER_2_434 VPWR VGND sg13g2_decap_8
XFILLER_49_42 VPWR VGND sg13g2_decap_8
Xfanout760 net761 net760 VPWR VGND sg13g2_buf_8
Xfanout771 ui_in[7] net771 VPWR VGND sg13g2_buf_8
X_5301__209 VPWR VGND net209 sg13g2_tiehi
Xfanout782 ui_in[6] net782 VPWR VGND sg13g2_buf_8
Xfanout793 net799 net793 VPWR VGND sg13g2_buf_8
XFILLER_1_49 VPWR VGND sg13g2_decap_8
XFILLER_46_666 VPWR VGND sg13g2_decap_8
XFILLER_34_817 VPWR VGND sg13g2_decap_8
XFILLER_42_861 VPWR VGND sg13g2_fill_2
XFILLER_14_563 VPWR VGND sg13g2_fill_1
XFILLER_6_784 VPWR VGND sg13g2_fill_2
X_5170_ net162 VGND VPWR _0498_ videogen.test_lut_thingy.pixel_feeder_inst.row\[56\]\[2\]
+ _0135_ sg13g2_dfrbpq_1
X_4121_ _1044_ _1761_ _1767_ VPWR VGND sg13g2_nor2_1
X_4052_ _1701_ _1697_ _1696_ VPWR VGND sg13g2_nand2b_1
X_3003_ videogen.test_lut_thingy.pixel_feeder_inst.row\[9\]\[2\] net787 _0816_ _0430_
+ VPWR VGND sg13g2_mux2_1
XFILLER_37_655 VPWR VGND sg13g2_decap_4
XFILLER_37_688 VPWR VGND sg13g2_fill_1
XFILLER_24_305 VPWR VGND sg13g2_decap_8
X_4954_ net126 VGND VPWR _0286_ videogen.test_lut_thingy.pixel_feeder_inst.row\[18\]\[0\]
+ _0013_ sg13g2_dfrbpq_1
X_3905_ net611 VPWR _1557_ VGND videogen.test_lut_thingy.pixel_feeder_inst.row\[2\]\[0\]
+ net588 sg13g2_o21ai_1
X_4885_ net712 net759 _0220_ VPWR VGND sg13g2_nor2_1
X_3836_ _1485_ _1486_ _1487_ _1488_ _1489_ VPWR VGND sg13g2_nor4_1
X_3767_ _1416_ _1417_ _1418_ _1419_ _1420_ VPWR VGND sg13g2_nor4_1
XFILLER_3_209 VPWR VGND sg13g2_fill_2
X_2718_ _0725_ net626 _0702_ VPWR VGND sg13g2_xnor2_1
X_3698_ _1350_ VPWR _1351_ VGND net2 _0694_ sg13g2_o21ai_1
XFILLER_10_58 VPWR VGND sg13g2_decap_8
XFILLER_0_916 VPWR VGND sg13g2_decap_8
X_5299_ net225 VGND VPWR _0627_ videogen.test_lut_thingy.pixel_feeder_inst.row\[24\]\[1\]
+ _0246_ sg13g2_dfrbpq_1
XFILLER_19_12 VPWR VGND sg13g2_fill_1
X_4319_ _1957_ _1959_ _1960_ VPWR VGND sg13g2_nor2_1
XFILLER_43_636 VPWR VGND sg13g2_decap_8
XFILLER_24_872 VPWR VGND sg13g2_decap_8
XFILLER_30_308 VPWR VGND sg13g2_fill_1
XFILLER_23_360 VPWR VGND sg13g2_decap_4
XFILLER_7_515 VPWR VGND sg13g2_decap_8
XFILLER_11_566 VPWR VGND sg13g2_fill_1
X_5118__270 VPWR VGND net270 sg13g2_tiehi
X_5149__208 VPWR VGND net208 sg13g2_tiehi
XFILLER_3_787 VPWR VGND sg13g2_fill_1
XFILLER_2_275 VPWR VGND sg13g2_decap_8
Xfanout590 net591 net590 VPWR VGND sg13g2_buf_8
XFILLER_46_452 VPWR VGND sg13g2_fill_1
XFILLER_20_1026 VPWR VGND sg13g2_fill_2
XFILLER_47_986 VPWR VGND sg13g2_decap_8
XFILLER_34_603 VPWR VGND sg13g2_fill_1
XFILLER_33_135 VPWR VGND sg13g2_decap_8
XFILLER_14_371 VPWR VGND sg13g2_fill_2
XFILLER_30_831 VPWR VGND sg13g2_fill_1
X_4670_ net713 net758 _0007_ VPWR VGND sg13g2_nor2_1
X_3621_ videogen.test_lut_thingy.pixel_feeder_inst.row\[22\]\[2\] net583 _1274_ VPWR
+ VGND sg13g2_nor2_1
X_3552_ VGND VPWR _1205_ _1202_ _1050_ sg13g2_or2_1
X_3483_ _1040_ _1135_ _1136_ VPWR VGND sg13g2_nor2_1
X_5222_ net328 VGND VPWR _0550_ videogen.test_lut_thingy.pixel_feeder_inst.row\[4\]\[2\]
+ _0179_ sg13g2_dfrbpq_1
X_5153_ net200 VGND VPWR _0481_ videogen.test_lut_thingy.pixel_feeder_inst.row\[60\]\[1\]
+ _0118_ sg13g2_dfrbpq_1
XFILLER_37_0 VPWR VGND sg13g2_decap_8
X_4104_ _1549_ VPWR _1751_ VGND _1650_ _1745_ sg13g2_o21ai_1
XFILLER_2_70 VPWR VGND sg13g2_fill_2
X_5084_ net189 VGND VPWR _0003_ videogen.test_lut_thingy.pixel_feeder_inst.state\[1\]
+ net646 sg13g2_dfrbpq_1
XFILLER_37_441 VPWR VGND sg13g2_fill_1
X_4035_ VPWR _1684_ _1683_ VGND sg13g2_inv_1
XFILLER_24_146 VPWR VGND sg13g2_fill_2
X_4937_ net151 VGND VPWR _0269_ serialize.shift_reg_b\[8\] clknet_3_0_0_clk_regs sg13g2_dfrbpq_1
X_4868_ net687 net732 _0203_ VPWR VGND sg13g2_nor2_1
X_3819_ net612 _1466_ _1471_ _1472_ VPWR VGND sg13g2_nor3_1
X_4799_ net679 net725 _0134_ VPWR VGND sg13g2_nor2_1
XFILLER_21_79 VPWR VGND sg13g2_decap_8
XFILLER_0_713 VPWR VGND sg13g2_decap_8
XFILLER_47_205 VPWR VGND sg13g2_fill_2
XFILLER_29_931 VPWR VGND sg13g2_decap_8
XFILLER_47_249 VPWR VGND sg13g2_fill_2
XFILLER_46_43 VPWR VGND sg13g2_fill_1
XFILLER_46_21 VPWR VGND sg13g2_decap_8
XFILLER_29_964 VPWR VGND sg13g2_decap_8
XFILLER_46_65 VPWR VGND sg13g2_fill_1
XFILLER_28_474 VPWR VGND sg13g2_fill_1
XFILLER_46_98 VPWR VGND sg13g2_decap_8
XFILLER_16_647 VPWR VGND sg13g2_fill_1
XFILLER_44_978 VPWR VGND sg13g2_decap_8
XFILLER_24_691 VPWR VGND sg13g2_decap_8
XFILLER_7_15 VPWR VGND sg13g2_fill_2
XFILLER_46_293 VPWR VGND sg13g2_decap_4
XFILLER_21_127 VPWR VGND sg13g2_fill_1
X_2983_ videogen.test_lut_thingy.pixel_feeder_inst.row\[2\]\[2\] net785 _0812_ _0446_
+ VPWR VGND sg13g2_mux2_1
X_4722_ net710 net755 _0057_ VPWR VGND sg13g2_nor2_1
XFILLER_30_683 VPWR VGND sg13g2_decap_8
X_4653_ VPWR _0659_ _2241_ VGND sg13g2_inv_1
X_4584_ _2199_ _2196_ _2198_ VPWR VGND sg13g2_xnor2_1
X_3604_ videogen.test_lut_thingy.pixel_feeder_inst.row\[19\]\[2\] net576 _1257_ VPWR
+ VGND sg13g2_nor2_1
X_3535_ _1181_ _1182_ _1168_ _1188_ VPWR VGND sg13g2_nand3_1
X_3466_ _1102_ _1115_ _1118_ _1119_ VPWR VGND sg13g2_or3_1
X_5205_ net426 VGND VPWR _0533_ videogen.test_lut_thingy.pixel_feeder_inst.row\[53\]\[1\]
+ _0162_ sg13g2_dfrbpq_1
X_3397_ _1049_ _1044_ _1050_ VPWR VGND sg13g2_xor2_1
X_5136_ net234 VGND VPWR _0464_ videogen.test_lut_thingy.pixel_feeder_inst.row\[8\]\[0\]
+ _0101_ sg13g2_dfrbpq_1
XFILLER_45_709 VPWR VGND sg13g2_decap_4
X_5067_ net355 VGND VPWR _0399_ videogen.test_lut_thingy.pixel_feeder_inst.row\[16\]\[0\]
+ _0045_ sg13g2_dfrbpq_1
X_4018_ _1659_ _1100_ _1667_ VPWR VGND sg13g2_xor2_1
XFILLER_25_433 VPWR VGND sg13g2_decap_4
XFILLER_26_978 VPWR VGND sg13g2_decap_8
XFILLER_12_116 VPWR VGND sg13g2_fill_1
XFILLER_21_694 VPWR VGND sg13g2_decap_8
XFILLER_4_359 VPWR VGND sg13g2_fill_2
XFILLER_0_510 VPWR VGND sg13g2_decap_8
XFILLER_48_536 VPWR VGND sg13g2_decap_8
X_5261__148 VPWR VGND net148 sg13g2_tiehi
XFILLER_17_956 VPWR VGND sg13g2_decap_8
XFILLER_32_926 VPWR VGND sg13g2_decap_8
XFILLER_32_937 VPWR VGND sg13g2_fill_2
XFILLER_7_131 VPWR VGND sg13g2_fill_1
XFILLER_11_171 VPWR VGND sg13g2_fill_1
X_5194__56 VPWR VGND net56 sg13g2_tiehi
XFILLER_4_860 VPWR VGND sg13g2_decap_8
X_3320_ videogen.fancy_shader.n646\[7\] _0986_ videogen.fancy_shader.n646\[8\] _0990_
+ VPWR VGND sg13g2_nand3_1
X_3251_ _0904_ videogen.test_lut_thingy.pixel_feeder_inst.v_counter\[0\] _0937_ VPWR
+ VGND sg13g2_xor2_1
X_3182_ _0716_ _0839_ _0889_ _0295_ VPWR VGND sg13g2_nor3_1
XFILLER_47_591 VPWR VGND sg13g2_decap_8
XFILLER_23_937 VPWR VGND sg13g2_decap_8
XFILLER_34_274 VPWR VGND sg13g2_fill_1
XFILLER_22_436 VPWR VGND sg13g2_decap_8
XFILLER_22_447 VPWR VGND sg13g2_decap_4
X_2966_ _0774_ _0806_ _0809_ VPWR VGND sg13g2_nor2_2
X_5173__142 VPWR VGND net142 sg13g2_tiehi
XFILLER_33_1003 VPWR VGND sg13g2_decap_8
X_4705_ net712 net759 _0041_ VPWR VGND sg13g2_nor2_1
X_2897_ videogen.test_lut_thingy.pixel_feeder_inst.row\[27\]\[0\] net805 _0792_ _0520_
+ VPWR VGND sg13g2_mux2_1
X_4636_ _2233_ net664 net478 net670 green_tmds_par\[1\] VPWR VGND sg13g2_a22oi_1
X_4567_ _2154_ VPWR _2183_ VGND _0690_ _2153_ sg13g2_o21ai_1
X_5288__273 VPWR VGND net273 sg13g2_tiehi
X_4498_ _2122_ _2119_ _2120_ VPWR VGND sg13g2_xnor2_1
X_3518_ _1171_ _1169_ _1170_ VPWR VGND sg13g2_xnor2_1
X_3449_ VGND VPWR _1100_ _1102_ _1094_ _1092_ sg13g2_a21oi_2
X_5119_ net268 VGND VPWR _0447_ videogen.test_lut_thingy.pixel_feeder_inst.row\[2\]\[3\]
+ _0084_ sg13g2_dfrbpq_1
XFILLER_14_904 VPWR VGND sg13g2_decap_8
XFILLER_43_55 VPWR VGND sg13g2_decap_8
XFILLER_43_99 VPWR VGND sg13g2_decap_8
XFILLER_40_266 VPWR VGND sg13g2_decap_4
XFILLER_5_646 VPWR VGND sg13g2_decap_8
XFILLER_4_101 VPWR VGND sg13g2_fill_2
XFILLER_49_1010 VPWR VGND sg13g2_decap_8
XFILLER_1_874 VPWR VGND sg13g2_decap_8
XFILLER_49_856 VPWR VGND sg13g2_decap_8
XFILLER_48_388 VPWR VGND sg13g2_decap_8
XFILLER_20_907 VPWR VGND sg13g2_decap_8
X_2820_ _0770_ _0774_ _0775_ VPWR VGND sg13g2_nor2_2
XFILLER_13_970 VPWR VGND sg13g2_decap_8
X_2751_ videogen.test_lut_thingy.pixel_feeder_inst.row\[24\]\[3\] net772 _0745_ _0629_
+ VPWR VGND sg13g2_mux2_1
XFILLER_9_974 VPWR VGND sg13g2_decap_8
X_2682_ VPWR _0690_ blue\[1\] VGND sg13g2_inv_1
X_4421_ green\[7\] net615 _2057_ VPWR VGND sg13g2_nor2b_1
X_4352_ _1993_ _1990_ _1992_ _1984_ tmds_red.dc_balancing_reg\[4\] VPWR VGND sg13g2_a22oi_1
X_3303_ _0977_ _0974_ _0976_ VPWR VGND sg13g2_xnor2_1
X_4283_ VGND VPWR _1929_ _1928_ _1926_ sg13g2_or2_1
XFILLER_39_300 VPWR VGND sg13g2_fill_1
X_3234_ _0924_ net641 _0926_ VPWR VGND sg13g2_xor2_1
X_3165_ serialize.tmds_parallel_b\[8\] net667 _0269_ VPWR VGND sg13g2_and2_1
XFILLER_39_399 VPWR VGND sg13g2_fill_2
X_3096_ _0833_ VPWR _0847_ VGND videogen.test_lut_thingy.pixel_feeder_inst.state\[0\]
+ _0846_ sg13g2_o21ai_1
X_3998_ _1254_ VPWR _0364_ VGND _1551_ _1649_ sg13g2_o21ai_1
XFILLER_13_25 VPWR VGND sg13g2_fill_1
X_2949_ net806 videogen.test_lut_thingy.pixel_feeder_inst.row\[7\]\[0\] _0804_ _0472_
+ VPWR VGND sg13g2_mux2_1
XFILLER_22_288 VPWR VGND sg13g2_decap_8
X_4619_ VPWR _0642_ _2224_ VGND sg13g2_inv_1
X_5327__229 VPWR VGND net229 sg13g2_tiehi
X_4969__103 VPWR VGND net103 sg13g2_tiehi
XFILLER_2_649 VPWR VGND sg13g2_fill_2
XFILLER_38_11 VPWR VGND sg13g2_fill_1
XFILLER_45_303 VPWR VGND sg13g2_decap_8
XFILLER_46_848 VPWR VGND sg13g2_decap_8
XFILLER_41_575 VPWR VGND sg13g2_decap_8
XFILLER_13_244 VPWR VGND sg13g2_fill_1
XFILLER_9_237 VPWR VGND sg13g2_decap_8
XFILLER_6_955 VPWR VGND sg13g2_decap_8
XFILLER_10_995 VPWR VGND sg13g2_decap_8
XFILLER_5_498 VPWR VGND sg13g2_decap_8
X_5128__250 VPWR VGND net250 sg13g2_tiehi
XFILLER_49_686 VPWR VGND sg13g2_decap_8
XFILLER_37_859 VPWR VGND sg13g2_fill_1
XFILLER_36_358 VPWR VGND sg13g2_decap_8
XFILLER_45_892 VPWR VGND sg13g2_decap_8
X_4970_ net102 VGND VPWR _0302_ videogen.fancy_shader.video_x\[8\] net649 sg13g2_dfrbpq_2
X_3921_ net608 _1567_ _1572_ _1573_ VPWR VGND sg13g2_nor3_1
X_5059__366 VPWR VGND net366 sg13g2_tiehi
X_3852_ videogen.test_lut_thingy.pixel_feeder_inst.row\[19\]\[3\] net580 _1505_ VPWR
+ VGND sg13g2_nor2_1
X_2803_ videogen.test_lut_thingy.pixel_feeder_inst.row\[3\]\[3\] net774 _0769_ _0591_
+ VPWR VGND sg13g2_mux2_1
XFILLER_30_1006 VPWR VGND sg13g2_decap_8
X_3783_ videogen.test_lut_thingy.pixel_feeder_inst.row\[37\]\[1\] net562 _1436_ VPWR
+ VGND sg13g2_nor2_1
X_2734_ videogen.test_lut_thingy.pixel_feeder_inst.row\[22\]\[3\] net768 _0736_ _0637_
+ VPWR VGND sg13g2_mux2_1
X_2665_ VPWR _0673_ videogen.test_lut_thingy.pixel_feeder_inst.row\[61\]\[0\] VGND
+ sg13g2_inv_1
X_4404_ _2026_ VPWR _2042_ VGND _2020_ _2027_ sg13g2_o21ai_1
X_4335_ _1976_ tmds_red.dc_balancing_reg\[1\] _1974_ VPWR VGND sg13g2_xnor2_1
XFILLER_5_92 VPWR VGND sg13g2_decap_8
X_4266_ VGND VPWR _1892_ _1908_ _1912_ _1885_ sg13g2_a21oi_1
XFILLER_39_141 VPWR VGND sg13g2_decap_4
X_3217_ _0914_ videogen.test_lut_thingy.pixel_feeder_inst.v_pix\[1\] videogen.test_lut_thingy.pixel_feeder_inst.v_pix\[0\]
+ _0905_ VPWR VGND sg13g2_and3_1
X_4197_ _1843_ _1840_ _1841_ _1836_ _1834_ VPWR VGND sg13g2_a22oi_1
XFILLER_28_815 VPWR VGND sg13g2_decap_4
XFILLER_39_174 VPWR VGND sg13g2_fill_2
X_3148_ clk_video _0005_ VPWR VGND sg13g2_inv_2
XFILLER_28_859 VPWR VGND sg13g2_fill_1
XFILLER_39_196 VPWR VGND sg13g2_fill_1
XFILLER_42_328 VPWR VGND sg13g2_decap_8
X_5042__392 VPWR VGND net392 sg13g2_tiehi
X_3079_ videogen.test_lut_thingy.pixel_feeder_inst.row\[1\]\[1\] net796 _0831_ _0272_
+ VPWR VGND sg13g2_mux2_1
XFILLER_23_575 VPWR VGND sg13g2_fill_1
XFILLER_11_737 VPWR VGND sg13g2_decap_8
XFILLER_6_218 VPWR VGND sg13g2_decap_8
XFILLER_40_78 VPWR VGND sg13g2_fill_1
XFILLER_3_925 VPWR VGND sg13g2_decap_8
XFILLER_49_21 VPWR VGND sg13g2_decap_8
XFILLER_46_1002 VPWR VGND sg13g2_decap_8
XFILLER_6_4 VPWR VGND sg13g2_decap_4
Xfanout750 net751 net750 VPWR VGND sg13g2_buf_8
XFILLER_1_28 VPWR VGND sg13g2_decap_8
Xfanout794 net795 net794 VPWR VGND sg13g2_buf_8
Xfanout772 net777 net772 VPWR VGND sg13g2_buf_8
Xfanout783 net788 net783 VPWR VGND sg13g2_buf_8
Xfanout761 clockdiv.q1 net761 VPWR VGND sg13g2_buf_8
XFILLER_46_645 VPWR VGND sg13g2_decap_8
XFILLER_18_347 VPWR VGND sg13g2_fill_2
XFILLER_18_358 VPWR VGND sg13g2_decap_8
XFILLER_18_369 VPWR VGND sg13g2_fill_2
XFILLER_41_394 VPWR VGND sg13g2_fill_1
XFILLER_6_741 VPWR VGND sg13g2_decap_4
XFILLER_6_774 VPWR VGND sg13g2_decap_4
X_4120_ _1766_ _0982_ _1049_ VPWR VGND sg13g2_xnor2_1
X_4051_ _1700_ _1684_ _1695_ VPWR VGND sg13g2_xnor2_1
XFILLER_49_483 VPWR VGND sg13g2_decap_8
XFILLER_49_461 VPWR VGND sg13g2_decap_8
X_3002_ videogen.test_lut_thingy.pixel_feeder_inst.row\[9\]\[3\] net776 _0816_ _0431_
+ VPWR VGND sg13g2_mux2_1
XFILLER_36_100 VPWR VGND sg13g2_decap_8
X_4953_ net127 VGND VPWR _0285_ serialize.bit_cnt\[1\] clknet_3_1_0_clk_regs sg13g2_dfrbpq_1
XFILLER_33_840 VPWR VGND sg13g2_decap_8
X_3904_ _1552_ _1553_ _1554_ _1555_ _1556_ VPWR VGND sg13g2_nor4_1
X_4884_ net712 net759 _0219_ VPWR VGND sg13g2_nor2_1
X_3835_ videogen.test_lut_thingy.pixel_feeder_inst.row\[58\]\[3\] net582 _1488_ VPWR
+ VGND sg13g2_nor2_1
XFILLER_20_567 VPWR VGND sg13g2_decap_8
X_3766_ videogen.test_lut_thingy.pixel_feeder_inst.row\[57\]\[1\] net561 _1419_ VPWR
+ VGND sg13g2_nor2_1
X_2717_ _0724_ _0705_ VPWR VGND net554 sg13g2_nand2b_2
X_3697_ _1302_ _1349_ net2 _1350_ VPWR VGND sg13g2_nand3_1
X_5298_ net233 VGND VPWR _0626_ videogen.test_lut_thingy.pixel_feeder_inst.row\[24\]\[0\]
+ _0245_ sg13g2_dfrbpq_1
X_4966__106 VPWR VGND net106 sg13g2_tiehi
X_4318_ _1959_ red\[0\] _1958_ VPWR VGND sg13g2_nand2b_1
X_5224__311 VPWR VGND net311 sg13g2_tiehi
X_4249_ _1893_ _1894_ _1895_ VPWR VGND sg13g2_nor2_1
XFILLER_19_57 VPWR VGND sg13g2_fill_1
XFILLER_28_667 VPWR VGND sg13g2_decap_8
XFILLER_27_155 VPWR VGND sg13g2_decap_8
X_5257__175 VPWR VGND net175 sg13g2_tiehi
XFILLER_24_851 VPWR VGND sg13g2_decap_8
XFILLER_11_512 VPWR VGND sg13g2_decap_8
XFILLER_13_1012 VPWR VGND sg13g2_decap_8
XFILLER_3_722 VPWR VGND sg13g2_fill_1
XFILLER_2_221 VPWR VGND sg13g2_fill_1
XFILLER_2_298 VPWR VGND sg13g2_fill_1
XFILLER_18_9 VPWR VGND sg13g2_decap_8
Xfanout591 net592 net591 VPWR VGND sg13g2_buf_8
Xfanout580 net581 net580 VPWR VGND sg13g2_buf_8
XFILLER_47_965 VPWR VGND sg13g2_decap_8
XFILLER_20_1005 VPWR VGND sg13g2_decap_8
XFILLER_18_144 VPWR VGND sg13g2_decap_8
XFILLER_34_626 VPWR VGND sg13g2_fill_2
XFILLER_15_873 VPWR VGND sg13g2_fill_2
XFILLER_33_158 VPWR VGND sg13g2_fill_1
X_3620_ videogen.test_lut_thingy.pixel_feeder_inst.row\[23\]\[2\] net572 _1273_ VPWR
+ VGND sg13g2_nor2_1
XFILLER_30_876 VPWR VGND sg13g2_fill_2
X_3551_ _1199_ _1203_ _1204_ VPWR VGND sg13g2_nor2_1
X_3482_ VGND VPWR _1134_ _1135_ _1132_ _1129_ sg13g2_a21oi_2
X_5221_ net332 VGND VPWR _0549_ videogen.test_lut_thingy.pixel_feeder_inst.row\[4\]\[1\]
+ _0178_ sg13g2_dfrbpq_1
X_5152_ net202 VGND VPWR _0480_ videogen.test_lut_thingy.pixel_feeder_inst.row\[60\]\[0\]
+ _0117_ sg13g2_dfrbpq_1
X_4103_ _1450_ _1547_ _1750_ VPWR VGND sg13g2_nor2_1
X_5083_ net188 VGND VPWR _0002_ videogen.test_lut_thingy.pixel_feeder_inst.state\[0\]
+ net646 sg13g2_dfrbpq_1
X_4034_ _1683_ _1040_ _1658_ VPWR VGND sg13g2_xnor2_1
XFILLER_37_497 VPWR VGND sg13g2_decap_8
XFILLER_25_659 VPWR VGND sg13g2_decap_8
X_4936_ net152 VGND VPWR _0268_ serialize.shift_reg_g\[9\] clknet_3_6_0_clk_regs sg13g2_dfrbpq_1
X_4867_ net687 net732 _0202_ VPWR VGND sg13g2_nor2_1
X_3818_ _1467_ _1468_ _1469_ _1470_ _1471_ VPWR VGND sg13g2_nor4_1
XFILLER_21_887 VPWR VGND sg13g2_decap_8
X_4798_ net679 net725 _0133_ VPWR VGND sg13g2_nor2_1
X_3749_ videogen.test_lut_thingy.pixel_feeder_inst.row\[55\]\[1\] net579 _1402_ VPWR
+ VGND sg13g2_nor2_1
XFILLER_0_769 VPWR VGND sg13g2_decap_8
XFILLER_28_420 VPWR VGND sg13g2_decap_8
XFILLER_28_431 VPWR VGND sg13g2_fill_2
XFILLER_44_957 VPWR VGND sg13g2_decap_8
XFILLER_15_103 VPWR VGND sg13g2_fill_1
XFILLER_30_128 VPWR VGND sg13g2_decap_4
XFILLER_8_869 VPWR VGND sg13g2_decap_8
XFILLER_3_596 VPWR VGND sg13g2_decap_8
XFILLER_4_1021 VPWR VGND sg13g2_decap_8
XFILLER_19_420 VPWR VGND sg13g2_decap_8
XFILLER_34_423 VPWR VGND sg13g2_decap_8
XFILLER_34_456 VPWR VGND sg13g2_fill_2
XFILLER_34_467 VPWR VGND sg13g2_decap_8
X_2982_ videogen.test_lut_thingy.pixel_feeder_inst.row\[2\]\[3\] net774 _0812_ _0447_
+ VPWR VGND sg13g2_mux2_1
X_4721_ net710 net757 _0056_ VPWR VGND sg13g2_nor2_1
X_4652_ _2241_ net664 net479 net669 red_tmds_par\[1\] VPWR VGND sg13g2_a22oi_1
X_3603_ videogen.test_lut_thingy.pixel_feeder_inst.row\[17\]\[2\] net566 _1256_ VPWR
+ VGND sg13g2_nor2_1
X_5214__365 VPWR VGND net365 sg13g2_tiehi
X_4583_ _2197_ tmds_blue.dc_balancing_reg\[4\] _2198_ VPWR VGND sg13g2_xor2_1
XFILLER_7_891 VPWR VGND sg13g2_decap_8
X_3534_ _1187_ _1158_ _1186_ VPWR VGND sg13g2_xnor2_1
X_3465_ _1118_ _1051_ net553 VPWR VGND sg13g2_nand2_1
X_5204_ net430 VGND VPWR _0532_ videogen.test_lut_thingy.pixel_feeder_inst.row\[53\]\[0\]
+ _0161_ sg13g2_dfrbpq_1
X_3396_ _1048_ _1047_ _1049_ VPWR VGND sg13g2_xor2_1
X_5135_ net236 VGND VPWR _0463_ videogen.test_lut_thingy.pixel_feeder_inst.row\[0\]\[3\]
+ _0100_ sg13g2_dfrbpq_1
X_4963__109 VPWR VGND net109 sg13g2_tiehi
XFILLER_29_217 VPWR VGND sg13g2_fill_1
X_5066_ net356 VGND VPWR _0398_ red_tmds_par\[7\] net658 sg13g2_dfrbpq_1
X_4017_ _1665_ _1107_ _1666_ VPWR VGND sg13g2_xor2_1
XFILLER_26_957 VPWR VGND sg13g2_decap_8
XFILLER_25_489 VPWR VGND sg13g2_decap_4
X_4919_ net678 net723 _0252_ VPWR VGND sg13g2_nor2_1
XFILLER_5_828 VPWR VGND sg13g2_decap_8
XFILLER_48_515 VPWR VGND sg13g2_decap_8
XFILLER_0_566 VPWR VGND sg13g2_decap_8
XFILLER_28_250 VPWR VGND sg13g2_decap_8
XFILLER_44_721 VPWR VGND sg13g2_decap_4
XFILLER_17_935 VPWR VGND sg13g2_decap_8
XFILLER_29_784 VPWR VGND sg13g2_decap_8
XFILLER_8_688 VPWR VGND sg13g2_fill_1
X_3250_ VGND VPWR _0936_ _0909_ _0907_ sg13g2_or2_1
X_3181_ videogen.fancy_shader.video_x\[0\] _0889_ _0294_ VPWR VGND sg13g2_nor2_1
XFILLER_21_4 VPWR VGND sg13g2_fill_1
XFILLER_47_570 VPWR VGND sg13g2_decap_8
XFILLER_19_272 VPWR VGND sg13g2_decap_4
XFILLER_23_916 VPWR VGND sg13g2_decap_8
XFILLER_34_253 VPWR VGND sg13g2_decap_8
X_5138__230 VPWR VGND net230 sg13g2_tiehi
XFILLER_34_297 VPWR VGND sg13g2_fill_2
X_4704_ net711 net751 _0040_ VPWR VGND sg13g2_nor2_1
X_2965_ videogen.test_lut_thingy.pixel_feeder_inst.row\[0\]\[0\] net808 _0808_ _0460_
+ VPWR VGND sg13g2_mux2_1
X_2896_ videogen.test_lut_thingy.pixel_feeder_inst.row\[27\]\[1\] net794 _0792_ _0521_
+ VPWR VGND sg13g2_mux2_1
X_4635_ VPWR _0650_ _2232_ VGND sg13g2_inv_1
X_4566_ VGND VPWR _2156_ _2163_ _2182_ _2165_ sg13g2_a21oi_1
X_3517_ _1170_ _0962_ _0964_ VPWR VGND sg13g2_xnor2_1
X_4497_ _2121_ _2119_ _2120_ VPWR VGND sg13g2_nand2b_1
X_3448_ _1101_ _1100_ VPWR VGND sg13g2_inv_2
X_3379_ _1031_ _1025_ _1032_ VPWR VGND sg13g2_nor2b_1
XFILLER_40_1019 VPWR VGND sg13g2_decap_8
X_5118_ net270 VGND VPWR _0446_ videogen.test_lut_thingy.pixel_feeder_inst.row\[2\]\[2\]
+ _0083_ sg13g2_dfrbpq_1
X_5049_ net383 VGND VPWR _0381_ videogen.test_lut_thingy.pixel_feeder_inst.row\[33\]\[2\]
+ _0035_ sg13g2_dfrbpq_1
XFILLER_27_68 VPWR VGND sg13g2_fill_1
X_5295__245 VPWR VGND net245 sg13g2_tiehi
XFILLER_13_404 VPWR VGND sg13g2_decap_4
XFILLER_40_234 VPWR VGND sg13g2_decap_8
XFILLER_43_78 VPWR VGND sg13g2_fill_1
XFILLER_40_245 VPWR VGND sg13g2_fill_1
XFILLER_21_470 VPWR VGND sg13g2_decap_8
XFILLER_21_481 VPWR VGND sg13g2_fill_1
XFILLER_22_982 VPWR VGND sg13g2_decap_8
XFILLER_5_603 VPWR VGND sg13g2_decap_8
XFILLER_5_636 VPWR VGND sg13g2_decap_4
XFILLER_4_39 VPWR VGND sg13g2_fill_2
XFILLER_1_853 VPWR VGND sg13g2_decap_8
XFILLER_49_835 VPWR VGND sg13g2_decap_8
XFILLER_17_732 VPWR VGND sg13g2_fill_1
XFILLER_29_592 VPWR VGND sg13g2_decap_4
XFILLER_16_275 VPWR VGND sg13g2_fill_2
XFILLER_17_776 VPWR VGND sg13g2_fill_1
XFILLER_32_713 VPWR VGND sg13g2_fill_1
XFILLER_32_724 VPWR VGND sg13g2_fill_1
XFILLER_9_953 VPWR VGND sg13g2_decap_8
XFILLER_12_470 VPWR VGND sg13g2_decap_8
X_2750_ _0743_ _0744_ _0745_ VPWR VGND sg13g2_nor2_2
XFILLER_31_289 VPWR VGND sg13g2_decap_8
X_2681_ VPWR _0689_ tmds_green.dc_balancing_reg\[4\] VGND sg13g2_inv_1
X_4420_ net605 _2055_ _2056_ VPWR VGND sg13g2_and2_1
X_4351_ tmds_red.dc_balancing_reg\[4\] _1984_ _1991_ _1992_ VPWR VGND sg13g2_nor3_1
X_3302_ _0976_ videogen.fancy_shader.n646\[4\] videogen.fancy_shader.video_x\[4\]
+ VPWR VGND sg13g2_xnor2_1
X_4282_ _1919_ _1927_ _1928_ VPWR VGND sg13g2_nor2_1
X_3233_ VPWR _0925_ _0924_ VGND sg13g2_inv_1
X_3164_ green_tmds_par\[9\] net671 _0268_ VPWR VGND sg13g2_and2_1
XFILLER_12_0 VPWR VGND sg13g2_fill_1
XFILLER_39_378 VPWR VGND sg13g2_fill_2
X_3095_ _0846_ _0844_ _0845_ _0838_ _0834_ VPWR VGND sg13g2_a22oi_1
XFILLER_11_919 VPWR VGND sg13g2_decap_8
X_3997_ _1646_ _1648_ _1649_ VPWR VGND sg13g2_nor2_1
X_2948_ net795 videogen.test_lut_thingy.pixel_feeder_inst.row\[7\]\[1\] _0804_ _0473_
+ VPWR VGND sg13g2_mux2_1
X_2879_ videogen.test_lut_thingy.pixel_feeder_inst.row\[53\]\[3\] net775 _0789_ _0535_
+ VPWR VGND sg13g2_mux2_1
X_4618_ _2224_ net663 net463 net668 blue_tmds_par\[0\] VPWR VGND sg13g2_a22oi_1
XFILLER_2_606 VPWR VGND sg13g2_fill_2
XFILLER_1_105 VPWR VGND sg13g2_decap_8
X_4549_ _2166_ _2145_ _2164_ VPWR VGND sg13g2_xnor2_1
XFILLER_38_23 VPWR VGND sg13g2_decap_8
XFILLER_46_827 VPWR VGND sg13g2_decap_8
XFILLER_45_337 VPWR VGND sg13g2_decap_8
XFILLER_26_595 VPWR VGND sg13g2_decap_4
XFILLER_14_768 VPWR VGND sg13g2_decap_8
XFILLER_6_934 VPWR VGND sg13g2_decap_8
XFILLER_10_974 VPWR VGND sg13g2_decap_8
X_5015__429 VPWR VGND net429 sg13g2_tiehi
XFILLER_5_444 VPWR VGND sg13g2_decap_8
XFILLER_1_683 VPWR VGND sg13g2_decap_8
XFILLER_23_1014 VPWR VGND sg13g2_decap_8
XFILLER_49_665 VPWR VGND sg13g2_decap_8
XFILLER_0_182 VPWR VGND sg13g2_decap_8
X_3920_ _1568_ _1569_ _1570_ _1571_ _1572_ VPWR VGND sg13g2_nor4_1
XFILLER_44_392 VPWR VGND sg13g2_decap_8
X_3851_ videogen.test_lut_thingy.pixel_feeder_inst.row\[18\]\[3\] net587 _1504_ VPWR
+ VGND sg13g2_nor2_1
XFILLER_20_738 VPWR VGND sg13g2_fill_2
X_2802_ _0765_ _0768_ _0769_ VPWR VGND sg13g2_nor2_2
XFILLER_32_598 VPWR VGND sg13g2_decap_4
X_3782_ videogen.test_lut_thingy.pixel_feeder_inst.row\[38\]\[1\] net584 _1435_ VPWR
+ VGND sg13g2_nor2_1
X_2733_ _0729_ _0735_ _0736_ VPWR VGND sg13g2_nor2_2
X_2664_ VPWR _0672_ videogen.test_lut_thingy.pixel_feeder_inst.row\[61\]\[2\] VGND
+ sg13g2_inv_1
X_4403_ VGND VPWR _2031_ _2041_ _0377_ net558 sg13g2_a21oi_1
XFILLER_5_71 VPWR VGND sg13g2_decap_8
X_4334_ tmds_red.dc_balancing_reg\[1\] _1974_ _1975_ VPWR VGND sg13g2_nor2_1
X_4265_ _1911_ _1885_ _1892_ _1908_ VPWR VGND sg13g2_and3_1
X_3216_ VGND VPWR videogen.test_lut_thingy.pixel_feeder_inst.v_pix\[0\] _0907_ _0913_
+ videogen.test_lut_thingy.pixel_feeder_inst.v_pix\[1\] sg13g2_a21oi_1
X_4196_ _1842_ _1840_ _1841_ VPWR VGND sg13g2_nand2_1
X_3147_ net713 net755 _0005_ VPWR VGND sg13g2_nor2_2
XFILLER_42_307 VPWR VGND sg13g2_decap_8
XFILLER_39_1021 VPWR VGND sg13g2_decap_8
X_3078_ videogen.test_lut_thingy.pixel_feeder_inst.row\[1\]\[2\] net785 _0831_ _0273_
+ VPWR VGND sg13g2_mux2_1
XFILLER_36_893 VPWR VGND sg13g2_fill_2
XFILLER_11_727 VPWR VGND sg13g2_fill_2
XFILLER_24_69 VPWR VGND sg13g2_decap_8
X_5000__45 VPWR VGND net45 sg13g2_tiehi
XFILLER_40_46 VPWR VGND sg13g2_decap_4
XFILLER_3_904 VPWR VGND sg13g2_decap_8
XFILLER_49_88 VPWR VGND sg13g2_fill_1
XFILLER_49_77 VPWR VGND sg13g2_decap_8
Xfanout740 net743 net740 VPWR VGND sg13g2_buf_8
Xfanout751 net754 net751 VPWR VGND sg13g2_buf_8
Xfanout762 net763 net762 VPWR VGND sg13g2_buf_8
Xfanout773 net777 net773 VPWR VGND sg13g2_buf_2
Xfanout784 net788 net784 VPWR VGND sg13g2_buf_8
XFILLER_46_624 VPWR VGND sg13g2_decap_8
XFILLER_18_304 VPWR VGND sg13g2_decap_8
Xfanout795 net799 net795 VPWR VGND sg13g2_buf_8
XFILLER_45_123 VPWR VGND sg13g2_fill_1
XFILLER_45_178 VPWR VGND sg13g2_decap_8
XFILLER_33_318 VPWR VGND sg13g2_fill_2
XFILLER_14_532 VPWR VGND sg13g2_decap_8
XFILLER_42_863 VPWR VGND sg13g2_fill_1
XFILLER_14_543 VPWR VGND sg13g2_fill_2
XFILLER_14_587 VPWR VGND sg13g2_fill_2
XFILLER_10_771 VPWR VGND sg13g2_decap_4
XFILLER_2_981 VPWR VGND sg13g2_decap_8
XFILLER_49_440 VPWR VGND sg13g2_decap_8
X_4050_ VPWR _1699_ _1698_ VGND sg13g2_inv_1
X_3001_ _0751_ _0806_ _0816_ VPWR VGND sg13g2_nor2_2
XFILLER_45_690 VPWR VGND sg13g2_fill_2
X_4952_ net128 VGND VPWR net451 serialize.bit_cnt\[0\] clknet_3_1_0_clk_regs sg13g2_dfrbpq_1
X_3903_ videogen.test_lut_thingy.pixel_feeder_inst.row\[8\]\[0\] net601 _1555_ VPWR
+ VGND sg13g2_nor2_1
X_4883_ net711 net757 _0218_ VPWR VGND sg13g2_nor2_1
XFILLER_32_340 VPWR VGND sg13g2_decap_8
X_3834_ videogen.test_lut_thingy.pixel_feeder_inst.row\[56\]\[3\] net593 _1487_ VPWR
+ VGND sg13g2_nor2_1
X_3765_ videogen.test_lut_thingy.pixel_feeder_inst.row\[56\]\[1\] net597 _1418_ VPWR
+ VGND sg13g2_nor2_1
X_2716_ _0721_ _0722_ _0713_ _0723_ VPWR VGND sg13g2_nand3_1
X_3696_ _1348_ VPWR _1349_ VGND _1313_ _1324_ sg13g2_o21ai_1
X_4317_ _1955_ red\[7\] _1958_ VPWR VGND sg13g2_xor2_1
X_5297_ net237 VGND VPWR net493 serialize.bit_cnt\[2\] clknet_3_1_0_clk_regs sg13g2_dfrbpq_2
X_4248_ _1890_ _1886_ _1894_ VPWR VGND sg13g2_nor2b_1
XFILLER_19_69 VPWR VGND sg13g2_decap_8
XFILLER_27_101 VPWR VGND sg13g2_fill_1
X_4179_ _1825_ _1816_ _1824_ VPWR VGND sg13g2_xnor2_1
XFILLER_27_112 VPWR VGND sg13g2_fill_1
XFILLER_27_123 VPWR VGND sg13g2_fill_2
XFILLER_43_616 VPWR VGND sg13g2_fill_2
X_5177__119 VPWR VGND net119 sg13g2_tiehi
XFILLER_11_557 VPWR VGND sg13g2_decap_8
XFILLER_11_579 VPWR VGND sg13g2_fill_2
XFILLER_2_244 VPWR VGND sg13g2_fill_2
Xfanout592 _0731_ net592 VPWR VGND sg13g2_buf_8
Xfanout581 _0734_ net581 VPWR VGND sg13g2_buf_8
Xfanout570 _0739_ net570 VPWR VGND sg13g2_buf_8
XFILLER_47_944 VPWR VGND sg13g2_decap_8
XFILLER_18_101 VPWR VGND sg13g2_fill_2
XFILLER_19_646 VPWR VGND sg13g2_decap_4
XFILLER_20_1028 VPWR VGND sg13g2_fill_1
XFILLER_18_178 VPWR VGND sg13g2_decap_8
XFILLER_14_373 VPWR VGND sg13g2_fill_1
X_3550_ VPWR VGND _1201_ _1051_ _1200_ _1102_ _1203_ _1120_ sg13g2_a221oi_1
X_3481_ _1123_ _1119_ _1133_ _1134_ VPWR VGND sg13g2_a21o_1
X_5220_ net336 VGND VPWR _0548_ videogen.test_lut_thingy.pixel_feeder_inst.row\[4\]\[0\]
+ _0177_ sg13g2_dfrbpq_1
XFILLER_29_1020 VPWR VGND sg13g2_decap_8
X_5151_ net204 VGND VPWR _0479_ videogen.test_lut_thingy.pixel_feeder_inst.row\[61\]\[3\]
+ _0116_ sg13g2_dfrbpq_1
X_5028__406 VPWR VGND net406 sg13g2_tiehi
X_5082_ net187 VGND VPWR _0414_ videogen.test_lut_thingy.pixel_feeder_inst.row\[13\]\[3\]
+ _0060_ sg13g2_dfrbpq_1
X_4102_ _1747_ _1749_ _1744_ _0367_ VPWR VGND sg13g2_nand3_1
X_4033_ _1681_ _1662_ _1682_ VPWR VGND sg13g2_xor2_1
XFILLER_49_281 VPWR VGND sg13g2_decap_8
XFILLER_2_83 VPWR VGND sg13g2_decap_8
XFILLER_38_999 VPWR VGND sg13g2_decap_8
XFILLER_38_977 VPWR VGND sg13g2_fill_2
XFILLER_18_690 VPWR VGND sg13g2_decap_8
XFILLER_24_104 VPWR VGND sg13g2_fill_2
XFILLER_24_148 VPWR VGND sg13g2_fill_1
X_4935_ net153 VGND VPWR _0267_ serialize.shift_reg_g\[8\] clknet_3_6_0_clk_regs sg13g2_dfrbpq_1
XFILLER_21_811 VPWR VGND sg13g2_fill_1
X_4866_ net692 net736 _0201_ VPWR VGND sg13g2_nor2_1
XFILLER_20_321 VPWR VGND sg13g2_decap_8
XFILLER_21_844 VPWR VGND sg13g2_decap_8
X_3817_ videogen.test_lut_thingy.pixel_feeder_inst.row\[40\]\[3\] net596 _1470_ VPWR
+ VGND sg13g2_nor2_1
X_4797_ net680 net724 _0132_ VPWR VGND sg13g2_nor2_1
X_4972__100 VPWR VGND net100 sg13g2_tiehi
X_3748_ videogen.test_lut_thingy.pixel_feeder_inst.row\[54\]\[1\] net590 _1401_ VPWR
+ VGND sg13g2_nor2_1
XFILLER_21_48 VPWR VGND sg13g2_fill_2
X_3679_ videogen.test_lut_thingy.pixel_feeder_inst.row\[37\]\[2\] net562 _1332_ VPWR
+ VGND sg13g2_nor2_1
X_5148__210 VPWR VGND net210 sg13g2_tiehi
XFILLER_43_1028 VPWR VGND sg13g2_fill_1
XFILLER_0_748 VPWR VGND sg13g2_decap_8
XFILLER_47_207 VPWR VGND sg13g2_fill_1
XFILLER_29_911 VPWR VGND sg13g2_fill_2
XFILLER_44_903 VPWR VGND sg13g2_fill_1
XFILLER_29_999 VPWR VGND sg13g2_decap_8
XFILLER_44_936 VPWR VGND sg13g2_decap_8
XFILLER_43_435 VPWR VGND sg13g2_decap_4
XFILLER_15_126 VPWR VGND sg13g2_fill_2
XFILLER_16_638 VPWR VGND sg13g2_fill_1
XFILLER_15_137 VPWR VGND sg13g2_fill_2
XFILLER_30_107 VPWR VGND sg13g2_decap_4
XFILLER_11_310 VPWR VGND sg13g2_decap_4
XFILLER_12_833 VPWR VGND sg13g2_decap_8
XFILLER_11_343 VPWR VGND sg13g2_decap_8
XFILLER_12_877 VPWR VGND sg13g2_fill_2
XFILLER_7_39 VPWR VGND sg13g2_decap_8
XFILLER_11_387 VPWR VGND sg13g2_decap_8
XFILLER_3_564 VPWR VGND sg13g2_decap_8
XFILLER_11_81 VPWR VGND sg13g2_decap_8
XFILLER_3_575 VPWR VGND sg13g2_fill_1
XFILLER_30_9 VPWR VGND sg13g2_fill_2
XFILLER_4_1000 VPWR VGND sg13g2_decap_8
XFILLER_46_262 VPWR VGND sg13g2_fill_2
XFILLER_19_498 VPWR VGND sg13g2_decap_4
XFILLER_34_435 VPWR VGND sg13g2_fill_2
X_2981_ _0768_ _0774_ _0812_ VPWR VGND sg13g2_nor2_2
X_4720_ net711 net746 _0055_ VPWR VGND sg13g2_nor2_1
X_5197__44 VPWR VGND net44 sg13g2_tiehi
X_4651_ VPWR _0658_ _2240_ VGND sg13g2_inv_1
X_3602_ net610 VPWR _1255_ VGND videogen.test_lut_thingy.pixel_feeder_inst.row\[18\]\[2\]
+ net587 sg13g2_o21ai_1
XFILLER_7_870 VPWR VGND sg13g2_decap_8
X_4582_ _2197_ _2151_ _2175_ VPWR VGND sg13g2_nand2_1
X_3533_ _1167_ VPWR _1186_ VGND _1173_ _1179_ sg13g2_o21ai_1
XFILLER_42_0 VPWR VGND sg13g2_decap_4
X_3464_ VPWR _1117_ _1116_ VGND sg13g2_inv_1
X_5203_ net434 VGND VPWR _0531_ videogen.test_lut_thingy.pixel_feeder_inst.row\[25\]\[3\]
+ _0160_ sg13g2_dfrbpq_1
X_5134_ net238 VGND VPWR _0462_ videogen.test_lut_thingy.pixel_feeder_inst.row\[0\]\[2\]
+ _0099_ sg13g2_dfrbpq_1
X_3395_ _0975_ VPWR _1048_ VGND _0973_ _0976_ sg13g2_o21ai_1
Xclkbuf_3_2_0_clk_regs clknet_0_clk_regs clknet_3_2_0_clk_regs VPWR VGND sg13g2_buf_8
X_5065_ net357 VGND VPWR _0397_ red_tmds_par\[5\] net659 sg13g2_dfrbpq_1
X_4016_ _1062_ _1099_ _1658_ _1665_ VPWR VGND sg13g2_nor3_1
XFILLER_41_928 VPWR VGND sg13g2_decap_8
XFILLER_13_619 VPWR VGND sg13g2_decap_8
X_4918_ net678 net723 _0251_ VPWR VGND sg13g2_nor2_1
XFILLER_34_991 VPWR VGND sg13g2_decap_8
X_4849_ net708 net753 _0184_ VPWR VGND sg13g2_nor2_1
XFILLER_10_1016 VPWR VGND sg13g2_decap_8
XFILLER_10_1027 VPWR VGND sg13g2_fill_2
XFILLER_0_545 VPWR VGND sg13g2_decap_8
XFILLER_17_914 VPWR VGND sg13g2_decap_8
XFILLER_16_402 VPWR VGND sg13g2_decap_4
XFILLER_43_243 VPWR VGND sg13g2_fill_2
XFILLER_43_265 VPWR VGND sg13g2_decap_8
XFILLER_43_298 VPWR VGND sg13g2_fill_2
XFILLER_24_490 VPWR VGND sg13g2_decap_8
XFILLER_31_427 VPWR VGND sg13g2_decap_8
XFILLER_31_449 VPWR VGND sg13g2_decap_8
XFILLER_11_162 VPWR VGND sg13g2_decap_8
XFILLER_8_667 VPWR VGND sg13g2_fill_2
XFILLER_4_895 VPWR VGND sg13g2_decap_8
X_3180_ _0889_ net810 _0888_ VPWR VGND sg13g2_nand2_2
X_5025__409 VPWR VGND net409 sg13g2_tiehi
X_4962__110 VPWR VGND net110 sg13g2_tiehi
XFILLER_19_295 VPWR VGND sg13g2_decap_4
XFILLER_22_416 VPWR VGND sg13g2_fill_2
XFILLER_16_991 VPWR VGND sg13g2_decap_8
XFILLER_22_427 VPWR VGND sg13g2_decap_4
X_2964_ videogen.test_lut_thingy.pixel_feeder_inst.row\[0\]\[1\] net796 _0808_ _0461_
+ VPWR VGND sg13g2_mux2_1
X_4703_ net711 net757 _0039_ VPWR VGND sg13g2_nor2_1
X_2895_ videogen.test_lut_thingy.pixel_feeder_inst.row\[27\]\[2\] net783 _0792_ _0522_
+ VPWR VGND sg13g2_mux2_1
XFILLER_31_983 VPWR VGND sg13g2_decap_8
X_4634_ _2232_ net664 net480 net669 green_tmds_par\[0\] VPWR VGND sg13g2_a22oi_1
X_4565_ _2142_ _2180_ _2181_ VPWR VGND sg13g2_nor2_1
X_3516_ _1023_ _1022_ _1169_ VPWR VGND sg13g2_xor2_1
X_4496_ _2093_ VPWR _2120_ VGND _2076_ _2092_ sg13g2_o21ai_1
X_3447_ _1100_ _1097_ _1099_ VPWR VGND sg13g2_xnor2_1
X_3378_ videogen.fancy_shader.video_y\[3\] videogen.fancy_shader.n646\[3\] _1031_
+ VPWR VGND sg13g2_nor2_1
X_5117_ net272 VGND VPWR _0445_ videogen.test_lut_thingy.pixel_feeder_inst.row\[2\]\[1\]
+ _0082_ sg13g2_dfrbpq_1
XFILLER_45_519 VPWR VGND sg13g2_fill_2
X_5048_ net385 VGND VPWR _0380_ videogen.test_lut_thingy.pixel_feeder_inst.row\[33\]\[1\]
+ _0034_ sg13g2_dfrbpq_1
X_4999__47 VPWR VGND net47 sg13g2_tiehi
XFILLER_27_47 VPWR VGND sg13g2_fill_2
XFILLER_14_939 VPWR VGND sg13g2_decap_8
XFILLER_26_788 VPWR VGND sg13g2_decap_8
XFILLER_26_799 VPWR VGND sg13g2_fill_2
XFILLER_22_961 VPWR VGND sg13g2_decap_8
XFILLER_5_626 VPWR VGND sg13g2_fill_2
XFILLER_4_18 VPWR VGND sg13g2_decap_8
XFILLER_1_832 VPWR VGND sg13g2_decap_8
XFILLER_49_814 VPWR VGND sg13g2_decap_8
XFILLER_0_397 VPWR VGND sg13g2_fill_2
XFILLER_48_368 VPWR VGND sg13g2_decap_4
XFILLER_1_1014 VPWR VGND sg13g2_decap_8
XFILLER_16_243 VPWR VGND sg13g2_decap_8
XFILLER_44_585 VPWR VGND sg13g2_decap_8
XFILLER_31_235 VPWR VGND sg13g2_fill_1
XFILLER_31_268 VPWR VGND sg13g2_decap_8
XFILLER_9_932 VPWR VGND sg13g2_decap_8
X_2680_ VPWR _0688_ tmds_green.dc_balancing_reg\[3\] VGND sg13g2_inv_1
XFILLER_33_90 VPWR VGND sg13g2_decap_8
X_4350_ tmds_red.dc_balancing_reg\[3\] tmds_red.dc_balancing_reg\[2\] tmds_red.dc_balancing_reg\[1\]
+ _1991_ VPWR VGND sg13g2_nor3_1
X_3301_ _0975_ videogen.fancy_shader.n646\[4\] videogen.fancy_shader.video_x\[4\]
+ VPWR VGND sg13g2_nand2_1
X_5190__72 VPWR VGND net72 sg13g2_tiehi
X_4281_ VGND VPWR _1858_ _1914_ _1927_ _1906_ sg13g2_a21oi_1
X_3232_ _0833_ _0923_ videogen.test_lut_thingy.pixel_feeder_inst.h_counter\[3\] _0924_
+ VPWR VGND sg13g2_nand3_1
X_5322__309 VPWR VGND net309 sg13g2_tiehi
XFILLER_39_335 VPWR VGND sg13g2_decap_8
X_3163_ green_tmds_par\[8\] _0669_ _0267_ VPWR VGND sg13g2_and2_1
XFILLER_48_880 VPWR VGND sg13g2_decap_8
X_3094_ _0687_ _0713_ _0845_ VPWR VGND sg13g2_and2_1
X_5105__296 VPWR VGND net296 sg13g2_tiehi
XFILLER_23_703 VPWR VGND sg13g2_decap_8
XFILLER_22_213 VPWR VGND sg13g2_fill_2
XFILLER_22_246 VPWR VGND sg13g2_decap_4
X_3996_ _1648_ _1351_ _1449_ VPWR VGND sg13g2_nand2_1
X_2947_ net784 videogen.test_lut_thingy.pixel_feeder_inst.row\[7\]\[2\] _0804_ _0474_
+ VPWR VGND sg13g2_mux2_1
X_4617_ _2223_ VPWR _0625_ VGND net492 _0884_ sg13g2_o21ai_1
X_2878_ _0749_ _0759_ _0789_ VPWR VGND sg13g2_nor2_2
X_4548_ _2145_ _2164_ _2165_ VPWR VGND sg13g2_and2_1
X_4479_ green\[6\] net615 _2103_ VPWR VGND sg13g2_nor2b_1
X_5181__94 VPWR VGND net94 sg13g2_tiehi
XFILLER_46_806 VPWR VGND sg13g2_decap_8
XFILLER_38_68 VPWR VGND sg13g2_fill_1
XFILLER_45_349 VPWR VGND sg13g2_decap_8
XFILLER_14_703 VPWR VGND sg13g2_fill_2
XFILLER_26_552 VPWR VGND sg13g2_decap_8
XFILLER_26_563 VPWR VGND sg13g2_fill_2
XFILLER_26_574 VPWR VGND sg13g2_decap_4
XFILLER_13_202 VPWR VGND sg13g2_decap_4
XFILLER_9_206 VPWR VGND sg13g2_decap_8
XFILLER_22_780 VPWR VGND sg13g2_decap_8
XFILLER_10_953 VPWR VGND sg13g2_decap_8
X_5156__194 VPWR VGND net194 sg13g2_tiehi
XFILLER_6_913 VPWR VGND sg13g2_decap_8
XFILLER_49_644 VPWR VGND sg13g2_decap_8
X_5163__176 VPWR VGND net176 sg13g2_tiehi
XFILLER_36_305 VPWR VGND sg13g2_fill_2
XFILLER_36_327 VPWR VGND sg13g2_fill_2
XFILLER_17_585 VPWR VGND sg13g2_decap_8
X_3850_ net610 VPWR _1503_ VGND videogen.test_lut_thingy.pixel_feeder_inst.row\[17\]\[3\]
+ net566 sg13g2_o21ai_1
X_2801_ _0768_ _0727_ _0767_ VPWR VGND sg13g2_nand2_2
X_3781_ net635 VPWR _1434_ VGND videogen.test_lut_thingy.pixel_feeder_inst.row\[39\]\[1\]
+ net573 sg13g2_o21ai_1
X_2732_ net640 _0732_ net639 _0735_ VPWR VGND sg13g2_nand3_1
XFILLER_9_784 VPWR VGND sg13g2_fill_2
XFILLER_8_294 VPWR VGND sg13g2_decap_8
XFILLER_8_283 VPWR VGND sg13g2_fill_1
X_2663_ VPWR _0671_ videogen.test_lut_thingy.pixel_feeder_inst.row\[46\]\[0\] VGND
+ sg13g2_inv_1
X_4402_ VPWR VGND _2017_ _2040_ _2037_ _2018_ _2041_ _2028_ sg13g2_a221oi_1
X_4333_ red\[7\] red\[4\] _1974_ VPWR VGND sg13g2_xor2_1
XFILLER_8_1009 VPWR VGND sg13g2_decap_8
X_4264_ _1857_ _1896_ _1904_ _1905_ _1910_ VPWR VGND sg13g2_nor4_1
X_3215_ VPWR _0305_ _0912_ VGND sg13g2_inv_1
X_4195_ _1832_ _1839_ _1826_ _1841_ VPWR VGND sg13g2_nand3_1
X_3146_ serialize.shift_reg_r\[1\] serialize.shift_reg_r\[0\] clknet_1_1__leaf_clk
+ net6 VPWR VGND sg13g2_mux2_1
XFILLER_39_187 VPWR VGND sg13g2_fill_1
X_3077_ videogen.test_lut_thingy.pixel_feeder_inst.row\[1\]\[3\] net774 _0831_ _0274_
+ VPWR VGND sg13g2_mux2_1
XFILLER_39_1000 VPWR VGND sg13g2_decap_8
X_3979_ videogen.test_lut_thingy.pixel_feeder_inst.row\[36\]\[0\] net595 _1631_ VPWR
+ VGND sg13g2_nor2_1
XFILLER_2_448 VPWR VGND sg13g2_decap_8
XFILLER_49_56 VPWR VGND sg13g2_fill_2
Xfanout730 net732 net730 VPWR VGND sg13g2_buf_8
Xfanout741 net743 net741 VPWR VGND sg13g2_buf_8
Xfanout785 net787 net785 VPWR VGND sg13g2_buf_8
Xfanout774 net776 net774 VPWR VGND sg13g2_buf_8
Xfanout752 net754 net752 VPWR VGND sg13g2_buf_8
Xfanout763 _0691_ net763 VPWR VGND sg13g2_buf_8
XFILLER_46_603 VPWR VGND sg13g2_decap_8
Xfanout796 net798 net796 VPWR VGND sg13g2_buf_8
XFILLER_18_349 VPWR VGND sg13g2_fill_1
XFILLER_27_850 VPWR VGND sg13g2_decap_8
XFILLER_26_360 VPWR VGND sg13g2_fill_1
XFILLER_26_382 VPWR VGND sg13g2_decap_4
XFILLER_27_883 VPWR VGND sg13g2_decap_8
XFILLER_42_842 VPWR VGND sg13g2_decap_8
XFILLER_14_599 VPWR VGND sg13g2_fill_1
XFILLER_6_710 VPWR VGND sg13g2_fill_2
XFILLER_6_754 VPWR VGND sg13g2_fill_1
XFILLER_10_794 VPWR VGND sg13g2_fill_2
XFILLER_5_253 VPWR VGND sg13g2_decap_8
XFILLER_46_7 VPWR VGND sg13g2_decap_8
XFILLER_6_798 VPWR VGND sg13g2_fill_1
XFILLER_5_286 VPWR VGND sg13g2_fill_2
XFILLER_2_960 VPWR VGND sg13g2_decap_8
X_3000_ net800 videogen.test_lut_thingy.pixel_feeder_inst.row\[31\]\[0\] _0815_ _0432_
+ VPWR VGND sg13g2_mux2_1
XFILLER_37_669 VPWR VGND sg13g2_decap_8
XFILLER_18_872 VPWR VGND sg13g2_decap_8
X_4951_ net129 VGND VPWR net459 serialize.shift_reg_c\[4\] clknet_3_3_0_clk_regs sg13g2_dfrbpq_1
X_3902_ videogen.test_lut_thingy.pixel_feeder_inst.row\[9\]\[0\] net568 _1554_ VPWR
+ VGND sg13g2_nor2_1
X_4882_ net711 net757 _0217_ VPWR VGND sg13g2_nor2_1
XFILLER_33_853 VPWR VGND sg13g2_decap_8
X_3833_ videogen.test_lut_thingy.pixel_feeder_inst.row\[57\]\[3\] net560 _1486_ VPWR
+ VGND sg13g2_nor2_1
XFILLER_20_536 VPWR VGND sg13g2_decap_8
XFILLER_20_558 VPWR VGND sg13g2_fill_1
X_4974__97 VPWR VGND net97 sg13g2_tiehi
X_3764_ videogen.test_lut_thingy.pixel_feeder_inst.row\[58\]\[1\] net582 _1417_ VPWR
+ VGND sg13g2_nor2_1
X_2715_ net642 videogen.fancy_shader.video_x\[4\] videogen.fancy_shader.video_x\[1\]
+ videogen.fancy_shader.video_x\[0\] _0722_ VPWR VGND sg13g2_nor4_1
X_3695_ _1347_ net625 _1348_ VPWR VGND sg13g2_nor2b_1
X_5296_ net241 VGND VPWR _0624_ serialize.tmds_parallel_b\[9\] net652 sg13g2_dfrbpq_1
X_4316_ VGND VPWR red\[4\] _1953_ _1957_ _1952_ sg13g2_a21oi_1
X_4247_ VGND VPWR _1893_ _1891_ _1888_ sg13g2_or2_1
X_4178_ VGND VPWR _1817_ _1819_ _1824_ _1821_ sg13g2_a21oi_1
XFILLER_43_606 VPWR VGND sg13g2_fill_2
X_3129_ _0869_ _0867_ _0868_ VPWR VGND sg13g2_nand2_1
XFILLER_15_308 VPWR VGND sg13g2_fill_1
XFILLER_24_886 VPWR VGND sg13g2_decap_4
XFILLER_3_757 VPWR VGND sg13g2_fill_2
XFILLER_2_289 VPWR VGND sg13g2_decap_8
Xfanout560 net564 net560 VPWR VGND sg13g2_buf_8
XFILLER_47_923 VPWR VGND sg13g2_decap_8
Xfanout593 net594 net593 VPWR VGND sg13g2_buf_8
Xfanout582 net592 net582 VPWR VGND sg13g2_buf_8
Xfanout571 net572 net571 VPWR VGND sg13g2_buf_8
XFILLER_33_105 VPWR VGND sg13g2_fill_1
XFILLER_33_116 VPWR VGND sg13g2_fill_2
XFILLER_25_80 VPWR VGND sg13g2_decap_8
XFILLER_41_171 VPWR VGND sg13g2_fill_2
XFILLER_30_845 VPWR VGND sg13g2_decap_8
X_3480_ _1119_ _1122_ _1133_ VPWR VGND sg13g2_nor2b_1
X_5150_ net206 VGND VPWR _0478_ videogen.test_lut_thingy.pixel_feeder_inst.row\[61\]\[2\]
+ _0115_ sg13g2_dfrbpq_1
X_5081_ net327 VGND VPWR _0413_ videogen.test_lut_thingy.pixel_feeder_inst.row\[13\]\[2\]
+ _0059_ sg13g2_dfrbpq_1
X_4101_ _1646_ _1746_ _1449_ _1749_ VPWR VGND sg13g2_nand3_1
X_4032_ VGND VPWR _1674_ _1678_ _1681_ _1680_ sg13g2_a21oi_1
XFILLER_25_628 VPWR VGND sg13g2_decap_8
X_4934_ net154 VGND VPWR _0266_ serialize.shift_reg_r\[9\] clknet_3_7_0_clk_regs sg13g2_dfrbpq_1
XFILLER_17_190 VPWR VGND sg13g2_decap_8
XFILLER_20_311 VPWR VGND sg13g2_decap_4
XFILLER_32_193 VPWR VGND sg13g2_decap_8
X_4865_ net689 net735 _0200_ VPWR VGND sg13g2_nor2_1
X_3816_ videogen.test_lut_thingy.pixel_feeder_inst.row\[42\]\[3\] net585 _1469_ VPWR
+ VGND sg13g2_nor2_1
X_4796_ net699 net744 _0131_ VPWR VGND sg13g2_nor2_1
X_5330__205 VPWR VGND net205 sg13g2_tiehi
X_3747_ net638 VPWR _1400_ VGND videogen.test_lut_thingy.pixel_feeder_inst.row\[53\]\[1\]
+ net569 sg13g2_o21ai_1
X_3678_ videogen.test_lut_thingy.pixel_feeder_inst.row\[36\]\[2\] net595 _1331_ VPWR
+ VGND sg13g2_nor2_1
XFILLER_0_727 VPWR VGND sg13g2_decap_8
XFILLER_43_1007 VPWR VGND sg13g2_decap_8
XFILLER_47_219 VPWR VGND sg13g2_fill_2
X_5279_ net354 VGND VPWR _0607_ videogen.test_lut_thingy.pixel_feeder_inst.row\[19\]\[3\]
+ _0236_ sg13g2_dfrbpq_1
XFILLER_44_915 VPWR VGND sg13g2_decap_8
X_5298__233 VPWR VGND net233 sg13g2_tiehi
XFILLER_29_978 VPWR VGND sg13g2_decap_8
XFILLER_43_447 VPWR VGND sg13g2_fill_1
XFILLER_15_149 VPWR VGND sg13g2_decap_4
XFILLER_12_801 VPWR VGND sg13g2_decap_4
XFILLER_3_543 VPWR VGND sg13g2_decap_8
XFILLER_47_775 VPWR VGND sg13g2_decap_8
XFILLER_47_753 VPWR VGND sg13g2_fill_2
XFILLER_47_742 VPWR VGND sg13g2_decap_8
XFILLER_19_444 VPWR VGND sg13g2_decap_8
XFILLER_19_455 VPWR VGND sg13g2_fill_2
XFILLER_34_458 VPWR VGND sg13g2_fill_1
XFILLER_15_650 VPWR VGND sg13g2_decap_8
X_2980_ videogen.test_lut_thingy.pixel_feeder_inst.row\[6\]\[0\] net806 _0811_ _0448_
+ VPWR VGND sg13g2_mux2_1
XFILLER_30_631 VPWR VGND sg13g2_fill_1
X_4650_ _2240_ net664 net461 net669 red_tmds_par\[0\] VPWR VGND sg13g2_a22oi_1
X_3601_ _1253_ VPWR _1254_ VGND _1190_ _1252_ sg13g2_o21ai_1
X_5034__400 VPWR VGND net400 sg13g2_tiehi
X_4581_ VGND VPWR _2176_ _2177_ _2196_ _2179_ sg13g2_a21oi_1
X_3532_ _1184_ _1174_ _1177_ _1185_ VPWR VGND sg13g2_mux2_1
X_3463_ _1102_ _1115_ _1116_ VPWR VGND sg13g2_nor2_1
X_5202_ net438 VGND VPWR _0530_ videogen.test_lut_thingy.pixel_feeder_inst.row\[25\]\[2\]
+ _0159_ sg13g2_dfrbpq_1
X_3394_ _1047_ videogen.fancy_shader.n646\[5\] videogen.fancy_shader.video_x\[5\]
+ VPWR VGND sg13g2_xnor2_1
X_5133_ net240 VGND VPWR _0461_ videogen.test_lut_thingy.pixel_feeder_inst.row\[0\]\[1\]
+ _0098_ sg13g2_dfrbpq_1
XFILLER_35_0 VPWR VGND sg13g2_decap_8
X_5064_ net358 VGND VPWR _0396_ red_tmds_par\[3\] net658 sg13g2_dfrbpq_1
X_4015_ _1663_ _1113_ _1664_ VPWR VGND sg13g2_xor2_1
XFILLER_37_263 VPWR VGND sg13g2_decap_4
XFILLER_16_16 VPWR VGND sg13g2_decap_4
XFILLER_25_403 VPWR VGND sg13g2_decap_4
XFILLER_16_38 VPWR VGND sg13g2_decap_8
XFILLER_40_417 VPWR VGND sg13g2_decap_4
X_4917_ net695 net740 _0250_ VPWR VGND sg13g2_nor2_1
XFILLER_21_631 VPWR VGND sg13g2_decap_8
X_4848_ net708 net753 _0183_ VPWR VGND sg13g2_nor2_1
XFILLER_21_664 VPWR VGND sg13g2_decap_8
XFILLER_20_152 VPWR VGND sg13g2_decap_4
XFILLER_21_675 VPWR VGND sg13g2_fill_2
XFILLER_5_808 VPWR VGND sg13g2_fill_2
X_4779_ net675 net721 _0114_ VPWR VGND sg13g2_nor2_1
X_5115__276 VPWR VGND net276 sg13g2_tiehi
XFILLER_0_524 VPWR VGND sg13g2_decap_8
XFILLER_43_222 VPWR VGND sg13g2_decap_8
XFILLER_12_631 VPWR VGND sg13g2_decap_4
XFILLER_40_984 VPWR VGND sg13g2_decap_8
XFILLER_12_697 VPWR VGND sg13g2_decap_8
XFILLER_11_185 VPWR VGND sg13g2_fill_2
XFILLER_7_178 VPWR VGND sg13g2_decap_8
XFILLER_22_81 VPWR VGND sg13g2_decap_8
XFILLER_4_874 VPWR VGND sg13g2_decap_8
XFILLER_26_1013 VPWR VGND sg13g2_decap_8
XFILLER_34_211 VPWR VGND sg13g2_fill_2
XFILLER_35_756 VPWR VGND sg13g2_fill_2
XFILLER_16_970 VPWR VGND sg13g2_decap_8
X_2963_ videogen.test_lut_thingy.pixel_feeder_inst.row\[0\]\[2\] net785 _0808_ _0462_
+ VPWR VGND sg13g2_mux2_1
X_4702_ net711 net757 _0038_ VPWR VGND sg13g2_nor2_1
XFILLER_31_962 VPWR VGND sg13g2_decap_8
XFILLER_33_1017 VPWR VGND sg13g2_decap_8
X_2894_ videogen.test_lut_thingy.pixel_feeder_inst.row\[27\]\[3\] net772 _0792_ _0523_
+ VPWR VGND sg13g2_mux2_1
XFILLER_33_1028 VPWR VGND sg13g2_fill_1
X_4633_ VPWR _0649_ net482 VGND sg13g2_inv_1
X_4564_ _2178_ _2174_ _2180_ VPWR VGND sg13g2_xor2_1
X_3515_ _1168_ _1030_ _1166_ VPWR VGND sg13g2_xnor2_1
X_4495_ _2118_ _2102_ _2119_ VPWR VGND sg13g2_xor2_1
X_3446_ _1099_ _1057_ _1098_ VPWR VGND sg13g2_xnor2_1
X_3377_ VPWR _1030_ _1029_ VGND sg13g2_inv_1
X_5116_ net274 VGND VPWR _0444_ videogen.test_lut_thingy.pixel_feeder_inst.row\[2\]\[0\]
+ _0081_ sg13g2_dfrbpq_1
X_5047_ net387 VGND VPWR _0379_ videogen.test_lut_thingy.pixel_feeder_inst.row\[33\]\[0\]
+ _0033_ sg13g2_dfrbpq_1
XFILLER_38_594 VPWR VGND sg13g2_fill_1
XFILLER_14_918 VPWR VGND sg13g2_decap_8
XFILLER_25_244 VPWR VGND sg13g2_decap_8
XFILLER_25_288 VPWR VGND sg13g2_fill_2
XFILLER_43_69 VPWR VGND sg13g2_decap_8
XFILLER_22_940 VPWR VGND sg13g2_decap_8
XFILLER_49_1024 VPWR VGND sg13g2_decap_4
XFILLER_1_811 VPWR VGND sg13g2_decap_8
XFILLER_0_310 VPWR VGND sg13g2_decap_8
XFILLER_0_332 VPWR VGND sg13g2_decap_8
XFILLER_1_888 VPWR VGND sg13g2_decap_8
XFILLER_0_376 VPWR VGND sg13g2_decap_8
XFILLER_17_701 VPWR VGND sg13g2_decap_4
XFILLER_44_531 VPWR VGND sg13g2_fill_1
XFILLER_16_211 VPWR VGND sg13g2_decap_4
XFILLER_9_911 VPWR VGND sg13g2_decap_8
XFILLER_31_247 VPWR VGND sg13g2_decap_8
XFILLER_13_984 VPWR VGND sg13g2_decap_8
XFILLER_8_443 VPWR VGND sg13g2_fill_2
XFILLER_9_988 VPWR VGND sg13g2_decap_8
X_5031__403 VPWR VGND net403 sg13g2_tiehi
XFILLER_4_671 VPWR VGND sg13g2_decap_8
X_3300_ _0971_ _0965_ _0972_ _0974_ VPWR VGND sg13g2_a21o_1
X_4280_ VPWR VGND _1920_ _1916_ _1918_ _1854_ _1926_ _1855_ sg13g2_a221oi_1
X_3231_ _0923_ _0837_ videogen.test_lut_thingy.pixel_feeder_inst.h_counter\[0\] VPWR
+ VGND sg13g2_nand2b_1
XFILLER_39_314 VPWR VGND sg13g2_fill_2
X_3162_ red_tmds_par\[9\] net671 _0266_ VPWR VGND sg13g2_and2_1
X_3093_ videogen.fancy_shader.video_x\[6\] _0843_ _0844_ VPWR VGND sg13g2_and2_1
X_5099__308 VPWR VGND net308 sg13g2_tiehi
XFILLER_35_553 VPWR VGND sg13g2_decap_8
XFILLER_35_597 VPWR VGND sg13g2_fill_2
X_3995_ _1646_ _1449_ _1647_ VPWR VGND sg13g2_nor2b_1
X_2946_ net773 videogen.test_lut_thingy.pixel_feeder_inst.row\[7\]\[3\] _0804_ _0475_
+ VPWR VGND sg13g2_mux2_1
XFILLER_31_770 VPWR VGND sg13g2_decap_4
XFILLER_31_781 VPWR VGND sg13g2_fill_2
X_2877_ videogen.test_lut_thingy.pixel_feeder_inst.row\[52\]\[0\] net807 _0788_ _0536_
+ VPWR VGND sg13g2_mux2_1
X_4616_ VGND VPWR net492 _0885_ _2223_ net765 sg13g2_a21oi_1
XFILLER_2_619 VPWR VGND sg13g2_decap_4
X_4547_ _2164_ _2155_ _2163_ VPWR VGND sg13g2_xnor2_1
X_4478_ _2102_ tmds_green.dc_balancing_reg\[3\] _2082_ VPWR VGND sg13g2_xnor2_1
X_3429_ VGND VPWR _0974_ _1081_ _1082_ _1080_ sg13g2_a21oi_1
XFILLER_13_258 VPWR VGND sg13g2_decap_4
XFILLER_16_1012 VPWR VGND sg13g2_decap_8
XFILLER_10_932 VPWR VGND sg13g2_decap_8
XFILLER_6_969 VPWR VGND sg13g2_decap_8
X_5308__121 VPWR VGND net121 sg13g2_tiehi
XFILLER_49_623 VPWR VGND sg13g2_decap_8
XFILLER_0_140 VPWR VGND sg13g2_decap_8
X_5280__346 VPWR VGND net346 sg13g2_tiehi
XFILLER_48_144 VPWR VGND sg13g2_decap_4
XFILLER_48_111 VPWR VGND sg13g2_fill_2
XFILLER_45_873 VPWR VGND sg13g2_fill_1
X_4986__73 VPWR VGND net73 sg13g2_tiehi
X_2800_ _0724_ _0725_ _0767_ VPWR VGND sg13g2_nor2b_2
X_3780_ net612 _1427_ _1432_ _1433_ VPWR VGND sg13g2_nor3_1
XFILLER_13_792 VPWR VGND sg13g2_decap_8
X_2731_ _0734_ net639 net640 VPWR VGND sg13g2_nand2_1
X_2662_ VPWR _0670_ videogen.test_lut_thingy.pixel_feeder_inst.row\[44\]\[0\] VGND
+ sg13g2_inv_1
X_4401_ VGND VPWR _2038_ _2039_ _2040_ _1995_ sg13g2_a21oi_1
X_4332_ _1955_ _1972_ _1973_ VPWR VGND sg13g2_nor2_1
X_4263_ _1909_ _1895_ _1904_ VPWR VGND sg13g2_xnor2_1
X_3214_ _0911_ VPWR _0912_ VGND videogen.test_lut_thingy.pixel_feeder_inst.v_pix\[0\]
+ _0907_ sg13g2_o21ai_1
X_4194_ _1832_ _1826_ _1839_ _1840_ VPWR VGND sg13g2_a21o_1
X_3145_ serialize.shift_reg_g\[1\] serialize.shift_reg_g\[0\] clknet_1_1__leaf_clk
+ net5 VPWR VGND sg13g2_mux2_1
X_3076_ _0751_ _0768_ _0831_ VPWR VGND sg13g2_nor2_2
XFILLER_23_501 VPWR VGND sg13g2_decap_8
X_3978_ videogen.test_lut_thingy.pixel_feeder_inst.row\[38\]\[0\] net584 _1630_ VPWR
+ VGND sg13g2_nor2_1
X_2929_ videogen.test_lut_thingy.pixel_feeder_inst.row\[5\]\[3\] net773 _0799_ _0487_
+ VPWR VGND sg13g2_mux2_1
X_5014__431 VPWR VGND net431 sg13g2_tiehi
XFILLER_2_405 VPWR VGND sg13g2_decap_8
XFILLER_3_939 VPWR VGND sg13g2_decap_8
XFILLER_49_35 VPWR VGND sg13g2_decap_8
XFILLER_46_1027 VPWR VGND sg13g2_fill_2
XFILLER_46_1016 VPWR VGND sg13g2_decap_8
Xfanout731 net732 net731 VPWR VGND sg13g2_buf_1
Xfanout742 net743 net742 VPWR VGND sg13g2_buf_1
Xfanout720 net721 net720 VPWR VGND sg13g2_buf_8
Xfanout775 net777 net775 VPWR VGND sg13g2_buf_8
Xfanout753 net754 net753 VPWR VGND sg13g2_buf_8
Xfanout764 net765 net764 VPWR VGND sg13g2_buf_8
Xfanout786 net788 net786 VPWR VGND sg13g2_buf_8
XFILLER_19_829 VPWR VGND sg13g2_decap_4
Xfanout797 net799 net797 VPWR VGND sg13g2_buf_8
XFILLER_46_659 VPWR VGND sg13g2_decap_8
XFILLER_14_512 VPWR VGND sg13g2_decap_8
XFILLER_42_854 VPWR VGND sg13g2_decap_8
XFILLER_14_556 VPWR VGND sg13g2_decap_8
XFILLER_14_589 VPWR VGND sg13g2_fill_1
XFILLER_14_60 VPWR VGND sg13g2_fill_1
XFILLER_5_298 VPWR VGND sg13g2_decap_4
XFILLER_30_70 VPWR VGND sg13g2_fill_1
XFILLER_30_81 VPWR VGND sg13g2_fill_2
XFILLER_7_1010 VPWR VGND sg13g2_decap_8
XFILLER_49_475 VPWR VGND sg13g2_decap_4
XFILLER_49_497 VPWR VGND sg13g2_decap_8
XFILLER_37_659 VPWR VGND sg13g2_fill_1
XFILLER_37_648 VPWR VGND sg13g2_decap_8
XFILLER_37_637 VPWR VGND sg13g2_fill_2
XFILLER_36_114 VPWR VGND sg13g2_decap_4
XFILLER_36_136 VPWR VGND sg13g2_fill_1
XFILLER_45_670 VPWR VGND sg13g2_decap_8
X_4950_ net130 VGND VPWR net453 serialize.shift_reg_c\[3\] clknet_3_3_0_clk_regs sg13g2_dfrbpq_1
XFILLER_17_372 VPWR VGND sg13g2_fill_2
X_4881_ net693 net738 _0216_ VPWR VGND sg13g2_nor2_1
X_3901_ videogen.test_lut_thingy.pixel_feeder_inst.row\[10\]\[0\] net589 _1553_ VPWR
+ VGND sg13g2_nor2_1
X_4959__116 VPWR VGND net116 sg13g2_tiehi
X_3832_ net606 VPWR _1485_ VGND videogen.test_lut_thingy.pixel_feeder_inst.row\[59\]\[3\]
+ net572 sg13g2_o21ai_1
XFILLER_32_353 VPWR VGND sg13g2_decap_8
X_5291__261 VPWR VGND net261 sg13g2_tiehi
X_3763_ net606 VPWR _1416_ VGND videogen.test_lut_thingy.pixel_feeder_inst.row\[59\]\[1\]
+ net572 sg13g2_o21ai_1
X_2714_ videogen.fancy_shader.video_x\[6\] _0687_ videogen.fancy_shader.video_x\[3\]
+ videogen.fancy_shader.video_x\[2\] _0721_ VPWR VGND sg13g2_nor4_1
X_3694_ net627 _1335_ _1346_ _1347_ VPWR VGND sg13g2_nor3_1
XFILLER_10_18 VPWR VGND sg13g2_fill_2
XFILLER_10_29 VPWR VGND sg13g2_decap_8
XFILLER_0_909 VPWR VGND sg13g2_decap_8
X_4315_ _1956_ red\[4\] _1953_ VPWR VGND sg13g2_xnor2_1
X_5295_ net245 VGND VPWR _0623_ serialize.tmds_parallel_b\[8\] net652 sg13g2_dfrbpq_1
X_4246_ _1888_ _1891_ _1892_ VPWR VGND sg13g2_nor2_1
X_4177_ _1819_ _1817_ _1822_ _1823_ VPWR VGND sg13g2_a21o_1
X_3128_ _0865_ videogen.test_lut_thingy.pixel_feeder_inst.v_pix\[0\] videogen.test_lut_thingy.pixel_feeder_inst.v_pix\[1\]
+ _0868_ VPWR VGND sg13g2_a21o_1
XFILLER_28_648 VPWR VGND sg13g2_decap_4
XFILLER_27_136 VPWR VGND sg13g2_decap_8
XFILLER_43_629 VPWR VGND sg13g2_decap_8
XFILLER_24_810 VPWR VGND sg13g2_decap_8
X_3059_ videogen.test_lut_thingy.pixel_feeder_inst.row\[37\]\[1\] net791 _0827_ _0326_
+ VPWR VGND sg13g2_mux2_1
XFILLER_42_139 VPWR VGND sg13g2_decap_4
XFILLER_24_865 VPWR VGND sg13g2_decap_8
XFILLER_23_353 VPWR VGND sg13g2_decap_8
XFILLER_7_508 VPWR VGND sg13g2_decap_8
XFILLER_13_1026 VPWR VGND sg13g2_fill_2
XFILLER_3_736 VPWR VGND sg13g2_decap_4
XFILLER_2_202 VPWR VGND sg13g2_fill_2
XFILLER_4_4 VPWR VGND sg13g2_decap_8
XFILLER_47_902 VPWR VGND sg13g2_decap_8
Xfanout583 net592 net583 VPWR VGND sg13g2_buf_1
Xfanout561 net564 net561 VPWR VGND sg13g2_buf_2
Xfanout572 net581 net572 VPWR VGND sg13g2_buf_8
XFILLER_46_434 VPWR VGND sg13g2_fill_2
X_5125__256 VPWR VGND net256 sg13g2_tiehi
Xfanout594 net597 net594 VPWR VGND sg13g2_buf_8
XFILLER_20_1019 VPWR VGND sg13g2_decap_8
XFILLER_47_979 VPWR VGND sg13g2_decap_8
XFILLER_27_681 VPWR VGND sg13g2_fill_1
XFILLER_26_180 VPWR VGND sg13g2_fill_2
XFILLER_26_191 VPWR VGND sg13g2_decap_8
XFILLER_6_552 VPWR VGND sg13g2_decap_8
X_4100_ _1748_ _1449_ _1646_ VPWR VGND sg13g2_nand2_1
X_5080_ net329 VGND VPWR _0412_ videogen.test_lut_thingy.pixel_feeder_inst.row\[13\]\[1\]
+ _0058_ sg13g2_dfrbpq_1
X_4031_ VGND VPWR _1671_ _1672_ _1680_ _1669_ sg13g2_a21oi_1
XFILLER_2_52 VPWR VGND sg13g2_decap_8
XFILLER_38_979 VPWR VGND sg13g2_fill_1
XFILLER_24_106 VPWR VGND sg13g2_fill_1
X_4933_ net155 VGND VPWR _0265_ serialize.shift_reg_r\[8\] clknet_3_6_0_clk_regs sg13g2_dfrbpq_1
XFILLER_32_150 VPWR VGND sg13g2_fill_1
X_4864_ net689 net734 _0199_ VPWR VGND sg13g2_nor2_1
X_3815_ videogen.test_lut_thingy.pixel_feeder_inst.row\[43\]\[3\] net574 _1468_ VPWR
+ VGND sg13g2_nor2_1
X_4795_ net680 net724 _0130_ VPWR VGND sg13g2_nor2_1
X_3746_ _1398_ VPWR _1399_ VGND _1362_ _1374_ sg13g2_o21ai_1
X_3677_ net612 VPWR _1330_ VGND videogen.test_lut_thingy.pixel_feeder_inst.row\[38\]\[2\]
+ net584 sg13g2_o21ai_1
XFILLER_0_706 VPWR VGND sg13g2_decap_8
X_5278_ net367 VGND VPWR _0606_ videogen.test_lut_thingy.pixel_feeder_inst.row\[19\]\[2\]
+ _0235_ sg13g2_dfrbpq_1
X_4229_ VGND VPWR _1872_ _1873_ _1875_ _1870_ sg13g2_a21oi_1
XFILLER_29_913 VPWR VGND sg13g2_fill_1
XFILLER_46_14 VPWR VGND sg13g2_decap_8
XFILLER_29_957 VPWR VGND sg13g2_decap_8
XFILLER_46_58 VPWR VGND sg13g2_decap_8
XFILLER_46_36 VPWR VGND sg13g2_decap_8
XFILLER_15_117 VPWR VGND sg13g2_decap_4
XFILLER_24_684 VPWR VGND sg13g2_decap_8
XFILLER_8_806 VPWR VGND sg13g2_fill_2
XFILLER_12_879 VPWR VGND sg13g2_fill_1
XFILLER_7_327 VPWR VGND sg13g2_decap_8
XFILLER_3_522 VPWR VGND sg13g2_fill_2
XFILLER_38_209 VPWR VGND sg13g2_fill_1
XFILLER_47_721 VPWR VGND sg13g2_fill_1
XFILLER_46_242 VPWR VGND sg13g2_decap_8
XFILLER_46_275 VPWR VGND sg13g2_fill_1
XFILLER_46_297 VPWR VGND sg13g2_fill_2
XFILLER_46_286 VPWR VGND sg13g2_decap_8
XFILLER_34_437 VPWR VGND sg13g2_fill_1
XFILLER_43_993 VPWR VGND sg13g2_decap_8
XFILLER_42_492 VPWR VGND sg13g2_decap_8
X_4580_ VGND VPWR _2188_ _2195_ _0514_ net559 sg13g2_a21oi_1
X_3600_ net766 _0696_ _1253_ VPWR VGND sg13g2_nor2_1
XFILLER_30_676 VPWR VGND sg13g2_decap_8
X_3531_ _1174_ _1179_ _1184_ VPWR VGND sg13g2_nor2_1
XFILLER_6_360 VPWR VGND sg13g2_decap_4
X_3462_ VPWR VGND _1113_ _1101_ net553 _1089_ _1115_ _1090_ sg13g2_a221oi_1
X_3393_ videogen.fancy_shader.n646\[5\] net642 _1046_ VPWR VGND sg13g2_nor2_1
X_5201_ net442 VGND VPWR _0529_ videogen.test_lut_thingy.pixel_feeder_inst.row\[25\]\[1\]
+ _0158_ sg13g2_dfrbpq_1
Xclkbuf_1_0__f_clk clknet_0_clk clknet_1_0__leaf_clk VPWR VGND sg13g2_buf_8
X_5132_ net242 VGND VPWR _0460_ videogen.test_lut_thingy.pixel_feeder_inst.row\[0\]\[0\]
+ _0097_ sg13g2_dfrbpq_1
X_5063_ net359 VGND VPWR _0395_ red_tmds_par\[1\] net658 sg13g2_dfrbpq_1
X_4014_ _1058_ _1062_ _1658_ _1663_ VPWR VGND sg13g2_nor3_1
XFILLER_25_426 VPWR VGND sg13g2_decap_8
XFILLER_25_437 VPWR VGND sg13g2_fill_1
XFILLER_25_448 VPWR VGND sg13g2_decap_8
X_4916_ net695 net740 _0249_ VPWR VGND sg13g2_nor2_1
XFILLER_33_481 VPWR VGND sg13g2_decap_4
X_4847_ net708 net753 _0182_ VPWR VGND sg13g2_nor2_1
X_4778_ net676 net720 _0113_ VPWR VGND sg13g2_nor2_1
X_3729_ videogen.test_lut_thingy.pixel_feeder_inst.row\[12\]\[1\] net600 _1382_ VPWR
+ VGND sg13g2_nor2_1
XFILLER_0_503 VPWR VGND sg13g2_decap_8
XFILLER_48_529 VPWR VGND sg13g2_decap_8
XFILLER_28_231 VPWR VGND sg13g2_fill_2
XFILLER_28_264 VPWR VGND sg13g2_decap_4
XFILLER_44_735 VPWR VGND sg13g2_fill_1
XFILLER_17_949 VPWR VGND sg13g2_decap_8
XFILLER_31_407 VPWR VGND sg13g2_fill_1
XFILLER_32_919 VPWR VGND sg13g2_decap_8
XFILLER_43_289 VPWR VGND sg13g2_fill_1
XFILLER_24_470 VPWR VGND sg13g2_decap_8
XFILLER_25_982 VPWR VGND sg13g2_decap_8
XFILLER_7_102 VPWR VGND sg13g2_decap_8
XFILLER_3_341 VPWR VGND sg13g2_fill_1
XFILLER_3_385 VPWR VGND sg13g2_decap_4
XFILLER_35_724 VPWR VGND sg13g2_fill_2
XFILLER_47_584 VPWR VGND sg13g2_decap_8
XFILLER_34_201 VPWR VGND sg13g2_fill_1
XFILLER_34_267 VPWR VGND sg13g2_decap_8
X_2962_ videogen.test_lut_thingy.pixel_feeder_inst.row\[0\]\[3\] net774 _0808_ _0463_
+ VPWR VGND sg13g2_mux2_1
X_4701_ net711 net757 _0037_ VPWR VGND sg13g2_nor2_1
X_4632_ _2231_ net662 net481 net667 serialize.tmds_parallel_b\[7\] VPWR VGND sg13g2_a22oi_1
X_2893_ _0743_ _0765_ _0792_ VPWR VGND sg13g2_nor2_2
XFILLER_30_484 VPWR VGND sg13g2_fill_2
X_4563_ _2174_ _2178_ _2179_ VPWR VGND sg13g2_nor2b_1
X_4494_ _2083_ _2091_ _2117_ _2118_ VPWR VGND sg13g2_or3_1
X_5193__60 VPWR VGND net60 sg13g2_tiehi
X_3514_ _1030_ VPWR _1167_ VGND _1154_ _1165_ sg13g2_o21ai_1
X_3445_ _1064_ VPWR _1098_ VGND _1035_ _1062_ sg13g2_o21ai_1
X_3376_ _1028_ _1027_ _1029_ VPWR VGND sg13g2_xor2_1
X_5115_ net276 VGND VPWR _0443_ videogen.test_lut_thingy.pixel_feeder_inst.row\[30\]\[3\]
+ _0080_ sg13g2_dfrbpq_1
X_5046_ net388 VGND VPWR _0378_ tmds_red.dc_balancing_reg\[4\] net658 sg13g2_dfrbpq_2
X_5260__163 VPWR VGND net163 sg13g2_tiehi
XFILLER_27_49 VPWR VGND sg13g2_fill_1
XFILLER_26_746 VPWR VGND sg13g2_fill_1
XFILLER_26_757 VPWR VGND sg13g2_fill_2
XFILLER_40_259 VPWR VGND sg13g2_decap_8
XFILLER_22_996 VPWR VGND sg13g2_decap_8
XFILLER_5_628 VPWR VGND sg13g2_fill_1
XFILLER_49_1003 VPWR VGND sg13g2_decap_8
XFILLER_1_867 VPWR VGND sg13g2_decap_8
XFILLER_49_849 VPWR VGND sg13g2_decap_8
X_5024__411 VPWR VGND net411 sg13g2_tiehi
XFILLER_29_551 VPWR VGND sg13g2_fill_2
XFILLER_13_963 VPWR VGND sg13g2_decap_8
XFILLER_8_422 VPWR VGND sg13g2_decap_8
XFILLER_9_967 VPWR VGND sg13g2_decap_8
X_3230_ VGND VPWR videogen.test_lut_thingy.pixel_feeder_inst.v_pix\[5\] _0921_ _0310_
+ _0922_ sg13g2_a21oi_1
X_3161_ red_tmds_par\[8\] net668 _0265_ VPWR VGND sg13g2_and2_1
X_3092_ net642 _0841_ _0843_ VPWR VGND sg13g2_and2_1
XFILLER_23_727 VPWR VGND sg13g2_decap_8
X_3994_ _1645_ VPWR _1646_ VGND _1598_ _1644_ sg13g2_o21ai_1
XFILLER_13_18 VPWR VGND sg13g2_decap_8
X_2945_ _0755_ _0767_ _0727_ _0804_ VPWR VGND sg13g2_nand3_1
X_2876_ videogen.test_lut_thingy.pixel_feeder_inst.row\[52\]\[1\] net797 _0788_ _0537_
+ VPWR VGND sg13g2_mux2_1
X_4615_ net763 _2222_ _0624_ VPWR VGND sg13g2_nor2_1
X_5331__197 VPWR VGND net197 sg13g2_tiehi
X_4546_ VGND VPWR _2143_ _2152_ _2163_ _2144_ sg13g2_a21oi_1
X_4477_ net616 _2076_ _2087_ _2101_ VPWR VGND sg13g2_or3_1
XFILLER_1_119 VPWR VGND sg13g2_fill_2
X_3428_ _0976_ _1047_ _1081_ VPWR VGND sg13g2_nor2_1
X_3359_ VGND VPWR videogen.test_lut_thingy.gol_counter_reg\[0\] videogen.test_lut_thingy.gol_counter_reg\[1\]
+ _1015_ videogen.test_lut_thingy.gol_counter_reg\[2\] sg13g2_a21oi_1
XFILLER_38_370 VPWR VGND sg13g2_decap_4
X_5029_ net405 VGND VPWR _0361_ hsync net650 sg13g2_dfrbpq_2
XFILLER_10_911 VPWR VGND sg13g2_decap_8
XFILLER_10_988 VPWR VGND sg13g2_decap_8
XFILLER_6_948 VPWR VGND sg13g2_decap_8
XFILLER_49_602 VPWR VGND sg13g2_decap_8
XFILLER_0_196 VPWR VGND sg13g2_decap_8
XFILLER_1_697 VPWR VGND sg13g2_decap_8
XFILLER_23_1028 VPWR VGND sg13g2_fill_1
XFILLER_49_679 VPWR VGND sg13g2_decap_8
XFILLER_45_852 VPWR VGND sg13g2_decap_8
XFILLER_45_885 VPWR VGND sg13g2_decap_8
X_5135__236 VPWR VGND net236 sg13g2_tiehi
X_2730_ videogen.test_lut_thingy.pixel_feeder_inst.row\[21\]\[0\] net801 _0733_ _0638_
+ VPWR VGND sg13g2_mux2_1
XFILLER_13_782 VPWR VGND sg13g2_fill_2
X_4400_ _2039_ _2034_ _2007_ VPWR VGND sg13g2_nand2b_1
X_4331_ _1958_ red\[4\] _1972_ VPWR VGND sg13g2_xor2_1
X_4262_ _1903_ VPWR _1908_ VGND _1885_ _1900_ sg13g2_o21ai_1
X_3213_ VGND VPWR videogen.test_lut_thingy.pixel_feeder_inst.v_pix\[0\] _0905_ _0911_
+ _0909_ sg13g2_a21oi_1
X_5326__277 VPWR VGND net277 sg13g2_tiehi
X_4193_ _1829_ _1838_ _1839_ VPWR VGND sg13g2_nor2b_1
XFILLER_39_145 VPWR VGND sg13g2_fill_2
X_3144_ serialize.shift_reg_b\[1\] serialize.shift_reg_b\[0\] clknet_1_0__leaf_clk
+ net3 VPWR VGND sg13g2_mux2_1
XFILLER_27_307 VPWR VGND sg13g2_decap_4
XFILLER_28_819 VPWR VGND sg13g2_fill_1
X_3075_ net805 videogen.test_lut_thingy.pixel_feeder_inst.row\[17\]\[0\] _0830_ _0275_
+ VPWR VGND sg13g2_mux2_1
XFILLER_36_841 VPWR VGND sg13g2_decap_8
XFILLER_35_395 VPWR VGND sg13g2_fill_2
X_3977_ net630 VPWR _1629_ VGND _1626_ _1628_ sg13g2_o21ai_1
X_2928_ _0759_ _0768_ _0799_ VPWR VGND sg13g2_nor2_2
XFILLER_40_38 VPWR VGND sg13g2_decap_4
X_2859_ videogen.test_lut_thingy.pixel_feeder_inst.row\[4\]\[3\] net773 _0785_ _0551_
+ VPWR VGND sg13g2_mux2_1
XFILLER_3_918 VPWR VGND sg13g2_decap_8
X_4529_ _0879_ VPWR _2147_ VGND _2139_ _2146_ sg13g2_o21ai_1
XFILLER_49_14 VPWR VGND sg13g2_decap_8
XFILLER_49_58 VPWR VGND sg13g2_fill_1
Xfanout732 net733 net732 VPWR VGND sg13g2_buf_8
Xfanout721 net739 net721 VPWR VGND sg13g2_buf_8
Xfanout710 net715 net710 VPWR VGND sg13g2_buf_8
Xfanout776 net777 net776 VPWR VGND sg13g2_buf_2
Xfanout743 net749 net743 VPWR VGND sg13g2_buf_8
Xfanout765 net766 net765 VPWR VGND sg13g2_buf_8
Xfanout754 net761 net754 VPWR VGND sg13g2_buf_8
Xfanout787 net788 net787 VPWR VGND sg13g2_buf_2
Xfanout798 net799 net798 VPWR VGND sg13g2_buf_2
XFILLER_46_638 VPWR VGND sg13g2_decap_8
X_5082__187 VPWR VGND net187 sg13g2_tiehi
X_5275__416 VPWR VGND net416 sg13g2_tiehi
XFILLER_14_579 VPWR VGND sg13g2_fill_2
XFILLER_6_734 VPWR VGND sg13g2_decap_8
XFILLER_10_796 VPWR VGND sg13g2_fill_1
XFILLER_6_778 VPWR VGND sg13g2_fill_2
XFILLER_6_767 VPWR VGND sg13g2_decap_8
XFILLER_2_995 VPWR VGND sg13g2_decap_8
XFILLER_1_494 VPWR VGND sg13g2_decap_8
XFILLER_49_454 VPWR VGND sg13g2_decap_8
XFILLER_45_660 VPWR VGND sg13g2_decap_4
XFILLER_33_800 VPWR VGND sg13g2_decap_8
X_4880_ net692 net732 _0215_ VPWR VGND sg13g2_nor2_1
X_3900_ net633 VPWR _1552_ VGND videogen.test_lut_thingy.pixel_feeder_inst.row\[11\]\[0\]
+ net578 sg13g2_o21ai_1
X_3831_ net631 _1478_ _1483_ _1484_ VPWR VGND sg13g2_nor3_1
X_3762_ _1411_ _1412_ _1413_ _1414_ _1415_ VPWR VGND sg13g2_nor4_1
XFILLER_9_561 VPWR VGND sg13g2_decap_8
X_5072__345 VPWR VGND net345 sg13g2_tiehi
X_3693_ net635 _1340_ _1345_ _1346_ VPWR VGND sg13g2_nor3_1
X_2713_ net604 _0711_ net557 _0720_ VPWR VGND sg13g2_nor3_2
X_4314_ _1955_ red\[6\] _1953_ VPWR VGND sg13g2_xnor2_1
X_5294_ net249 VGND VPWR _0622_ serialize.tmds_parallel_b\[7\] net653 sg13g2_dfrbpq_1
X_4245_ VPWR VGND _1889_ _1886_ _1880_ _1877_ _1891_ _1879_ sg13g2_a221oi_1
XFILLER_19_17 VPWR VGND sg13g2_decap_4
X_4176_ VGND VPWR _1817_ _1821_ _1822_ _1819_ sg13g2_a21oi_1
X_3127_ videogen.test_lut_thingy.pixel_feeder_inst.v_pix\[0\] _0865_ videogen.test_lut_thingy.pixel_feeder_inst.v_pix\[1\]
+ _0867_ VPWR VGND sg13g2_nand3_1
X_4942__143 VPWR VGND net143 sg13g2_tiehi
X_3058_ videogen.test_lut_thingy.pixel_feeder_inst.row\[37\]\[2\] net780 _0827_ _0327_
+ VPWR VGND sg13g2_mux2_1
XFILLER_11_505 VPWR VGND sg13g2_decap_8
XFILLER_13_1005 VPWR VGND sg13g2_decap_8
XFILLER_2_214 VPWR VGND sg13g2_decap_8
X_5264__117 VPWR VGND net117 sg13g2_tiehi
Xfanout562 net563 net562 VPWR VGND sg13g2_buf_8
Xfanout573 net581 net573 VPWR VGND sg13g2_buf_8
Xfanout584 net585 net584 VPWR VGND sg13g2_buf_8
XFILLER_47_958 VPWR VGND sg13g2_decap_8
Xfanout595 net597 net595 VPWR VGND sg13g2_buf_8
XFILLER_46_457 VPWR VGND sg13g2_fill_1
XFILLER_18_126 VPWR VGND sg13g2_decap_8
XFILLER_18_137 VPWR VGND sg13g2_decap_8
XFILLER_33_118 VPWR VGND sg13g2_fill_1
XFILLER_14_332 VPWR VGND sg13g2_fill_2
XFILLER_41_184 VPWR VGND sg13g2_decap_4
XFILLER_14_387 VPWR VGND sg13g2_fill_2
XFILLER_14_398 VPWR VGND sg13g2_decap_8
X_4030_ _1679_ _1674_ _1678_ VPWR VGND sg13g2_nand2_1
XFILLER_2_97 VPWR VGND sg13g2_decap_8
XFILLER_37_479 VPWR VGND sg13g2_decap_4
X_4932_ net156 VGND VPWR net758 clockdiv.q2temp net445 sg13g2_dfrbpq_1
XFILLER_17_170 VPWR VGND sg13g2_fill_2
X_4863_ net684 net729 _0198_ VPWR VGND sg13g2_nor2_1
X_3814_ net607 VPWR _1467_ VGND videogen.test_lut_thingy.pixel_feeder_inst.row\[41\]\[3\]
+ net563 sg13g2_o21ai_1
X_4794_ net679 net724 _0129_ VPWR VGND sg13g2_nor2_1
XFILLER_21_858 VPWR VGND sg13g2_decap_4
X_3745_ net625 _1397_ _1398_ VPWR VGND sg13g2_nor2_1
XFILLER_21_29 VPWR VGND sg13g2_fill_2
X_3676_ _1325_ _1326_ _1327_ _1328_ _1329_ VPWR VGND sg13g2_nor4_1
X_5277_ net375 VGND VPWR _0605_ videogen.test_lut_thingy.pixel_feeder_inst.row\[19\]\[1\]
+ _0234_ sg13g2_dfrbpq_1
X_4228_ _1874_ _1868_ _1869_ VPWR VGND sg13g2_nand2_1
XFILLER_28_413 VPWR VGND sg13g2_decap_8
X_4159_ _1805_ _1802_ _1804_ VPWR VGND sg13g2_nand2_1
XFILLER_28_446 VPWR VGND sg13g2_fill_1
XFILLER_28_457 VPWR VGND sg13g2_fill_2
XFILLER_8_829 VPWR VGND sg13g2_fill_2
XFILLER_11_335 VPWR VGND sg13g2_fill_2
XFILLER_11_357 VPWR VGND sg13g2_fill_2
XFILLER_23_195 VPWR VGND sg13g2_fill_1
XFILLER_3_534 VPWR VGND sg13g2_decap_4
XFILLER_11_62 VPWR VGND sg13g2_decap_4
XFILLER_11_95 VPWR VGND sg13g2_fill_2
XFILLER_3_589 VPWR VGND sg13g2_decap_8
XFILLER_4_1014 VPWR VGND sg13g2_decap_8
XFILLER_36_81 VPWR VGND sg13g2_fill_2
XFILLER_43_972 VPWR VGND sg13g2_decap_8
XFILLER_7_840 VPWR VGND sg13g2_fill_2
X_3530_ videogen.fancy_shader.video_x\[0\] videogen.fancy_shader.video_y\[0\] _1183_
+ VPWR VGND sg13g2_xor2_1
XFILLER_7_884 VPWR VGND sg13g2_decap_8
XFILLER_6_350 VPWR VGND sg13g2_fill_1
X_3461_ VPWR _1114_ _1113_ VGND sg13g2_inv_1
X_5200_ net32 VGND VPWR _0528_ videogen.test_lut_thingy.pixel_feeder_inst.row\[25\]\[0\]
+ _0157_ sg13g2_dfrbpq_1
X_3392_ _1045_ videogen.fancy_shader.n646\[5\] net642 VPWR VGND sg13g2_nand2_1
X_5131_ net244 VGND VPWR _0459_ videogen.test_lut_thingy.pixel_feeder_inst.row\[10\]\[3\]
+ _0096_ sg13g2_dfrbpq_1
X_5062_ net360 VGND VPWR _0394_ red_tmds_par\[0\] net658 sg13g2_dfrbpq_1
X_4013_ _1662_ _1049_ _1661_ VPWR VGND sg13g2_xnor2_1
XFILLER_37_221 VPWR VGND sg13g2_fill_2
XFILLER_19_991 VPWR VGND sg13g2_decap_8
X_4915_ net700 net745 _0248_ VPWR VGND sg13g2_nor2_1
XFILLER_21_611 VPWR VGND sg13g2_fill_1
X_4846_ net709 net753 _0181_ VPWR VGND sg13g2_nor2_1
X_4777_ net701 net745 _0112_ VPWR VGND sg13g2_nor2_1
XFILLER_20_176 VPWR VGND sg13g2_fill_2
X_3728_ videogen.test_lut_thingy.pixel_feeder_inst.row\[13\]\[1\] net567 _1381_ VPWR
+ VGND sg13g2_nor2_1
X_3659_ _1308_ _1309_ _1310_ _1311_ _1312_ VPWR VGND sg13g2_nor4_1
X_5329_ net213 VGND VPWR _0657_ serialize.shift_reg_g\[7\] clknet_3_7_0_clk_regs sg13g2_dfrbpq_1
XFILLER_48_508 VPWR VGND sg13g2_decap_8
XFILLER_0_559 VPWR VGND sg13g2_decap_8
XFILLER_29_711 VPWR VGND sg13g2_decap_8
XFILLER_28_210 VPWR VGND sg13g2_decap_8
XFILLER_17_928 VPWR VGND sg13g2_decap_8
XFILLER_29_777 VPWR VGND sg13g2_decap_8
XFILLER_29_799 VPWR VGND sg13g2_fill_2
XFILLER_44_725 VPWR VGND sg13g2_fill_2
XFILLER_25_961 VPWR VGND sg13g2_decap_8
XFILLER_31_419 VPWR VGND sg13g2_decap_4
XFILLER_11_121 VPWR VGND sg13g2_decap_8
XFILLER_8_615 VPWR VGND sg13g2_decap_8
XFILLER_7_114 VPWR VGND sg13g2_fill_2
XFILLER_11_187 VPWR VGND sg13g2_fill_1
XFILLER_7_169 VPWR VGND sg13g2_decap_4
XFILLER_3_320 VPWR VGND sg13g2_decap_8
XFILLER_39_508 VPWR VGND sg13g2_decap_8
XFILLER_47_563 VPWR VGND sg13g2_decap_8
XFILLER_47_91 VPWR VGND sg13g2_fill_2
XFILLER_19_265 VPWR VGND sg13g2_decap_8
XFILLER_19_276 VPWR VGND sg13g2_fill_2
XFILLER_34_213 VPWR VGND sg13g2_fill_1
XFILLER_23_909 VPWR VGND sg13g2_decap_8
XFILLER_35_758 VPWR VGND sg13g2_fill_1
X_2961_ _0744_ _0768_ _0808_ VPWR VGND sg13g2_nor2_2
X_4700_ _0689_ net558 _0384_ VPWR VGND sg13g2_nor2_1
X_2892_ videogen.test_lut_thingy.pixel_feeder_inst.row\[26\]\[0\] net805 _0791_ _0524_
+ VPWR VGND sg13g2_mux2_1
XFILLER_31_997 VPWR VGND sg13g2_decap_8
X_4631_ VPWR _0648_ net473 VGND sg13g2_inv_1
XFILLER_8_85 VPWR VGND sg13g2_fill_1
X_4562_ _2177_ _2176_ _2178_ VPWR VGND sg13g2_xor2_1
X_4493_ net615 green\[6\] _2117_ VPWR VGND sg13g2_nor2b_1
X_3513_ _1154_ _1165_ _1166_ VPWR VGND sg13g2_nor2_1
X_3444_ _1097_ _1078_ _1082_ VPWR VGND sg13g2_xnor2_1
XFILLER_6_191 VPWR VGND sg13g2_fill_2
XFILLER_40_0 VPWR VGND sg13g2_fill_1
X_3375_ _1028_ _0965_ _0967_ VPWR VGND sg13g2_xnor2_1
X_5145__216 VPWR VGND net216 sg13g2_tiehi
X_5114_ net278 VGND VPWR _0442_ videogen.test_lut_thingy.pixel_feeder_inst.row\[30\]\[2\]
+ _0079_ sg13g2_dfrbpq_1
X_5045_ net389 VGND VPWR _0377_ tmds_red.dc_balancing_reg\[3\] net661 sg13g2_dfrbpq_2
XFILLER_38_563 VPWR VGND sg13g2_fill_1
XFILLER_43_38 VPWR VGND sg13g2_decap_8
XFILLER_40_205 VPWR VGND sg13g2_fill_2
XFILLER_13_408 VPWR VGND sg13g2_fill_1
XFILLER_21_463 VPWR VGND sg13g2_decap_8
XFILLER_22_975 VPWR VGND sg13g2_decap_8
X_4829_ net706 net754 _0164_ VPWR VGND sg13g2_nor2_1
XFILLER_1_846 VPWR VGND sg13g2_decap_8
XFILLER_49_828 VPWR VGND sg13g2_decap_8
XFILLER_44_522 VPWR VGND sg13g2_decap_8
XFILLER_44_500 VPWR VGND sg13g2_fill_2
XFILLER_1_1028 VPWR VGND sg13g2_fill_1
XFILLER_29_585 VPWR VGND sg13g2_decap_8
XFILLER_17_769 VPWR VGND sg13g2_decap_8
XFILLER_32_706 VPWR VGND sg13g2_decap_8
XFILLER_44_599 VPWR VGND sg13g2_decap_8
XFILLER_16_268 VPWR VGND sg13g2_decap_8
XFILLER_13_942 VPWR VGND sg13g2_decap_8
XFILLER_8_401 VPWR VGND sg13g2_decap_8
XFILLER_12_463 VPWR VGND sg13g2_decap_8
XFILLER_9_946 VPWR VGND sg13g2_decap_8
Xclkbuf_3_1_0_clk_regs clknet_0_clk_regs clknet_3_1_0_clk_regs VPWR VGND sg13g2_buf_8
XFILLER_39_316 VPWR VGND sg13g2_fill_1
X_3160_ _0669_ net492 net814 _0882_ VPWR VGND sg13g2_and3_2
XFILLER_39_349 VPWR VGND sg13g2_fill_2
X_3091_ _0842_ videogen.fancy_shader.video_x\[6\] net642 VPWR VGND sg13g2_nand2_1
Xhold1 clockdiv.q2 VPWR VGND net446 sg13g2_dlygate4sd3_1
XFILLER_48_894 VPWR VGND sg13g2_decap_8
XFILLER_47_393 VPWR VGND sg13g2_decap_8
XFILLER_23_717 VPWR VGND sg13g2_fill_1
X_3993_ _1645_ videogen.test_lut_thingy.gol_counter_reg\[0\] net2 VPWR VGND sg13g2_nand2b_1
X_2944_ _0803_ VPWR _0476_ VGND _0673_ _0801_ sg13g2_o21ai_1
X_2875_ videogen.test_lut_thingy.pixel_feeder_inst.row\[52\]\[2\] net786 _0788_ _0538_
+ VPWR VGND sg13g2_mux2_1
XFILLER_31_794 VPWR VGND sg13g2_fill_1
X_4614_ VGND VPWR net621 _2214_ _2222_ _2221_ sg13g2_a21oi_1
X_4545_ _2160_ net618 _2161_ _2162_ VPWR VGND sg13g2_a21o_1
X_4476_ VGND VPWR _2099_ _2100_ _0421_ net558 sg13g2_a21oi_1
X_3427_ _1045_ VPWR _1080_ VGND _0975_ _1046_ sg13g2_o21ai_1
XFILLER_38_16 VPWR VGND sg13g2_fill_2
X_3358_ VGND VPWR videogen.test_lut_thingy.gol_counter_reg\[0\] videogen.test_lut_thingy.gol_counter_reg\[1\]
+ _0358_ _1014_ sg13g2_a21oi_1
X_3289_ videogen.fancy_shader.n646\[1\] videogen.fancy_shader.video_x\[1\] _0963_
+ VPWR VGND sg13g2_nor2_1
X_5028_ net406 VGND VPWR _0360_ videogen.test_lut_thingy.gol_counter_reg\[3\] net650
+ sg13g2_dfrbpq_1
XFILLER_14_739 VPWR VGND sg13g2_fill_1
XFILLER_41_547 VPWR VGND sg13g2_fill_1
XFILLER_22_761 VPWR VGND sg13g2_decap_4
XFILLER_6_927 VPWR VGND sg13g2_decap_8
XFILLER_5_404 VPWR VGND sg13g2_fill_2
XFILLER_10_967 VPWR VGND sg13g2_decap_8
XFILLER_21_293 VPWR VGND sg13g2_decap_4
XFILLER_1_665 VPWR VGND sg13g2_decap_8
XFILLER_49_658 VPWR VGND sg13g2_decap_8
XFILLER_23_1007 VPWR VGND sg13g2_decap_8
XFILLER_17_511 VPWR VGND sg13g2_fill_1
X_5098__310 VPWR VGND net310 sg13g2_tiehi
XFILLER_29_393 VPWR VGND sg13g2_fill_2
XFILLER_32_558 VPWR VGND sg13g2_fill_2
XFILLER_9_732 VPWR VGND sg13g2_decap_8
XFILLER_8_253 VPWR VGND sg13g2_decap_8
XFILLER_5_993 VPWR VGND sg13g2_decap_8
X_4330_ _1971_ _1958_ net552 VPWR VGND sg13g2_xnor2_1
X_4261_ _1907_ _1858_ _1906_ VPWR VGND sg13g2_nand2_1
X_3212_ VPWR _0910_ _0909_ VGND sg13g2_inv_1
X_4192_ _1814_ VPWR _1838_ VGND _1816_ _1824_ sg13g2_o21ai_1
X_3143_ serialize.shift_reg_c\[1\] serialize.shift_reg_c\[0\] clknet_1_0__leaf_clk
+ net4 VPWR VGND sg13g2_mux2_1
X_3074_ net794 videogen.test_lut_thingy.pixel_feeder_inst.row\[17\]\[1\] _0830_ _0276_
+ VPWR VGND sg13g2_mux2_1
XFILLER_39_1014 VPWR VGND sg13g2_decap_8
XFILLER_36_886 VPWR VGND sg13g2_decap_8
X_3976_ _1627_ VPWR _1628_ VGND videogen.test_lut_thingy.pixel_feeder_inst.row\[45\]\[0\]
+ net564 sg13g2_o21ai_1
X_2927_ net806 videogen.test_lut_thingy.pixel_feeder_inst.row\[58\]\[0\] _0798_ _0488_
+ VPWR VGND sg13g2_mux2_1
XFILLER_31_591 VPWR VGND sg13g2_decap_8
X_2858_ _0768_ _0778_ _0785_ VPWR VGND sg13g2_nor2_2
X_2789_ videogen.test_lut_thingy.pixel_feeder_inst.row\[38\]\[2\] net780 _0762_ _0598_
+ VPWR VGND sg13g2_mux2_1
X_4528_ _2145_ _2142_ _2146_ VPWR VGND sg13g2_xor2_1
X_4459_ _2082_ tmds_green.dc_balancing_reg\[2\] _2084_ VPWR VGND sg13g2_xor2_1
Xfanout700 net704 net700 VPWR VGND sg13g2_buf_1
Xfanout733 net739 net733 VPWR VGND sg13g2_buf_2
Xfanout722 net726 net722 VPWR VGND sg13g2_buf_8
Xfanout711 net715 net711 VPWR VGND sg13g2_buf_8
Xfanout766 _0691_ net766 VPWR VGND sg13g2_buf_8
Xfanout744 net749 net744 VPWR VGND sg13g2_buf_8
Xfanout755 net760 net755 VPWR VGND sg13g2_buf_8
XFILLER_46_617 VPWR VGND sg13g2_decap_8
Xfanout777 ui_in[7] net777 VPWR VGND sg13g2_buf_8
Xfanout788 ui_in[6] net788 VPWR VGND sg13g2_buf_8
Xfanout799 ui_in[5] net799 VPWR VGND sg13g2_buf_8
XFILLER_45_116 VPWR VGND sg13g2_decap_8
XFILLER_39_691 VPWR VGND sg13g2_fill_2
XFILLER_27_864 VPWR VGND sg13g2_decap_4
XFILLER_14_525 VPWR VGND sg13g2_decap_8
XFILLER_41_399 VPWR VGND sg13g2_fill_1
XFILLER_10_731 VPWR VGND sg13g2_decap_8
XFILLER_10_742 VPWR VGND sg13g2_fill_1
XFILLER_5_267 VPWR VGND sg13g2_decap_4
XFILLER_30_83 VPWR VGND sg13g2_fill_1
XFILLER_2_974 VPWR VGND sg13g2_decap_8
XFILLER_49_433 VPWR VGND sg13g2_decap_8
XFILLER_39_81 VPWR VGND sg13g2_fill_1
XFILLER_39_70 VPWR VGND sg13g2_decap_8
XFILLER_37_639 VPWR VGND sg13g2_fill_1
X_3830_ _1479_ _1480_ _1481_ _1482_ _1483_ VPWR VGND sg13g2_nor4_1
XFILLER_13_580 VPWR VGND sg13g2_decap_8
X_3761_ videogen.test_lut_thingy.pixel_feeder_inst.row\[61\]\[1\] net560 _1414_ VPWR
+ VGND sg13g2_nor2_1
XFILLER_32_399 VPWR VGND sg13g2_decap_8
X_2712_ _0711_ net557 _0719_ VPWR VGND sg13g2_nor2_1
X_3692_ _1341_ _1342_ _1343_ _1344_ _1345_ VPWR VGND sg13g2_nor4_1
X_4313_ _1954_ _1953_ VPWR VGND sg13g2_inv_2
X_5293_ net253 VGND VPWR _0621_ serialize.tmds_parallel_b\[6\] net652 sg13g2_dfrbpq_1
X_4244_ VGND VPWR _1880_ _1889_ _1890_ _1881_ sg13g2_a21oi_1
X_4175_ _1809_ _1820_ _1821_ VPWR VGND sg13g2_nor2_1
X_3126_ VGND VPWR _0863_ _0866_ net16 _0864_ sg13g2_a21oi_1
XFILLER_28_628 VPWR VGND sg13g2_fill_2
XFILLER_28_639 VPWR VGND sg13g2_decap_4
X_3057_ videogen.test_lut_thingy.pixel_feeder_inst.row\[37\]\[3\] net770 _0827_ _0328_
+ VPWR VGND sg13g2_mux2_1
X_3959_ videogen.test_lut_thingy.pixel_feeder_inst.row\[57\]\[0\] net560 _1611_ VPWR
+ VGND sg13g2_nor2_1
XFILLER_13_1028 VPWR VGND sg13g2_fill_1
XFILLER_2_226 VPWR VGND sg13g2_fill_2
Xfanout574 net581 net574 VPWR VGND sg13g2_buf_8
Xfanout552 _1966_ net552 VPWR VGND sg13g2_buf_8
Xfanout563 net564 net563 VPWR VGND sg13g2_buf_8
XFILLER_47_937 VPWR VGND sg13g2_decap_8
XFILLER_18_116 VPWR VGND sg13g2_fill_2
XFILLER_19_639 VPWR VGND sg13g2_decap_8
Xfanout585 net592 net585 VPWR VGND sg13g2_buf_8
Xfanout596 net597 net596 VPWR VGND sg13g2_buf_8
XFILLER_46_469 VPWR VGND sg13g2_fill_1
XFILLER_15_801 VPWR VGND sg13g2_fill_2
XFILLER_15_834 VPWR VGND sg13g2_decap_4
XFILLER_26_160 VPWR VGND sg13g2_fill_1
XFILLER_27_694 VPWR VGND sg13g2_decap_8
XFILLER_30_804 VPWR VGND sg13g2_decap_4
XFILLER_25_94 VPWR VGND sg13g2_decap_8
XFILLER_30_859 VPWR VGND sg13g2_decap_4
XFILLER_44_7 VPWR VGND sg13g2_decap_4
XFILLER_29_1013 VPWR VGND sg13g2_decap_8
XFILLER_2_32 VPWR VGND sg13g2_decap_8
XFILLER_49_274 VPWR VGND sg13g2_decap_8
XFILLER_2_76 VPWR VGND sg13g2_decap_8
XFILLER_46_981 VPWR VGND sg13g2_decap_8
XFILLER_18_672 VPWR VGND sg13g2_fill_2
XFILLER_17_160 VPWR VGND sg13g2_decap_4
XFILLER_17_182 VPWR VGND sg13g2_fill_1
X_4931_ net157 VGND VPWR _0264_ clockdiv.q2 clknet_3_0_0_clk_regs sg13g2_dfrbpq_1
X_4862_ net689 net725 _0197_ VPWR VGND sg13g2_nor2_1
XFILLER_32_141 VPWR VGND sg13g2_decap_8
X_5176__123 VPWR VGND net123 sg13g2_tiehi
XFILLER_21_837 VPWR VGND sg13g2_fill_2
X_3813_ _1462_ _1463_ _1464_ _1465_ _1466_ VPWR VGND sg13g2_nor4_1
XFILLER_36_1028 VPWR VGND sg13g2_fill_1
X_4793_ net680 net724 _0128_ VPWR VGND sg13g2_nor2_1
X_3744_ net628 _1385_ _1396_ _1397_ VPWR VGND sg13g2_nor3_1
X_3675_ videogen.test_lut_thingy.pixel_feeder_inst.row\[47\]\[2\] net574 _1328_ VPWR
+ VGND sg13g2_nor2_1
X_5276_ net386 VGND VPWR _0604_ videogen.test_lut_thingy.pixel_feeder_inst.row\[19\]\[0\]
+ _0233_ sg13g2_dfrbpq_1
X_4227_ _1868_ _1869_ _1873_ VPWR VGND sg13g2_and2_1
X_5304__181 VPWR VGND net181 sg13g2_tiehi
X_4158_ _1763_ _1795_ _1804_ VPWR VGND sg13g2_nor2_1
XFILLER_44_929 VPWR VGND sg13g2_decap_8
X_3109_ VGND VPWR net556 _0854_ net9 net604 sg13g2_a21oi_1
X_4089_ _1736_ _1737_ _1183_ _1738_ VPWR VGND sg13g2_nand3_1
XFILLER_43_428 VPWR VGND sg13g2_fill_2
XFILLER_24_620 VPWR VGND sg13g2_decap_8
XFILLER_11_314 VPWR VGND sg13g2_fill_1
XFILLER_12_826 VPWR VGND sg13g2_decap_8
XFILLER_23_141 VPWR VGND sg13g2_fill_2
XFILLER_23_163 VPWR VGND sg13g2_fill_2
XFILLER_24_675 VPWR VGND sg13g2_decap_4
XFILLER_23_185 VPWR VGND sg13g2_decap_4
X_5313__428 VPWR VGND net428 sg13g2_tiehi
X_5055__374 VPWR VGND net374 sg13g2_tiehi
XFILLER_3_513 VPWR VGND sg13g2_fill_1
XFILLER_3_557 VPWR VGND sg13g2_decap_8
XFILLER_47_789 VPWR VGND sg13g2_fill_1
XFILLER_15_675 VPWR VGND sg13g2_fill_2
XFILLER_15_697 VPWR VGND sg13g2_decap_4
XFILLER_7_863 VPWR VGND sg13g2_decap_8
X_3460_ _1111_ _1112_ _1113_ VPWR VGND sg13g2_and2_1
XFILLER_42_4 VPWR VGND sg13g2_fill_2
X_3391_ _1044_ _1042_ _1043_ VPWR VGND sg13g2_xnor2_1
X_5130_ net246 VGND VPWR _0458_ videogen.test_lut_thingy.pixel_feeder_inst.row\[10\]\[2\]
+ _0095_ sg13g2_dfrbpq_1
X_5061_ net362 VGND VPWR _0393_ videogen.test_lut_thingy.pixel_feeder_inst.row\[11\]\[3\]
+ _0044_ sg13g2_dfrbpq_1
X_4012_ _1659_ _1660_ _1661_ VPWR VGND sg13g2_nor2b_2
XFILLER_37_211 VPWR VGND sg13g2_fill_2
XFILLER_37_200 VPWR VGND sg13g2_fill_1
XFILLER_38_778 VPWR VGND sg13g2_fill_2
XFILLER_19_970 VPWR VGND sg13g2_decap_8
XFILLER_26_907 VPWR VGND sg13g2_fill_1
X_4914_ net697 net742 _0247_ VPWR VGND sg13g2_nor2_1
XFILLER_34_984 VPWR VGND sg13g2_decap_8
XFILLER_21_645 VPWR VGND sg13g2_decap_8
X_4845_ net701 net746 _0180_ VPWR VGND sg13g2_nor2_1
X_4776_ net701 net746 _0111_ VPWR VGND sg13g2_nor2_1
X_3727_ net637 VPWR _1380_ VGND videogen.test_lut_thingy.pixel_feeder_inst.row\[15\]\[1\]
+ net577 sg13g2_o21ai_1
XFILLER_10_1009 VPWR VGND sg13g2_decap_8
X_3658_ videogen.test_lut_thingy.pixel_feeder_inst.row\[48\]\[2\] net602 _1311_ VPWR
+ VGND sg13g2_nor2_1
X_3589_ _1171_ _1239_ _1242_ VPWR VGND sg13g2_nor2_1
X_5328_ net221 VGND VPWR _0656_ serialize.shift_reg_g\[6\] clknet_3_6_0_clk_regs sg13g2_dfrbpq_1
XFILLER_0_538 VPWR VGND sg13g2_decap_8
X_5259_ net167 VGND VPWR _0587_ videogen.test_lut_thingy.pixel_feeder_inst.row\[40\]\[3\]
+ _0216_ sg13g2_dfrbpq_1
X_5266__74 VPWR VGND net74 sg13g2_tiehi
XFILLER_17_907 VPWR VGND sg13g2_decap_8
XFILLER_43_258 VPWR VGND sg13g2_decap_8
XFILLER_25_940 VPWR VGND sg13g2_decap_8
X_5276__386 VPWR VGND net386 sg13g2_tiehi
XFILLER_12_601 VPWR VGND sg13g2_fill_2
XFILLER_19_1012 VPWR VGND sg13g2_decap_8
XFILLER_19_1023 VPWR VGND sg13g2_fill_2
X_5159__184 VPWR VGND net184 sg13g2_tiehi
XFILLER_24_483 VPWR VGND sg13g2_decap_8
XFILLER_40_998 VPWR VGND sg13g2_decap_8
XFILLER_11_155 VPWR VGND sg13g2_decap_8
XFILLER_8_649 VPWR VGND sg13g2_decap_4
X_5283__313 VPWR VGND net313 sg13g2_tiehi
XFILLER_4_888 VPWR VGND sg13g2_decap_8
XFILLER_0_0 VPWR VGND sg13g2_decap_8
XFILLER_26_1027 VPWR VGND sg13g2_fill_2
XFILLER_47_542 VPWR VGND sg13g2_decap_8
XFILLER_47_70 VPWR VGND sg13g2_fill_1
XFILLER_19_233 VPWR VGND sg13g2_fill_2
XFILLER_19_288 VPWR VGND sg13g2_decap_8
X_2960_ videogen.test_lut_thingy.pixel_feeder_inst.row\[8\]\[0\] net808 _0807_ _0464_
+ VPWR VGND sg13g2_mux2_1
XFILLER_16_984 VPWR VGND sg13g2_decap_8
X_2891_ videogen.test_lut_thingy.pixel_feeder_inst.row\[26\]\[1\] net795 _0791_ _0525_
+ VPWR VGND sg13g2_mux2_1
XFILLER_15_483 VPWR VGND sg13g2_fill_1
XFILLER_30_420 VPWR VGND sg13g2_fill_1
XFILLER_31_932 VPWR VGND sg13g2_fill_2
XFILLER_30_442 VPWR VGND sg13g2_fill_2
XFILLER_31_976 VPWR VGND sg13g2_decap_8
X_4630_ _2230_ net662 net472 net667 serialize.tmds_parallel_b\[6\] VPWR VGND sg13g2_a22oi_1
XFILLER_30_486 VPWR VGND sg13g2_fill_1
X_4561_ _2154_ VPWR _2177_ VGND blue\[1\] _2153_ sg13g2_o21ai_1
X_4492_ _2076_ _2095_ net616 _2116_ VPWR VGND sg13g2_nand3_1
XFILLER_7_682 VPWR VGND sg13g2_decap_8
X_3512_ VGND VPWR _1162_ _1163_ _1165_ _1160_ sg13g2_a21oi_1
X_3443_ _1096_ _1089_ _1090_ VPWR VGND sg13g2_nand2_2
X_5113_ net280 VGND VPWR _0441_ videogen.test_lut_thingy.pixel_feeder_inst.row\[30\]\[1\]
+ _0078_ sg13g2_dfrbpq_1
X_3374_ _1027_ _1024_ _1026_ VPWR VGND sg13g2_xnor2_1
XFILLER_33_0 VPWR VGND sg13g2_decap_4
XFILLER_38_531 VPWR VGND sg13g2_fill_1
X_5044_ net390 VGND VPWR _0376_ tmds_red.dc_balancing_reg\[2\] net655 sg13g2_dfrbpq_2
XFILLER_25_258 VPWR VGND sg13g2_decap_4
XFILLER_26_759 VPWR VGND sg13g2_fill_1
XFILLER_43_28 VPWR VGND sg13g2_decap_4
XFILLER_22_954 VPWR VGND sg13g2_decap_8
XFILLER_33_280 VPWR VGND sg13g2_decap_4
XFILLER_21_442 VPWR VGND sg13g2_fill_2
X_4828_ net705 net750 _0163_ VPWR VGND sg13g2_nor2_1
X_4939__149 VPWR VGND net149 sg13g2_tiehi
XFILLER_21_497 VPWR VGND sg13g2_decap_4
X_4759_ net712 net759 _0094_ VPWR VGND sg13g2_nor2_1
XFILLER_5_619 VPWR VGND sg13g2_decap_8
XFILLER_1_825 VPWR VGND sg13g2_decap_8
XFILLER_49_807 VPWR VGND sg13g2_decap_8
XFILLER_0_346 VPWR VGND sg13g2_fill_2
XFILLER_1_1007 VPWR VGND sg13g2_decap_8
XFILLER_29_553 VPWR VGND sg13g2_fill_1
XFILLER_16_236 VPWR VGND sg13g2_decap_8
XFILLER_17_73 VPWR VGND sg13g2_fill_1
XFILLER_44_578 VPWR VGND sg13g2_decap_8
XFILLER_17_84 VPWR VGND sg13g2_fill_2
XFILLER_13_921 VPWR VGND sg13g2_decap_8
X_5006__33 VPWR VGND net33 sg13g2_tiehi
XFILLER_25_792 VPWR VGND sg13g2_decap_8
XFILLER_31_228 VPWR VGND sg13g2_decap_8
XFILLER_9_925 VPWR VGND sg13g2_decap_8
XFILLER_13_998 VPWR VGND sg13g2_decap_8
XFILLER_33_83 VPWR VGND sg13g2_decap_8
XFILLER_8_457 VPWR VGND sg13g2_decap_4
X_5309__78 VPWR VGND net78 sg13g2_tiehi
XFILLER_4_685 VPWR VGND sg13g2_fill_2
XFILLER_3_195 VPWR VGND sg13g2_decap_8
XFILLER_3_173 VPWR VGND sg13g2_decap_4
X_3090_ videogen.fancy_shader.video_x\[4\] _0840_ _0841_ VPWR VGND sg13g2_and2_1
Xhold2 _0666_ VPWR VGND net447 sg13g2_dlygate4sd3_1
XFILLER_48_873 VPWR VGND sg13g2_decap_8
XFILLER_35_523 VPWR VGND sg13g2_fill_2
X_3992_ net2 VPWR _1644_ VGND _1620_ _1643_ sg13g2_o21ai_1
X_2943_ _0803_ net800 _0801_ VPWR VGND sg13g2_nand2_1
XFILLER_30_272 VPWR VGND sg13g2_fill_1
X_2874_ videogen.test_lut_thingy.pixel_feeder_inst.row\[52\]\[3\] net775 _0788_ _0539_
+ VPWR VGND sg13g2_mux2_1
X_4613_ net621 _2220_ _2221_ VPWR VGND sg13g2_nor2_1
X_4544_ net618 _2158_ _2161_ VPWR VGND sg13g2_nor2_1
X_4475_ net605 _2055_ net616 _2100_ VPWR VGND _2094_ sg13g2_nand4_1
X_3426_ _1077_ _1078_ _1079_ VPWR VGND sg13g2_nor2_1
X_3357_ net811 VPWR _1014_ VGND videogen.test_lut_thingy.gol_counter_reg\[0\] videogen.test_lut_thingy.gol_counter_reg\[1\]
+ sg13g2_o21ai_1
X_3288_ _0962_ videogen.fancy_shader.n646\[0\] videogen.fancy_shader.video_x\[0\]
+ VPWR VGND sg13g2_nand2_1
X_5027_ net407 VGND VPWR _0359_ videogen.test_lut_thingy.gol_counter_reg\[2\] net650
+ sg13g2_dfrbpq_1
XFILLER_39_873 VPWR VGND sg13g2_fill_2
XFILLER_26_545 VPWR VGND sg13g2_decap_8
XFILLER_13_206 VPWR VGND sg13g2_fill_2
XFILLER_26_578 VPWR VGND sg13g2_fill_1
XFILLER_26_589 VPWR VGND sg13g2_fill_1
XFILLER_16_1026 VPWR VGND sg13g2_fill_2
XFILLER_10_946 VPWR VGND sg13g2_decap_8
XFILLER_22_773 VPWR VGND sg13g2_decap_8
XFILLER_6_906 VPWR VGND sg13g2_decap_8
X_5210__384 VPWR VGND net384 sg13g2_tiehi
XFILLER_1_677 VPWR VGND sg13g2_fill_1
XFILLER_49_637 VPWR VGND sg13g2_decap_8
XFILLER_0_176 VPWR VGND sg13g2_fill_2
XFILLER_44_320 VPWR VGND sg13g2_fill_2
XFILLER_17_523 VPWR VGND sg13g2_fill_2
XFILLER_17_534 VPWR VGND sg13g2_fill_1
XFILLER_13_773 VPWR VGND sg13g2_decap_4
XFILLER_9_777 VPWR VGND sg13g2_decap_8
XFILLER_5_972 VPWR VGND sg13g2_decap_8
X_4260_ _1904_ _1905_ _1906_ VPWR VGND sg13g2_nor2_1
X_3211_ net811 VPWR _0909_ VGND _0712_ net557 sg13g2_o21ai_1
X_4191_ _1837_ _1834_ _1836_ VPWR VGND sg13g2_nand2_1
X_3142_ _0864_ _0877_ net7 VPWR VGND sg13g2_nor2_1
X_3073_ net784 videogen.test_lut_thingy.pixel_feeder_inst.row\[17\]\[2\] _0830_ _0277_
+ VPWR VGND sg13g2_mux2_1
XFILLER_23_515 VPWR VGND sg13g2_fill_1
XFILLER_35_397 VPWR VGND sg13g2_fill_1
X_3975_ _1627_ _0730_ _0671_ _0699_ _0670_ VPWR VGND sg13g2_a22oi_1
X_2926_ net790 videogen.test_lut_thingy.pixel_feeder_inst.row\[58\]\[1\] _0798_ _0489_
+ VPWR VGND sg13g2_mux2_1
X_2857_ videogen.test_lut_thingy.pixel_feeder_inst.row\[48\]\[0\] net807 _0784_ _0552_
+ VPWR VGND sg13g2_mux2_1
X_2788_ videogen.test_lut_thingy.pixel_feeder_inst.row\[38\]\[3\] net770 _0762_ _0599_
+ VPWR VGND sg13g2_mux2_1
X_4527_ _2145_ tmds_blue.dc_balancing_reg\[1\] _2143_ VPWR VGND sg13g2_xnor2_1
X_4458_ tmds_green.dc_balancing_reg\[2\] _2082_ _2083_ VPWR VGND sg13g2_nor2_1
XFILLER_49_49 VPWR VGND sg13g2_decap_8
Xfanout712 net714 net712 VPWR VGND sg13g2_buf_8
Xfanout723 net726 net723 VPWR VGND sg13g2_buf_1
X_3409_ _1062_ _1042_ VPWR VGND _1037_ sg13g2_nand2b_2
Xfanout701 net703 net701 VPWR VGND sg13g2_buf_8
Xfanout745 net749 net745 VPWR VGND sg13g2_buf_1
Xfanout767 net771 net767 VPWR VGND sg13g2_buf_8
X_4389_ _2027_ _2020_ _2028_ VPWR VGND sg13g2_xor2_1
Xfanout734 net735 net734 VPWR VGND sg13g2_buf_8
Xfanout756 net757 net756 VPWR VGND sg13g2_buf_1
Xfanout789 net793 net789 VPWR VGND sg13g2_buf_8
Xfanout778 net782 net778 VPWR VGND sg13g2_buf_8
XFILLER_27_843 VPWR VGND sg13g2_decap_8
XFILLER_6_703 VPWR VGND sg13g2_decap_8
X_4983__79 VPWR VGND net79 sg13g2_tiehi
XFILLER_22_581 VPWR VGND sg13g2_fill_1
XFILLER_5_246 VPWR VGND sg13g2_decap_8
XFILLER_2_953 VPWR VGND sg13g2_decap_8
XFILLER_49_412 VPWR VGND sg13g2_decap_8
XFILLER_7_1024 VPWR VGND sg13g2_decap_4
XFILLER_45_640 VPWR VGND sg13g2_decap_8
XFILLER_18_865 VPWR VGND sg13g2_decap_8
X_3760_ videogen.test_lut_thingy.pixel_feeder_inst.row\[60\]\[1\] net594 _1413_ VPWR
+ VGND sg13g2_nor2_1
XFILLER_20_529 VPWR VGND sg13g2_decap_8
X_2711_ _0715_ _0716_ _0714_ _0718_ VPWR VGND _0717_ sg13g2_nand4_1
X_3691_ videogen.test_lut_thingy.pixel_feeder_inst.row\[35\]\[2\] net573 _1344_ VPWR
+ VGND sg13g2_nor2_1
X_5292_ net257 VGND VPWR _0620_ serialize.tmds_parallel_b\[5\] net653 sg13g2_dfrbpq_1
XFILLER_5_791 VPWR VGND sg13g2_fill_2
X_4312_ red\[0\] red\[2\] _1953_ VPWR VGND sg13g2_xor2_1
X_4243_ _1877_ VPWR _1889_ VGND _1879_ _1883_ sg13g2_o21ai_1
X_4174_ VGND VPWR _1805_ _1811_ _1820_ _1808_ sg13g2_a21oi_1
X_3125_ _0866_ videogen.test_lut_thingy.pixel_feeder_inst.v_pix\[0\] _0865_ VPWR VGND
+ sg13g2_xnor2_1
X_3056_ _0754_ _0759_ _0827_ VPWR VGND sg13g2_nor2_2
XFILLER_23_323 VPWR VGND sg13g2_fill_2
XFILLER_35_183 VPWR VGND sg13g2_decap_8
XFILLER_24_879 VPWR VGND sg13g2_decap_8
X_3958_ net606 VPWR _1610_ VGND videogen.test_lut_thingy.pixel_feeder_inst.row\[56\]\[0\]
+ net593 sg13g2_o21ai_1
X_3889_ net637 _1536_ _1541_ _1542_ VPWR VGND sg13g2_nor3_1
X_2909_ videogen.test_lut_thingy.pixel_feeder_inst.row\[54\]\[3\] net775 _0795_ _0503_
+ VPWR VGND sg13g2_mux2_1
Xfanout553 _1107_ net553 VPWR VGND sg13g2_buf_8
Xfanout575 net576 net575 VPWR VGND sg13g2_buf_8
Xfanout564 _0739_ net564 VPWR VGND sg13g2_buf_8
XFILLER_47_916 VPWR VGND sg13g2_decap_8
Xfanout597 _0700_ net597 VPWR VGND sg13g2_buf_8
Xfanout586 net591 net586 VPWR VGND sg13g2_buf_8
XFILLER_42_654 VPWR VGND sg13g2_fill_2
XFILLER_42_632 VPWR VGND sg13g2_decap_8
XFILLER_25_62 VPWR VGND sg13g2_decap_8
XFILLER_25_73 VPWR VGND sg13g2_decap_8
XFILLER_6_566 VPWR VGND sg13g2_decap_4
X_5169__164 VPWR VGND net164 sg13g2_tiehi
XFILLER_37_7 VPWR VGND sg13g2_fill_2
XFILLER_49_220 VPWR VGND sg13g2_fill_1
XFILLER_2_11 VPWR VGND sg13g2_decap_8
XFILLER_49_253 VPWR VGND sg13g2_decap_4
XFILLER_2_66 VPWR VGND sg13g2_decap_4
XFILLER_37_437 VPWR VGND sg13g2_decap_4
XFILLER_37_426 VPWR VGND sg13g2_decap_8
XFILLER_46_960 VPWR VGND sg13g2_decap_8
XFILLER_18_651 VPWR VGND sg13g2_decap_4
XFILLER_17_150 VPWR VGND sg13g2_decap_4
X_4930_ net158 VGND VPWR _0263_ clockdiv.q1 clknet_3_0_0_clk_regs sg13g2_dfrbpq_1
XFILLER_33_610 VPWR VGND sg13g2_fill_2
X_4861_ net691 net734 _0196_ VPWR VGND sg13g2_nor2_1
XFILLER_32_131 VPWR VGND sg13g2_fill_1
XFILLER_33_643 VPWR VGND sg13g2_fill_1
XFILLER_20_304 VPWR VGND sg13g2_decap_8
XFILLER_20_315 VPWR VGND sg13g2_fill_2
X_3812_ videogen.test_lut_thingy.pixel_feeder_inst.row\[44\]\[3\] net596 _1465_ VPWR
+ VGND sg13g2_nor2_1
X_4792_ net699 net744 _0127_ VPWR VGND sg13g2_nor2_1
X_3743_ net631 _1390_ _1395_ _1396_ VPWR VGND sg13g2_nor3_1
X_3674_ videogen.test_lut_thingy.pixel_feeder_inst.row\[44\]\[2\] net596 _1327_ VPWR
+ VGND sg13g2_nor2_1
X_5011__437 VPWR VGND net437 sg13g2_tiehi
X_5275_ net416 VGND VPWR _0603_ videogen.test_lut_thingy.pixel_feeder_inst.row\[29\]\[3\]
+ _0232_ sg13g2_dfrbpq_1
X_4226_ VPWR VGND _1869_ _1867_ _1864_ _1859_ _1872_ _1860_ sg13g2_a221oi_1
X_4157_ _1803_ _1769_ _1800_ VPWR VGND sg13g2_xnor2_1
XFILLER_29_938 VPWR VGND sg13g2_fill_2
XFILLER_46_28 VPWR VGND sg13g2_decap_4
X_3108_ net594 net571 _0854_ VPWR VGND sg13g2_and2_1
XFILLER_44_908 VPWR VGND sg13g2_decap_8
X_4088_ _1715_ _1724_ _1735_ _1737_ VPWR VGND sg13g2_or3_1
X_3039_ videogen.test_lut_thingy.pixel_feeder_inst.row\[12\]\[1\] net796 _0823_ _0387_
+ VPWR VGND sg13g2_mux2_1
XFILLER_36_481 VPWR VGND sg13g2_decap_4
XFILLER_23_120 VPWR VGND sg13g2_fill_2
XFILLER_11_304 VPWR VGND sg13g2_fill_2
XFILLER_12_805 VPWR VGND sg13g2_fill_2
XFILLER_23_153 VPWR VGND sg13g2_fill_2
XFILLER_24_698 VPWR VGND sg13g2_decap_8
XFILLER_20_893 VPWR VGND sg13g2_decap_8
XFILLER_2_4 VPWR VGND sg13g2_decap_8
XFILLER_11_97 VPWR VGND sg13g2_fill_1
X_5269__50 VPWR VGND net50 sg13g2_tiehi
XFILLER_47_735 VPWR VGND sg13g2_decap_8
XFILLER_46_212 VPWR VGND sg13g2_fill_2
XFILLER_46_256 VPWR VGND sg13g2_fill_2
XFILLER_15_621 VPWR VGND sg13g2_fill_1
XFILLER_28_982 VPWR VGND sg13g2_decap_8
XFILLER_36_61 VPWR VGND sg13g2_decap_4
XFILLER_43_952 VPWR VGND sg13g2_decap_4
XFILLER_14_131 VPWR VGND sg13g2_fill_1
X_5339__54 VPWR VGND net54 sg13g2_tiehi
X_3390_ _1036_ VPWR _1043_ VGND _1035_ _1037_ sg13g2_o21ai_1
X_5060_ net364 VGND VPWR _0392_ videogen.test_lut_thingy.pixel_feeder_inst.row\[11\]\[2\]
+ _0043_ sg13g2_dfrbpq_1
XFILLER_42_1022 VPWR VGND sg13g2_decap_8
X_4011_ _1044_ VPWR _1660_ VGND _1038_ _1658_ sg13g2_o21ai_1
XFILLER_37_267 VPWR VGND sg13g2_fill_2
X_4913_ net698 net743 _0246_ VPWR VGND sg13g2_nor2_1
XFILLER_20_112 VPWR VGND sg13g2_fill_2
X_4844_ net702 net747 _0179_ VPWR VGND sg13g2_nor2_1
XFILLER_21_624 VPWR VGND sg13g2_fill_2
XFILLER_33_495 VPWR VGND sg13g2_decap_8
X_4775_ net701 net746 _0110_ VPWR VGND sg13g2_nor2_1
XFILLER_20_156 VPWR VGND sg13g2_fill_2
X_3726_ _1375_ _1376_ _1377_ _1378_ _1379_ VPWR VGND sg13g2_nor4_1
XFILLER_20_178 VPWR VGND sg13g2_fill_1
XFILLER_9_190 VPWR VGND sg13g2_fill_2
X_3657_ videogen.test_lut_thingy.pixel_feeder_inst.row\[49\]\[2\] net569 _1310_ VPWR
+ VGND sg13g2_nor2_1
X_3588_ VGND VPWR _1183_ _1240_ _1241_ _1234_ sg13g2_a21oi_1
X_5327_ net229 VGND VPWR _0655_ serialize.shift_reg_g\[5\] clknet_3_4_0_clk_regs sg13g2_dfrbpq_1
XFILLER_0_517 VPWR VGND sg13g2_decap_8
X_5258_ net171 VGND VPWR _0586_ videogen.test_lut_thingy.pixel_feeder_inst.row\[40\]\[2\]
+ _0215_ sg13g2_dfrbpq_1
X_5189_ net76 VGND VPWR _0517_ videogen.test_lut_thingy.pixel_feeder_inst.row\[28\]\[1\]
+ _0146_ sg13g2_dfrbpq_1
X_4209_ _1855_ _1752_ _1655_ VPWR VGND sg13g2_nand2b_1
XFILLER_43_215 VPWR VGND sg13g2_decap_8
XFILLER_24_440 VPWR VGND sg13g2_decap_8
XFILLER_25_996 VPWR VGND sg13g2_decap_8
XFILLER_12_635 VPWR VGND sg13g2_fill_1
XFILLER_11_145 VPWR VGND sg13g2_decap_4
XFILLER_22_52 VPWR VGND sg13g2_decap_4
X_5187__82 VPWR VGND net82 sg13g2_tiehi
XFILLER_4_823 VPWR VGND sg13g2_decap_4
XFILLER_4_867 VPWR VGND sg13g2_decap_8
XFILLER_3_366 VPWR VGND sg13g2_fill_2
XFILLER_26_1006 VPWR VGND sg13g2_decap_8
XFILLER_47_521 VPWR VGND sg13g2_decap_8
XFILLER_19_201 VPWR VGND sg13g2_fill_1
XFILLER_47_598 VPWR VGND sg13g2_decap_8
XFILLER_47_93 VPWR VGND sg13g2_fill_1
XFILLER_16_963 VPWR VGND sg13g2_decap_8
XFILLER_43_782 VPWR VGND sg13g2_fill_2
X_2890_ videogen.test_lut_thingy.pixel_feeder_inst.row\[26\]\[2\] net783 _0791_ _0526_
+ VPWR VGND sg13g2_mux2_1
XFILLER_8_10 VPWR VGND sg13g2_fill_2
X_4560_ _2176_ tmds_blue.dc_balancing_reg\[3\] _2153_ VPWR VGND sg13g2_xnor2_1
XFILLER_8_65 VPWR VGND sg13g2_fill_2
X_5253__195 VPWR VGND net195 sg13g2_tiehi
X_4491_ _2115_ _2112_ _2114_ VPWR VGND sg13g2_xnor2_1
XFILLER_7_672 VPWR VGND sg13g2_fill_2
XFILLER_6_171 VPWR VGND sg13g2_decap_8
X_3511_ _1164_ _1162_ _1163_ VPWR VGND sg13g2_nand2_1
XFILLER_6_193 VPWR VGND sg13g2_fill_1
X_3442_ _1095_ _1092_ _1094_ VPWR VGND sg13g2_nand2_2
X_3373_ videogen.fancy_shader.n646\[2\] videogen.fancy_shader.video_y\[2\] _1026_
+ VPWR VGND sg13g2_xor2_1
X_5112_ net282 VGND VPWR _0440_ videogen.test_lut_thingy.pixel_feeder_inst.row\[30\]\[0\]
+ _0077_ sg13g2_dfrbpq_1
X_5043_ net391 VGND VPWR _0375_ tmds_red.dc_balancing_reg\[1\] net655 sg13g2_dfrbpq_2
XFILLER_19_790 VPWR VGND sg13g2_decap_8
XFILLER_22_933 VPWR VGND sg13g2_decap_8
X_4827_ net705 net750 _0162_ VPWR VGND sg13g2_nor2_1
X_4758_ net714 net758 _0093_ VPWR VGND sg13g2_nor2_1
X_5052__378 VPWR VGND net378 sg13g2_tiehi
X_4689_ net685 net730 _0026_ VPWR VGND sg13g2_nor2_1
X_3709_ net632 _1356_ _1361_ _1362_ VPWR VGND sg13g2_nor3_1
X_5232__279 VPWR VGND net279 sg13g2_tiehi
XFILLER_49_1028 VPWR VGND sg13g2_fill_1
XFILLER_49_1017 VPWR VGND sg13g2_decap_8
XFILLER_0_325 VPWR VGND sg13g2_decap_8
XFILLER_17_52 VPWR VGND sg13g2_fill_2
XFILLER_13_900 VPWR VGND sg13g2_decap_8
XFILLER_9_904 VPWR VGND sg13g2_decap_8
XFILLER_13_977 VPWR VGND sg13g2_decap_8
XFILLER_8_436 VPWR VGND sg13g2_decap_8
XFILLER_33_73 VPWR VGND sg13g2_decap_4
XFILLER_4_664 VPWR VGND sg13g2_decap_8
Xhold3 serialize.shift_reg_c\[4\] VPWR VGND net448 sg13g2_dlygate4sd3_1
XFILLER_0_881 VPWR VGND sg13g2_decap_8
XFILLER_48_852 VPWR VGND sg13g2_decap_8
XFILLER_16_760 VPWR VGND sg13g2_decap_4
X_3991_ _1643_ net625 _1642_ VPWR VGND sg13g2_nand2_1
XFILLER_15_270 VPWR VGND sg13g2_fill_2
XFILLER_16_793 VPWR VGND sg13g2_decap_4
X_2942_ videogen.test_lut_thingy.pixel_feeder_inst.row\[61\]\[1\] net789 _0801_ _0477_
+ VPWR VGND sg13g2_mux2_1
XFILLER_31_730 VPWR VGND sg13g2_decap_8
XFILLER_31_763 VPWR VGND sg13g2_decap_8
X_2873_ _0749_ _0778_ _0788_ VPWR VGND sg13g2_nor2_2
XFILLER_31_774 VPWR VGND sg13g2_fill_2
X_4938__150 VPWR VGND net150 sg13g2_tiehi
X_4612_ tmds_blue.vsync hsync _2220_ VPWR VGND sg13g2_xor2_1
XFILLER_30_295 VPWR VGND sg13g2_decap_4
XFILLER_8_981 VPWR VGND sg13g2_decap_8
X_4543_ _2158_ _2145_ _2160_ VPWR VGND sg13g2_xor2_1
X_4474_ _2090_ _2098_ _2059_ _2099_ VPWR VGND sg13g2_nand3_1
X_3425_ _1078_ videogen.fancy_shader.n646\[6\] videogen.fancy_shader.video_x\[6\]
+ VPWR VGND sg13g2_xnor2_1
XFILLER_38_18 VPWR VGND sg13g2_fill_1
X_3356_ videogen.test_lut_thingy.gol_counter_reg\[0\] net763 _0357_ VPWR VGND sg13g2_nor2_1
X_3287_ _0961_ videogen.fancy_shader.n646\[1\] videogen.fancy_shader.video_x\[1\]
+ VPWR VGND sg13g2_nand2_1
X_5026_ net408 VGND VPWR _0358_ videogen.test_lut_thingy.gol_counter_reg\[1\] net650
+ sg13g2_dfrbpq_2
X_4995__55 VPWR VGND net55 sg13g2_tiehi
XFILLER_16_1005 VPWR VGND sg13g2_decap_8
XFILLER_10_925 VPWR VGND sg13g2_decap_8
XFILLER_5_406 VPWR VGND sg13g2_fill_1
XFILLER_49_616 VPWR VGND sg13g2_decap_8
XFILLER_0_133 VPWR VGND sg13g2_decap_8
XFILLER_48_148 VPWR VGND sg13g2_fill_1
XFILLER_29_395 VPWR VGND sg13g2_fill_1
XFILLER_45_866 VPWR VGND sg13g2_decap_8
XFILLER_45_899 VPWR VGND sg13g2_decap_8
XFILLER_5_951 VPWR VGND sg13g2_decap_8
XFILLER_5_11 VPWR VGND sg13g2_fill_1
XFILLER_4_450 VPWR VGND sg13g2_decap_8
X_3210_ _0712_ net557 _0908_ VPWR VGND sg13g2_nor2_2
X_4190_ _1753_ _1825_ _1836_ VPWR VGND sg13g2_nor2_1
X_3141_ VGND VPWR videogen.test_lut_thingy.pixel_feeder_inst.v_pix\[5\] _0873_ _0877_
+ _0876_ sg13g2_a21oi_1
XFILLER_39_126 VPWR VGND sg13g2_fill_2
X_3072_ net773 videogen.test_lut_thingy.pixel_feeder_inst.row\[17\]\[3\] _0830_ _0278_
+ VPWR VGND sg13g2_mux2_1
XFILLER_36_822 VPWR VGND sg13g2_decap_8
XFILLER_48_693 VPWR VGND sg13g2_decap_8
X_5179__111 VPWR VGND net111 sg13g2_tiehi
X_3974_ net635 VPWR _1626_ VGND videogen.test_lut_thingy.pixel_feeder_inst.row\[47\]\[0\]
+ net574 sg13g2_o21ai_1
X_2925_ net783 videogen.test_lut_thingy.pixel_feeder_inst.row\[58\]\[2\] _0798_ _0490_
+ VPWR VGND sg13g2_mux2_1
X_2856_ videogen.test_lut_thingy.pixel_feeder_inst.row\[48\]\[1\] net797 _0784_ _0553_
+ VPWR VGND sg13g2_mux2_1
X_2787_ _0754_ _0761_ _0762_ VPWR VGND sg13g2_nor2_2
X_4526_ tmds_blue.dc_balancing_reg\[1\] _2143_ _2144_ VPWR VGND sg13g2_nor2_1
XFILLER_49_28 VPWR VGND sg13g2_decap_8
XFILLER_46_1009 VPWR VGND sg13g2_decap_8
X_4457_ _2080_ _2081_ _2082_ VPWR VGND sg13g2_nor2_2
Xfanout713 net714 net713 VPWR VGND sg13g2_buf_8
X_3408_ _1061_ _1058_ _1060_ VPWR VGND sg13g2_nand2_1
Xfanout724 net726 net724 VPWR VGND sg13g2_buf_8
Xfanout702 net703 net702 VPWR VGND sg13g2_buf_1
Xfanout735 net738 net735 VPWR VGND sg13g2_buf_8
Xfanout746 net748 net746 VPWR VGND sg13g2_buf_8
X_4388_ _2025_ _2023_ _2027_ VPWR VGND sg13g2_xor2_1
Xfanout757 net760 net757 VPWR VGND sg13g2_buf_8
X_3339_ net624 _1002_ _1003_ VPWR VGND sg13g2_nor2_1
Xfanout768 net771 net768 VPWR VGND sg13g2_buf_8
Xfanout779 net782 net779 VPWR VGND sg13g2_buf_8
X_5009_ net441 VGND VPWR _0341_ videogen.fancy_shader.n646\[4\] net648 sg13g2_dfrbpq_2
XFILLER_27_822 VPWR VGND sg13g2_decap_8
X_5021__417 VPWR VGND net417 sg13g2_tiehi
XFILLER_42_836 VPWR VGND sg13g2_fill_2
XFILLER_14_549 VPWR VGND sg13g2_decap_8
XFILLER_30_63 VPWR VGND sg13g2_decap_8
XFILLER_2_932 VPWR VGND sg13g2_decap_8
XFILLER_39_50 VPWR VGND sg13g2_decap_8
XFILLER_7_1003 VPWR VGND sg13g2_decap_8
XFILLER_49_468 VPWR VGND sg13g2_decap_8
XFILLER_18_800 VPWR VGND sg13g2_fill_1
XFILLER_36_107 VPWR VGND sg13g2_decap_8
XFILLER_17_321 VPWR VGND sg13g2_decap_8
XFILLER_18_822 VPWR VGND sg13g2_decap_8
XFILLER_36_118 VPWR VGND sg13g2_fill_1
XFILLER_17_343 VPWR VGND sg13g2_fill_2
XFILLER_44_173 VPWR VGND sg13g2_fill_2
XFILLER_33_847 VPWR VGND sg13g2_fill_1
XFILLER_32_324 VPWR VGND sg13g2_fill_2
X_2710_ videogen.fancy_shader.video_x\[6\] net642 _0717_ VPWR VGND sg13g2_nor2_1
XFILLER_13_593 VPWR VGND sg13g2_decap_8
X_3690_ videogen.test_lut_thingy.pixel_feeder_inst.row\[34\]\[2\] net584 _1343_ VPWR
+ VGND sg13g2_nor2_1
XFILLER_9_575 VPWR VGND sg13g2_fill_1
X_4935__153 VPWR VGND net153 sg13g2_tiehi
X_4311_ red\[2\] red\[0\] _1952_ VPWR VGND sg13g2_and2_1
X_5291_ net261 VGND VPWR _0619_ serialize.tmds_parallel_b\[3\] net652 sg13g2_dfrbpq_1
X_4242_ _1881_ _1883_ _1884_ _1888_ VGND VPWR _1887_ sg13g2_nor4_2
X_4173_ _1818_ _1795_ _1819_ VPWR VGND sg13g2_xor2_1
X_3124_ _0704_ net556 _0865_ VPWR VGND sg13g2_nor2b_2
X_3055_ videogen.test_lut_thingy.pixel_feeder_inst.row\[35\]\[0\] net802 _0826_ _0329_
+ VPWR VGND sg13g2_mux2_1
X_5300__217 VPWR VGND net217 sg13g2_tiehi
XFILLER_27_129 VPWR VGND sg13g2_decap_8
XFILLER_35_140 VPWR VGND sg13g2_decap_8
XFILLER_35_162 VPWR VGND sg13g2_decap_8
XFILLER_24_858 VPWR VGND sg13g2_decap_8
X_3957_ net631 _1603_ _1608_ _1609_ VPWR VGND sg13g2_nor3_1
Xclkbuf_0_clk_regs clk_regs clknet_0_clk_regs VPWR VGND sg13g2_buf_8
X_2908_ _0749_ _0761_ _0795_ VPWR VGND sg13g2_nor2_2
X_3888_ _1537_ _1538_ _1539_ _1540_ _1541_ VPWR VGND sg13g2_nor4_1
XFILLER_13_1019 VPWR VGND sg13g2_decap_8
XFILLER_31_390 VPWR VGND sg13g2_decap_4
X_2839_ videogen.test_lut_thingy.pixel_feeder_inst.row\[45\]\[3\] net769 _0781_ _0567_
+ VPWR VGND sg13g2_mux2_1
XFILLER_3_707 VPWR VGND sg13g2_fill_2
X_4509_ VGND VPWR _2123_ _2131_ _2132_ _2063_ sg13g2_a21oi_1
XFILLER_3_729 VPWR VGND sg13g2_decap_8
X_5088__322 VPWR VGND net322 sg13g2_tiehi
Xfanout554 _0720_ net554 VPWR VGND sg13g2_buf_8
Xfanout565 net570 net565 VPWR VGND sg13g2_buf_8
Xfanout576 net580 net576 VPWR VGND sg13g2_buf_8
Xfanout598 net603 net598 VPWR VGND sg13g2_buf_8
Xfanout587 net591 net587 VPWR VGND sg13g2_buf_8
XFILLER_46_427 VPWR VGND sg13g2_decap_8
XFILLER_42_611 VPWR VGND sg13g2_decap_8
XFILLER_27_674 VPWR VGND sg13g2_decap_8
X_5095__315 VPWR VGND net315 sg13g2_tiehi
XFILLER_41_198 VPWR VGND sg13g2_fill_2
XFILLER_10_585 VPWR VGND sg13g2_fill_2
XFILLER_2_740 VPWR VGND sg13g2_fill_2
XFILLER_49_232 VPWR VGND sg13g2_decap_8
XFILLER_2_45 VPWR VGND sg13g2_decap_8
XFILLER_49_298 VPWR VGND sg13g2_decap_8
XFILLER_18_674 VPWR VGND sg13g2_fill_1
X_4860_ net684 net729 _0195_ VPWR VGND sg13g2_nor2_1
X_3811_ videogen.test_lut_thingy.pixel_feeder_inst.row\[45\]\[3\] net563 _1464_ VPWR
+ VGND sg13g2_nor2_1
X_4791_ net679 net724 _0126_ VPWR VGND sg13g2_nor2_1
X_3742_ _1391_ _1392_ _1393_ _1394_ _1395_ VPWR VGND sg13g2_nor4_1
X_3673_ videogen.test_lut_thingy.pixel_feeder_inst.row\[45\]\[2\] net562 _1326_ VPWR
+ VGND sg13g2_nor2_1
X_5274_ net424 VGND VPWR _0602_ videogen.test_lut_thingy.pixel_feeder_inst.row\[29\]\[2\]
+ _0231_ sg13g2_dfrbpq_1
X_4225_ VGND VPWR _1864_ _1869_ _1871_ _1867_ sg13g2_a21oi_1
X_4156_ _1802_ _1770_ _1800_ VPWR VGND sg13g2_xnor2_1
X_5228__295 VPWR VGND net295 sg13g2_tiehi
X_3107_ VGND VPWR net640 net556 net8 net604 sg13g2_a21oi_1
XFILLER_28_438 VPWR VGND sg13g2_decap_4
XFILLER_37_961 VPWR VGND sg13g2_fill_1
X_4087_ _1715_ VPWR _1736_ VGND _1724_ _1735_ sg13g2_o21ai_1
X_3038_ videogen.test_lut_thingy.pixel_feeder_inst.row\[12\]\[2\] net785 _0823_ _0388_
+ VPWR VGND sg13g2_mux2_1
X_4989_ net67 VGND VPWR _0321_ videogen.test_lut_thingy.pixel_feeder_inst.h_counter\[0\]
+ net645 sg13g2_dfrbpq_1
XFILLER_11_10 VPWR VGND sg13g2_decap_4
XFILLER_3_504 VPWR VGND sg13g2_decap_4
XFILLER_11_43 VPWR VGND sg13g2_fill_2
XFILLER_47_703 VPWR VGND sg13g2_fill_1
XFILLER_46_224 VPWR VGND sg13g2_fill_2
XFILLER_46_202 VPWR VGND sg13g2_fill_2
XFILLER_4_1028 VPWR VGND sg13g2_fill_1
XFILLER_19_427 VPWR VGND sg13g2_decap_8
XFILLER_46_235 VPWR VGND sg13g2_decap_8
X_5103__300 VPWR VGND net300 sg13g2_tiehi
XFILLER_28_961 VPWR VGND sg13g2_decap_8
XFILLER_46_268 VPWR VGND sg13g2_decap_8
XFILLER_27_493 VPWR VGND sg13g2_decap_4
XFILLER_43_986 VPWR VGND sg13g2_decap_8
XFILLER_42_485 VPWR VGND sg13g2_decap_8
XFILLER_11_872 VPWR VGND sg13g2_fill_2
XFILLER_6_342 VPWR VGND sg13g2_fill_2
XFILLER_10_393 VPWR VGND sg13g2_decap_4
XFILLER_7_898 VPWR VGND sg13g2_decap_8
XFILLER_6_364 VPWR VGND sg13g2_fill_1
X_4932__156 VPWR VGND net156 sg13g2_tiehi
XFILLER_42_1001 VPWR VGND sg13g2_decap_8
XFILLER_2_570 VPWR VGND sg13g2_fill_1
XFILLER_2_581 VPWR VGND sg13g2_fill_1
X_4010_ _1062_ _1658_ _1659_ VPWR VGND sg13g2_nor2_1
XFILLER_45_290 VPWR VGND sg13g2_decap_8
X_4912_ net695 net743 _0245_ VPWR VGND sg13g2_nor2_1
X_4843_ net702 net747 _0178_ VPWR VGND sg13g2_nor2_1
X_4774_ net701 net746 _0109_ VPWR VGND sg13g2_nor2_1
X_3725_ videogen.test_lut_thingy.pixel_feeder_inst.row\[11\]\[1\] net578 _1378_ VPWR
+ VGND sg13g2_nor2_1
X_3656_ videogen.test_lut_thingy.pixel_feeder_inst.row\[51\]\[2\] net579 _1309_ VPWR
+ VGND sg13g2_nor2_1
X_3587_ _1238_ _1237_ _1172_ _1240_ VPWR VGND sg13g2_a21o_1
X_5326_ net277 VGND VPWR _0654_ serialize.shift_reg_g\[4\] clknet_3_7_0_clk_regs sg13g2_dfrbpq_1
X_5257_ net175 VGND VPWR _0585_ videogen.test_lut_thingy.pixel_feeder_inst.row\[40\]\[1\]
+ _0214_ sg13g2_dfrbpq_1
X_4208_ _1854_ _1655_ _1752_ VPWR VGND sg13g2_nand2b_1
X_5188_ net80 VGND VPWR _0516_ videogen.test_lut_thingy.pixel_feeder_inst.row\[28\]\[0\]
+ _0145_ sg13g2_dfrbpq_1
X_4139_ _1785_ _1100_ _1784_ VPWR VGND sg13g2_xnor2_1
XFILLER_28_224 VPWR VGND sg13g2_decap_8
XFILLER_28_257 VPWR VGND sg13g2_decap_8
XFILLER_25_975 VPWR VGND sg13g2_decap_8
X_5092__318 VPWR VGND net318 sg13g2_tiehi
XFILLER_40_956 VPWR VGND sg13g2_fill_1
X_5317__363 VPWR VGND net363 sg13g2_tiehi
XFILLER_11_135 VPWR VGND sg13g2_decap_4
XFILLER_22_64 VPWR VGND sg13g2_decap_8
XFILLER_22_75 VPWR VGND sg13g2_fill_2
XFILLER_3_334 VPWR VGND sg13g2_decap_8
XFILLER_3_378 VPWR VGND sg13g2_decap_8
XFILLER_47_500 VPWR VGND sg13g2_decap_8
XFILLER_19_213 VPWR VGND sg13g2_decap_8
XFILLER_19_246 VPWR VGND sg13g2_decap_8
XFILLER_35_706 VPWR VGND sg13g2_fill_1
XFILLER_47_577 VPWR VGND sg13g2_decap_8
XFILLER_16_942 VPWR VGND sg13g2_decap_8
XFILLER_34_238 VPWR VGND sg13g2_decap_8
XFILLER_42_282 VPWR VGND sg13g2_decap_8
XFILLER_42_271 VPWR VGND sg13g2_fill_1
XFILLER_30_444 VPWR VGND sg13g2_fill_1
X_3510_ _1126_ _1136_ _1161_ _1163_ VPWR VGND sg13g2_or3_1
X_4490_ _2114_ net605 _2113_ VPWR VGND sg13g2_xnor2_1
XFILLER_10_190 VPWR VGND sg13g2_fill_1
X_3441_ _1072_ _1088_ _1070_ _1094_ VPWR VGND sg13g2_nand3_1
X_3372_ videogen.fancy_shader.video_y\[2\] videogen.fancy_shader.n646\[2\] _1025_
+ VPWR VGND sg13g2_and2_1
X_5111_ net284 VGND VPWR _0439_ videogen.test_lut_thingy.pixel_feeder_inst.row\[34\]\[3\]
+ _0076_ sg13g2_dfrbpq_1
XFILLER_3_890 VPWR VGND sg13g2_decap_8
X_5042_ net392 VGND VPWR _0374_ red\[7\] net656 sg13g2_dfrbpq_2
XFILLER_26_728 VPWR VGND sg13g2_fill_2
XFILLER_22_912 VPWR VGND sg13g2_decap_8
XFILLER_33_271 VPWR VGND sg13g2_decap_4
XFILLER_21_444 VPWR VGND sg13g2_fill_1
X_4826_ net706 net750 _0161_ VPWR VGND sg13g2_nor2_1
XFILLER_21_477 VPWR VGND sg13g2_decap_4
XFILLER_22_989 VPWR VGND sg13g2_decap_8
X_4757_ net674 net720 _0092_ VPWR VGND sg13g2_nor2_1
X_4688_ net685 net730 _0025_ VPWR VGND sg13g2_nor2_1
X_3708_ _1357_ _1358_ _1359_ _1360_ _1361_ VPWR VGND sg13g2_nor4_1
X_3639_ videogen.test_lut_thingy.pixel_feeder_inst.row\[10\]\[2\] net589 _1292_ VPWR
+ VGND sg13g2_nor2_1
XFILLER_1_805 VPWR VGND sg13g2_fill_1
X_5309_ net78 VGND VPWR _0637_ videogen.test_lut_thingy.pixel_feeder_inst.row\[22\]\[3\]
+ _0256_ sg13g2_dfrbpq_1
XFILLER_0_348 VPWR VGND sg13g2_fill_1
XFILLER_17_86 VPWR VGND sg13g2_fill_1
XFILLER_13_956 VPWR VGND sg13g2_decap_8
XFILLER_8_415 VPWR VGND sg13g2_decap_8
XFILLER_32_1022 VPWR VGND sg13g2_fill_2
XFILLER_33_63 VPWR VGND sg13g2_fill_1
X_5287__281 VPWR VGND net281 sg13g2_tiehi
X_5068__353 VPWR VGND net353 sg13g2_tiehi
Xhold4 _0281_ VPWR VGND net449 sg13g2_dlygate4sd3_1
XFILLER_0_860 VPWR VGND sg13g2_decap_8
XFILLER_48_831 VPWR VGND sg13g2_decap_8
XFILLER_35_525 VPWR VGND sg13g2_fill_1
X_3990_ _1641_ VPWR _1642_ VGND _1625_ _1629_ sg13g2_o21ai_1
X_2941_ _0802_ VPWR _0478_ VGND _0672_ _0801_ sg13g2_o21ai_1
X_2872_ videogen.test_lut_thingy.pixel_feeder_inst.row\[51\]\[0\] net809 _0787_ _0540_
+ VPWR VGND sg13g2_mux2_1
X_4611_ VGND VPWR net619 net621 _0623_ _2213_ sg13g2_a21oi_1
XFILLER_8_960 VPWR VGND sg13g2_decap_8
X_4542_ _2158_ _2145_ _2159_ VPWR VGND sg13g2_nor2b_1
X_4473_ _2097_ VPWR _2098_ VGND _2094_ _2096_ sg13g2_o21ai_1
X_3424_ _1077_ videogen.fancy_shader.n646\[7\] videogen.fancy_shader.video_x\[7\]
+ VPWR VGND sg13g2_xnor2_1
X_3355_ _0999_ _1013_ _0356_ VPWR VGND sg13g2_nor2_1
XFILLER_39_820 VPWR VGND sg13g2_decap_8
X_3286_ _0340_ net812 _0959_ _0960_ VPWR VGND sg13g2_and3_1
X_5025_ net409 VGND VPWR _0357_ videogen.test_lut_thingy.gol_counter_reg\[0\] net650
+ sg13g2_dfrbpq_2
XFILLER_38_352 VPWR VGND sg13g2_fill_2
XFILLER_38_374 VPWR VGND sg13g2_fill_1
XFILLER_22_742 VPWR VGND sg13g2_fill_1
XFILLER_10_904 VPWR VGND sg13g2_decap_8
XFILLER_16_1028 VPWR VGND sg13g2_fill_1
X_4809_ net690 net735 _0144_ VPWR VGND sg13g2_nor2_1
XFILLER_0_112 VPWR VGND sg13g2_decap_8
X_5321__326 VPWR VGND net326 sg13g2_tiehi
XFILLER_0_189 VPWR VGND sg13g2_decap_8
XFILLER_29_363 VPWR VGND sg13g2_decap_8
XFILLER_45_845 VPWR VGND sg13g2_decap_8
XFILLER_44_322 VPWR VGND sg13g2_fill_1
XFILLER_17_525 VPWR VGND sg13g2_fill_1
XFILLER_29_374 VPWR VGND sg13g2_fill_1
XFILLER_45_878 VPWR VGND sg13g2_decap_8
XFILLER_44_399 VPWR VGND sg13g2_fill_1
XFILLER_44_40 VPWR VGND sg13g2_fill_2
XFILLER_9_702 VPWR VGND sg13g2_decap_4
XFILLER_8_234 VPWR VGND sg13g2_fill_2
XFILLER_5_930 VPWR VGND sg13g2_decap_8
X_5111__284 VPWR VGND net284 sg13g2_tiehi
XFILLER_5_78 VPWR VGND sg13g2_decap_8
XFILLER_4_473 VPWR VGND sg13g2_fill_2
X_3140_ _0863_ VPWR _0876_ VGND videogen.test_lut_thingy.pixel_feeder_inst.v_pix\[5\]
+ _0873_ sg13g2_o21ai_1
XFILLER_48_672 VPWR VGND sg13g2_decap_8
X_3071_ _0830_ _0728_ _0750_ VPWR VGND sg13g2_nand2_2
XFILLER_47_193 VPWR VGND sg13g2_fill_2
XFILLER_39_1028 VPWR VGND sg13g2_fill_1
X_2691__1 VPWR net445 clknet_1_0__leaf_clk VGND sg13g2_inv_1
X_3973_ _1621_ _1622_ _1623_ _1624_ _1625_ VPWR VGND sg13g2_nor4_1
X_2924_ net772 videogen.test_lut_thingy.pixel_feeder_inst.row\[58\]\[3\] _0798_ _0491_
+ VPWR VGND sg13g2_mux2_1
X_2855_ videogen.test_lut_thingy.pixel_feeder_inst.row\[48\]\[2\] net786 _0784_ _0554_
+ VPWR VGND sg13g2_mux2_1
X_2786_ VGND VPWR _0761_ _0735_ net604 sg13g2_or2_1
X_4525_ blue\[7\] blue\[1\] _2143_ VPWR VGND sg13g2_xor2_1
X_4456_ net615 green\[7\] green\[6\] _2081_ VPWR VGND sg13g2_nor3_1
Xfanout714 net715 net714 VPWR VGND sg13g2_buf_8
X_3407_ VGND VPWR _1060_ _1059_ _1054_ sg13g2_or2_1
Xfanout703 net704 net703 VPWR VGND sg13g2_buf_8
X_4387_ _2026_ _2025_ _2023_ VPWR VGND sg13g2_nand2b_1
Xfanout736 net737 net736 VPWR VGND sg13g2_buf_8
Xfanout758 net760 net758 VPWR VGND sg13g2_buf_8
Xfanout747 net748 net747 VPWR VGND sg13g2_buf_1
X_3338_ net763 _1001_ _1002_ _0350_ VPWR VGND sg13g2_nor3_1
Xfanout725 net726 net725 VPWR VGND sg13g2_buf_8
Xfanout769 net771 net769 VPWR VGND sg13g2_buf_8
X_3269_ _0946_ _0948_ _0949_ _0322_ VPWR VGND sg13g2_nor3_1
XFILLER_22_1010 VPWR VGND sg13g2_decap_8
Xclkbuf_3_0_0_clk_regs clknet_0_clk_regs clknet_3_0_0_clk_regs VPWR VGND sg13g2_buf_8
X_5008_ net443 VGND VPWR _0340_ videogen.fancy_shader.n646\[3\] net655 sg13g2_dfrbpq_2
XFILLER_14_539 VPWR VGND sg13g2_decap_4
XFILLER_41_325 VPWR VGND sg13g2_fill_1
XFILLER_10_701 VPWR VGND sg13g2_decap_4
XFILLER_22_550 VPWR VGND sg13g2_fill_1
XFILLER_22_561 VPWR VGND sg13g2_decap_8
XFILLER_22_572 VPWR VGND sg13g2_fill_1
XFILLER_14_98 VPWR VGND sg13g2_fill_2
XFILLER_5_237 VPWR VGND sg13g2_fill_1
XFILLER_2_911 VPWR VGND sg13g2_decap_8
XFILLER_2_988 VPWR VGND sg13g2_decap_8
XFILLER_49_447 VPWR VGND sg13g2_decap_8
XFILLER_1_487 VPWR VGND sg13g2_decap_8
XFILLER_45_664 VPWR VGND sg13g2_fill_2
XFILLER_45_653 VPWR VGND sg13g2_decap_8
XFILLER_32_303 VPWR VGND sg13g2_fill_2
XFILLER_32_347 VPWR VGND sg13g2_fill_2
X_5217__348 VPWR VGND net348 sg13g2_tiehi
XFILLER_9_554 VPWR VGND sg13g2_decap_8
XFILLER_9_587 VPWR VGND sg13g2_fill_2
X_4982__81 VPWR VGND net81 sg13g2_tiehi
X_4310_ _1948_ _1951_ _1946_ _0374_ VPWR VGND sg13g2_nand3_1
X_5290_ net265 VGND VPWR _0618_ blue_tmds_par\[2\] net652 sg13g2_dfrbpq_1
X_4241_ _1887_ _1877_ _1886_ VPWR VGND sg13g2_nand2b_1
X_4172_ _1801_ VPWR _1818_ VGND _1803_ _1812_ sg13g2_o21ai_1
X_3123_ net613 VPWR _0864_ VGND _0856_ _0863_ sg13g2_o21ai_1
X_3054_ videogen.test_lut_thingy.pixel_feeder_inst.row\[35\]\[1\] net791 _0826_ _0330_
+ VPWR VGND sg13g2_mux2_1
XFILLER_36_653 VPWR VGND sg13g2_fill_2
X_3956_ _1604_ _1605_ _1606_ _1607_ _1608_ VPWR VGND sg13g2_nor4_1
X_2907_ net807 videogen.test_lut_thingy.pixel_feeder_inst.row\[55\]\[0\] _0794_ _0504_
+ VPWR VGND sg13g2_mux2_1
X_3887_ videogen.test_lut_thingy.pixel_feeder_inst.row\[2\]\[3\] net588 _1540_ VPWR
+ VGND sg13g2_nor2_1
X_2838_ _0759_ _0770_ _0781_ VPWR VGND sg13g2_nor2_2
X_2769_ _0753_ _0755_ net555 _0756_ VPWR VGND sg13g2_nand3_1
X_4508_ _2131_ _2128_ _2130_ VPWR VGND sg13g2_xnor2_1
X_4439_ VGND VPWR _1958_ _1996_ _0398_ _2070_ sg13g2_a21oi_1
Xfanout555 _0727_ net555 VPWR VGND sg13g2_buf_8
Xfanout566 net570 net566 VPWR VGND sg13g2_buf_2
XFILLER_19_609 VPWR VGND sg13g2_fill_1
Xfanout599 net603 net599 VPWR VGND sg13g2_buf_2
Xfanout588 net591 net588 VPWR VGND sg13g2_buf_8
Xfanout577 net580 net577 VPWR VGND sg13g2_buf_8
XFILLER_39_491 VPWR VGND sg13g2_decap_4
XFILLER_26_141 VPWR VGND sg13g2_fill_1
XFILLER_42_656 VPWR VGND sg13g2_fill_1
XFILLER_41_111 VPWR VGND sg13g2_fill_1
XFILLER_14_325 VPWR VGND sg13g2_decap_8
XFILLER_25_31 VPWR VGND sg13g2_decap_4
XFILLER_26_174 VPWR VGND sg13g2_fill_1
XFILLER_41_177 VPWR VGND sg13g2_decap_8
XFILLER_23_881 VPWR VGND sg13g2_decap_8
XFILLER_6_502 VPWR VGND sg13g2_decap_8
XFILLER_10_542 VPWR VGND sg13g2_fill_2
XFILLER_29_1027 VPWR VGND sg13g2_fill_2
XFILLER_37_9 VPWR VGND sg13g2_fill_1
XFILLER_49_288 VPWR VGND sg13g2_fill_2
XFILLER_46_995 VPWR VGND sg13g2_decap_8
XFILLER_45_461 VPWR VGND sg13g2_fill_1
XFILLER_33_612 VPWR VGND sg13g2_fill_1
XFILLER_18_697 VPWR VGND sg13g2_decap_8
X_4790_ net699 net744 _0125_ VPWR VGND sg13g2_nor2_1
X_3810_ videogen.test_lut_thingy.pixel_feeder_inst.row\[47\]\[3\] net574 _1463_ VPWR
+ VGND sg13g2_nor2_1
XFILLER_20_328 VPWR VGND sg13g2_decap_8
X_3741_ videogen.test_lut_thingy.pixel_feeder_inst.row\[3\]\[1\] net577 _1394_ VPWR
+ VGND sg13g2_nor2_1
X_3672_ net630 VPWR _1325_ VGND videogen.test_lut_thingy.pixel_feeder_inst.row\[46\]\[2\]
+ net584 sg13g2_o21ai_1
XFILLER_49_0 VPWR VGND sg13g2_decap_8
X_5273_ net432 VGND VPWR _0601_ videogen.test_lut_thingy.pixel_feeder_inst.row\[29\]\[1\]
+ _0230_ sg13g2_dfrbpq_1
X_4224_ VGND VPWR _1866_ _1869_ _1870_ _1865_ sg13g2_a21oi_1
X_4155_ VGND VPWR _1801_ _1800_ _1769_ sg13g2_or2_1
XFILLER_28_406 VPWR VGND sg13g2_decap_8
X_3106_ _0836_ _0833_ net614 videogen.mem_row VPWR VGND sg13g2_a21o_2
X_4086_ VPWR VGND _1731_ _1656_ _1723_ _1716_ _1735_ _1720_ sg13g2_a221oi_1
X_3037_ videogen.test_lut_thingy.pixel_feeder_inst.row\[12\]\[3\] net774 _0823_ _0389_
+ VPWR VGND sg13g2_mux2_1
XFILLER_36_450 VPWR VGND sg13g2_decap_8
XFILLER_23_122 VPWR VGND sg13g2_fill_1
XFILLER_24_634 VPWR VGND sg13g2_decap_4
X_4988_ net69 VGND VPWR _0320_ videogen.test_lut_thingy.pixel_feeder_inst.v_counter\[3\]
+ net644 sg13g2_dfrbpq_1
X_3939_ net612 VPWR _1591_ VGND videogen.test_lut_thingy.pixel_feeder_inst.row\[20\]\[0\]
+ net593 sg13g2_o21ai_1
X_5235__267 VPWR VGND net267 sg13g2_tiehi
XFILLER_11_55 VPWR VGND sg13g2_decap_8
XFILLER_11_66 VPWR VGND sg13g2_fill_1
XFILLER_11_88 VPWR VGND sg13g2_decap_8
XFILLER_4_1007 VPWR VGND sg13g2_decap_8
XFILLER_14_100 VPWR VGND sg13g2_fill_1
XFILLER_36_74 VPWR VGND sg13g2_decap_8
XFILLER_43_965 VPWR VGND sg13g2_decap_8
XFILLER_42_475 VPWR VGND sg13g2_fill_2
XFILLER_7_833 VPWR VGND sg13g2_decap_8
XFILLER_7_877 VPWR VGND sg13g2_decap_8
XFILLER_6_321 VPWR VGND sg13g2_decap_8
XFILLER_19_984 VPWR VGND sg13g2_decap_8
X_4911_ _2211_ _2212_ _0620_ VPWR VGND sg13g2_nor2_1
X_5078__333 VPWR VGND net333 sg13g2_tiehi
XFILLER_34_965 VPWR VGND sg13g2_decap_4
XFILLER_20_114 VPWR VGND sg13g2_fill_1
X_4842_ net702 net747 _0177_ VPWR VGND sg13g2_nor2_1
XFILLER_21_626 VPWR VGND sg13g2_fill_1
XFILLER_34_998 VPWR VGND sg13g2_decap_8
X_4773_ net675 net719 _0108_ VPWR VGND sg13g2_nor2_1
XFILLER_20_136 VPWR VGND sg13g2_fill_2
X_3724_ videogen.test_lut_thingy.pixel_feeder_inst.row\[10\]\[1\] net589 _1377_ VPWR
+ VGND sg13g2_nor2_1
X_3655_ net611 VPWR _1308_ VGND videogen.test_lut_thingy.pixel_feeder_inst.row\[50\]\[2\]
+ net590 sg13g2_o21ai_1
X_3586_ _1239_ _1237_ _1238_ _1235_ _1229_ VPWR VGND sg13g2_a22oi_1
X_5325_ net285 VGND VPWR _0653_ serialize.shift_reg_g\[3\] clknet_3_4_0_clk_regs sg13g2_dfrbpq_1
X_5256_ net179 VGND VPWR _0584_ videogen.test_lut_thingy.pixel_feeder_inst.row\[40\]\[0\]
+ _0213_ sg13g2_dfrbpq_1
X_4207_ _1852_ _1850_ _1182_ _1853_ VPWR VGND sg13g2_a21o_1
XFILLER_29_704 VPWR VGND sg13g2_decap_8
X_5187_ net82 VGND VPWR _0515_ tmds_blue.dc_balancing_reg\[4\] net653 sg13g2_dfrbpq_2
XFILLER_28_203 VPWR VGND sg13g2_decap_8
X_4138_ _1784_ _1765_ _1767_ VPWR VGND sg13g2_xnor2_1
XFILLER_44_707 VPWR VGND sg13g2_fill_2
X_4069_ _1706_ VPWR _1718_ VGND _1703_ _1710_ sg13g2_o21ai_1
XFILLER_24_420 VPWR VGND sg13g2_fill_1
XFILLER_25_954 VPWR VGND sg13g2_decap_8
XFILLER_11_114 VPWR VGND sg13g2_decap_8
XFILLER_24_464 VPWR VGND sg13g2_fill_2
XFILLER_24_497 VPWR VGND sg13g2_decap_8
XFILLER_8_608 VPWR VGND sg13g2_decap_8
XFILLER_7_129 VPWR VGND sg13g2_fill_2
X_4955__124 VPWR VGND net124 sg13g2_tiehi
XFILLER_11_169 VPWR VGND sg13g2_fill_2
XFILLER_3_346 VPWR VGND sg13g2_fill_2
XFILLER_47_556 VPWR VGND sg13g2_decap_8
XFILLER_19_225 VPWR VGND sg13g2_fill_2
XFILLER_47_84 VPWR VGND sg13g2_decap_8
XFILLER_16_921 VPWR VGND sg13g2_decap_8
XFILLER_43_740 VPWR VGND sg13g2_fill_2
XFILLER_15_453 VPWR VGND sg13g2_fill_1
XFILLER_43_784 VPWR VGND sg13g2_fill_1
XFILLER_16_998 VPWR VGND sg13g2_decap_8
XFILLER_31_913 VPWR VGND sg13g2_decap_8
XFILLER_30_456 VPWR VGND sg13g2_fill_1
XFILLER_8_67 VPWR VGND sg13g2_fill_1
XFILLER_8_78 VPWR VGND sg13g2_decap_8
XFILLER_7_652 VPWR VGND sg13g2_decap_8
X_5329__213 VPWR VGND net213 sg13g2_tiehi
XFILLER_7_696 VPWR VGND sg13g2_decap_8
XFILLER_6_184 VPWR VGND sg13g2_decap_8
X_3440_ _1093_ _1070_ _1072_ _1088_ VPWR VGND sg13g2_and3_1
X_3371_ _1021_ VPWR _1024_ VGND _1022_ _1023_ sg13g2_o21ai_1
X_5110_ net286 VGND VPWR _0438_ videogen.test_lut_thingy.pixel_feeder_inst.row\[34\]\[2\]
+ _0075_ sg13g2_dfrbpq_1
X_5041_ net393 VGND VPWR _0373_ red\[6\] net656 sg13g2_dfrbpq_2
XFILLER_19_770 VPWR VGND sg13g2_decap_8
X_5121__264 VPWR VGND net264 sg13g2_tiehi
XFILLER_21_401 VPWR VGND sg13g2_decap_4
X_4825_ net699 net744 _0160_ VPWR VGND sg13g2_nor2_1
XFILLER_22_968 VPWR VGND sg13g2_decap_8
X_4756_ net674 net719 _0091_ VPWR VGND sg13g2_nor2_1
X_3707_ net608 VPWR _1360_ VGND videogen.test_lut_thingy.pixel_feeder_inst.row\[18\]\[1\]
+ net586 sg13g2_o21ai_1
X_4687_ net683 net728 _0024_ VPWR VGND sg13g2_nor2_1
X_3638_ videogen.test_lut_thingy.pixel_feeder_inst.row\[9\]\[2\] net568 _1291_ VPWR
+ VGND sg13g2_nor2_1
X_3569_ _1221_ _1220_ _1209_ _1222_ VPWR VGND sg13g2_a21o_1
X_5308_ net121 VGND VPWR _0636_ videogen.test_lut_thingy.pixel_feeder_inst.row\[22\]\[2\]
+ _0255_ sg13g2_dfrbpq_1
XFILLER_1_839 VPWR VGND sg13g2_decap_8
X_5239_ net251 VGND VPWR _0567_ videogen.test_lut_thingy.pixel_feeder_inst.row\[45\]\[3\]
+ _0196_ sg13g2_dfrbpq_1
XFILLER_17_32 VPWR VGND sg13g2_fill_2
XFILLER_13_935 VPWR VGND sg13g2_decap_8
XFILLER_24_272 VPWR VGND sg13g2_fill_2
XFILLER_9_939 VPWR VGND sg13g2_decap_8
XFILLER_32_1001 VPWR VGND sg13g2_decap_8
XFILLER_8_449 VPWR VGND sg13g2_decap_4
XFILLER_33_97 VPWR VGND sg13g2_decap_4
XFILLER_3_154 VPWR VGND sg13g2_fill_2
XFILLER_3_143 VPWR VGND sg13g2_fill_1
XFILLER_48_810 VPWR VGND sg13g2_decap_8
Xhold5 serialize.bit_cnt\[0\] VPWR VGND net450 sg13g2_dlygate4sd3_1
XFILLER_48_887 VPWR VGND sg13g2_decap_8
XFILLER_47_353 VPWR VGND sg13g2_fill_2
X_2940_ _0802_ net778 _0801_ VPWR VGND sg13g2_nand2_1
XFILLER_31_721 VPWR VGND sg13g2_decap_4
X_2871_ videogen.test_lut_thingy.pixel_feeder_inst.row\[51\]\[1\] net797 _0787_ _0541_
+ VPWR VGND sg13g2_mux2_1
XFILLER_31_787 VPWR VGND sg13g2_decap_8
X_4610_ VGND VPWR net620 _2219_ _0622_ _2212_ sg13g2_a21oi_1
X_4541_ _2157_ _2155_ _2158_ VPWR VGND sg13g2_xor2_1
X_4472_ VGND VPWR _2094_ _2096_ _2097_ _2063_ sg13g2_a21oi_1
XFILLER_7_471 VPWR VGND sg13g2_decap_8
X_3423_ VGND VPWR _0679_ _0687_ _1076_ _1075_ sg13g2_a21oi_1
X_3354_ _1013_ videogen.fancy_shader.video_y\[9\] _1011_ VPWR VGND sg13g2_xnor2_1
XFILLER_31_0 VPWR VGND sg13g2_decap_8
X_3285_ _0960_ videogen.fancy_shader.n646\[3\] _0958_ VPWR VGND sg13g2_nand2_1
X_5024_ net411 VGND VPWR _0356_ videogen.fancy_shader.video_y\[9\] net647 sg13g2_dfrbpq_2
XFILLER_0_1021 VPWR VGND sg13g2_decap_8
XFILLER_26_559 VPWR VGND sg13g2_decap_4
XFILLER_22_710 VPWR VGND sg13g2_fill_2
XFILLER_22_754 VPWR VGND sg13g2_decap_8
XFILLER_34_592 VPWR VGND sg13g2_fill_1
XFILLER_22_787 VPWR VGND sg13g2_decap_8
XFILLER_21_286 VPWR VGND sg13g2_decap_8
XFILLER_21_297 VPWR VGND sg13g2_fill_2
X_5003__39 VPWR VGND net39 sg13g2_tiehi
X_4808_ net690 net735 _0143_ VPWR VGND sg13g2_nor2_1
X_4739_ net686 net731 _0074_ VPWR VGND sg13g2_nor2_1
XFILLER_28_20 VPWR VGND sg13g2_fill_2
XFILLER_17_504 VPWR VGND sg13g2_decap_8
XFILLER_45_824 VPWR VGND sg13g2_fill_1
XFILLER_29_386 VPWR VGND sg13g2_decap_8
XFILLER_13_710 VPWR VGND sg13g2_fill_1
XFILLER_44_96 VPWR VGND sg13g2_fill_2
XFILLER_44_74 VPWR VGND sg13g2_decap_4
XFILLER_13_732 VPWR VGND sg13g2_decap_8
XFILLER_8_246 VPWR VGND sg13g2_decap_8
XFILLER_8_279 VPWR VGND sg13g2_decap_4
XFILLER_5_986 VPWR VGND sg13g2_decap_8
X_3070_ net805 videogen.test_lut_thingy.pixel_feeder_inst.row\[18\]\[0\] _0829_ _0286_
+ VPWR VGND sg13g2_mux2_1
XFILLER_48_662 VPWR VGND sg13g2_decap_4
XFILLER_47_161 VPWR VGND sg13g2_decap_8
XFILLER_47_150 VPWR VGND sg13g2_fill_1
XFILLER_39_1007 VPWR VGND sg13g2_decap_8
X_3972_ videogen.test_lut_thingy.pixel_feeder_inst.row\[40\]\[0\] net596 _1624_ VPWR
+ VGND sg13g2_nor2_1
XFILLER_16_581 VPWR VGND sg13g2_decap_8
X_2923_ _0763_ _0773_ net614 _0798_ VPWR VGND sg13g2_nand3_1
X_2854_ videogen.test_lut_thingy.pixel_feeder_inst.row\[48\]\[3\] net775 _0784_ _0555_
+ VPWR VGND sg13g2_mux2_1
X_2785_ videogen.test_lut_thingy.pixel_feeder_inst.row\[29\]\[0\] net800 _0760_ _0600_
+ VPWR VGND sg13g2_mux2_1
X_4524_ _2142_ net618 _2140_ VPWR VGND sg13g2_nand2_2
XFILLER_8_780 VPWR VGND sg13g2_fill_2
X_4455_ VPWR _2080_ _2079_ VGND sg13g2_inv_1
X_3406_ _1059_ videogen.fancy_shader.n646\[6\] videogen.fancy_shader.video_y\[6\]
+ videogen.fancy_shader.n646\[7\] videogen.fancy_shader.video_y\[7\] VPWR VGND sg13g2_a22oi_1
Xfanout704 net716 net704 VPWR VGND sg13g2_buf_8
X_4386_ _1998_ VPWR _2025_ VGND _1986_ _1989_ sg13g2_o21ai_1
Xfanout715 net716 net715 VPWR VGND sg13g2_buf_8
Xfanout737 net738 net737 VPWR VGND sg13g2_buf_8
Xfanout748 net749 net748 VPWR VGND sg13g2_buf_8
X_3337_ _0857_ _0859_ _0888_ _1002_ VPWR VGND sg13g2_nor3_1
Xfanout726 net739 net726 VPWR VGND sg13g2_buf_8
Xfanout759 net760 net759 VPWR VGND sg13g2_buf_8
X_3268_ videogen.test_lut_thingy.pixel_feeder_inst.h_counter\[1\] _0834_ _0949_ VPWR
+ VGND sg13g2_and2_1
X_3199_ VGND VPWR _0832_ _0895_ _0899_ _0889_ sg13g2_a21oi_1
X_5007_ net31 VGND VPWR _0339_ videogen.fancy_shader.n646\[2\] net655 sg13g2_dfrbpq_2
XFILLER_26_356 VPWR VGND sg13g2_decap_4
XFILLER_27_857 VPWR VGND sg13g2_decap_8
XFILLER_42_849 VPWR VGND sg13g2_fill_1
XFILLER_41_359 VPWR VGND sg13g2_fill_1
XFILLER_22_595 VPWR VGND sg13g2_decap_8
XFILLER_5_227 VPWR VGND sg13g2_decap_4
XFILLER_2_967 VPWR VGND sg13g2_decap_8
XFILLER_1_455 VPWR VGND sg13g2_decap_4
XFILLER_49_426 VPWR VGND sg13g2_decap_8
XFILLER_39_63 VPWR VGND sg13g2_decap_8
X_5065__357 VPWR VGND net357 sg13g2_tiehi
XFILLER_39_96 VPWR VGND sg13g2_fill_2
XFILLER_44_197 VPWR VGND sg13g2_fill_2
XFILLER_44_186 VPWR VGND sg13g2_decap_8
XFILLER_26_890 VPWR VGND sg13g2_decap_8
XFILLER_9_544 VPWR VGND sg13g2_decap_4
XFILLER_13_573 VPWR VGND sg13g2_decap_8
XFILLER_5_750 VPWR VGND sg13g2_fill_2
XFILLER_45_1011 VPWR VGND sg13g2_decap_8
X_4240_ _1886_ _0980_ _1683_ VPWR VGND sg13g2_xnor2_1
X_4171_ _1803_ _1814_ _1816_ _1817_ VPWR VGND sg13g2_or3_1
X_3122_ _0711_ _0861_ _0863_ VPWR VGND sg13g2_nor2_2
XFILLER_49_982 VPWR VGND sg13g2_decap_8
X_3053_ videogen.test_lut_thingy.pixel_feeder_inst.row\[35\]\[2\] net781 _0826_ _0331_
+ VPWR VGND sg13g2_mux2_1
XFILLER_36_610 VPWR VGND sg13g2_fill_1
XFILLER_35_120 VPWR VGND sg13g2_decap_8
X_3955_ videogen.test_lut_thingy.pixel_feeder_inst.row\[50\]\[0\] net590 _1607_ VPWR
+ VGND sg13g2_nor2_1
XFILLER_32_860 VPWR VGND sg13g2_decap_8
XFILLER_32_893 VPWR VGND sg13g2_decap_8
X_2906_ net792 videogen.test_lut_thingy.pixel_feeder_inst.row\[55\]\[1\] _0794_ _0505_
+ VPWR VGND sg13g2_mux2_1
X_3886_ videogen.test_lut_thingy.pixel_feeder_inst.row\[1\]\[3\] net567 _1539_ VPWR
+ VGND sg13g2_nor2_1
X_2837_ _0780_ VPWR _0568_ VGND _0670_ _0779_ sg13g2_o21ai_1
XFILLER_3_709 VPWR VGND sg13g2_fill_1
X_2768_ _0701_ net613 net554 _0755_ VPWR VGND sg13g2_a21o_2
X_4507_ _2130_ tmds_green.dc_balancing_reg\[4\] _2129_ VPWR VGND sg13g2_xnor2_1
X_2699_ videogen.fancy_shader.video_y\[6\] net623 videogen.fancy_shader.video_y\[7\]
+ _0706_ VPWR VGND sg13g2_nand3_1
X_4438_ _0879_ VPWR _2070_ VGND _1958_ _1996_ sg13g2_o21ai_1
Xfanout556 _0718_ net556 VPWR VGND sg13g2_buf_8
X_4369_ _1966_ _1976_ _2009_ VPWR VGND sg13g2_nor2_1
Xfanout589 net591 net589 VPWR VGND sg13g2_buf_1
Xfanout567 net570 net567 VPWR VGND sg13g2_buf_8
Xfanout578 net580 net578 VPWR VGND sg13g2_buf_1
X_5279__354 VPWR VGND net354 sg13g2_tiehi
XFILLER_14_304 VPWR VGND sg13g2_decap_4
XFILLER_15_827 VPWR VGND sg13g2_decap_8
XFILLER_26_153 VPWR VGND sg13g2_decap_8
XFILLER_27_687 VPWR VGND sg13g2_decap_8
XFILLER_15_838 VPWR VGND sg13g2_fill_2
XFILLER_23_860 VPWR VGND sg13g2_decap_8
XFILLER_25_87 VPWR VGND sg13g2_decap_8
XFILLER_30_808 VPWR VGND sg13g2_fill_2
XFILLER_41_167 VPWR VGND sg13g2_decap_4
XFILLER_10_521 VPWR VGND sg13g2_decap_4
XFILLER_22_381 VPWR VGND sg13g2_decap_8
XFILLER_29_1006 VPWR VGND sg13g2_decap_8
XFILLER_2_742 VPWR VGND sg13g2_fill_1
XFILLER_2_731 VPWR VGND sg13g2_fill_1
XFILLER_1_241 VPWR VGND sg13g2_decap_8
XFILLER_2_25 VPWR VGND sg13g2_decap_8
XFILLER_49_267 VPWR VGND sg13g2_decap_8
XFILLER_46_974 VPWR VGND sg13g2_decap_8
XFILLER_45_473 VPWR VGND sg13g2_fill_2
XFILLER_17_164 VPWR VGND sg13g2_fill_2
XFILLER_18_665 VPWR VGND sg13g2_decap_8
XFILLER_17_197 VPWR VGND sg13g2_decap_8
XFILLER_32_101 VPWR VGND sg13g2_fill_1
XFILLER_33_668 VPWR VGND sg13g2_fill_2
X_3740_ videogen.test_lut_thingy.pixel_feeder_inst.row\[2\]\[1\] net588 _1393_ VPWR
+ VGND sg13g2_nor2_1
XFILLER_9_363 VPWR VGND sg13g2_fill_2
X_3671_ net626 VPWR _1324_ VGND _1318_ _1323_ sg13g2_o21ai_1
X_5341_ net436 VGND VPWR net667 serialize.shift_reg_c\[8\] clknet_3_2_0_clk_regs sg13g2_dfrbpq_1
X_5272_ net440 VGND VPWR _0600_ videogen.test_lut_thingy.pixel_feeder_inst.row\[29\]\[0\]
+ _0229_ sg13g2_dfrbpq_1
X_4223_ _1776_ _1664_ _1869_ VPWR VGND sg13g2_xor2_1
X_4154_ VGND VPWR _1799_ _1800_ _1798_ _1791_ sg13g2_a21oi_2
X_5048__385 VPWR VGND net385 sg13g2_tiehi
X_3105_ VGND VPWR _0848_ _0853_ _0002_ _0362_ sg13g2_a21oi_1
X_4085_ _1734_ _1733_ _1732_ VPWR VGND sg13g2_nand2b_1
X_3036_ _0778_ _0806_ _0823_ VPWR VGND sg13g2_nor2_2
XFILLER_24_613 VPWR VGND sg13g2_decap_8
XFILLER_24_668 VPWR VGND sg13g2_fill_2
XFILLER_24_679 VPWR VGND sg13g2_fill_1
X_4987_ net71 VGND VPWR _0319_ videogen.test_lut_thingy.pixel_feeder_inst.v_counter\[2\]
+ net644 sg13g2_dfrbpq_2
XFILLER_11_329 VPWR VGND sg13g2_fill_2
XFILLER_23_178 VPWR VGND sg13g2_decap_8
XFILLER_23_189 VPWR VGND sg13g2_fill_2
X_3938_ _1586_ _1587_ _1588_ _1589_ _1590_ VPWR VGND sg13g2_nor4_1
XFILLER_20_830 VPWR VGND sg13g2_fill_2
X_3869_ videogen.test_lut_thingy.pixel_feeder_inst.row\[7\]\[3\] net576 _1522_ VPWR
+ VGND sg13g2_nor2_1
X_5131__244 VPWR VGND net244 sg13g2_tiehi
X_5242__239 VPWR VGND net239 sg13g2_tiehi
XFILLER_47_749 VPWR VGND sg13g2_decap_4
XFILLER_46_226 VPWR VGND sg13g2_fill_1
XFILLER_36_53 VPWR VGND sg13g2_decap_4
XFILLER_28_996 VPWR VGND sg13g2_decap_8
XFILLER_15_657 VPWR VGND sg13g2_fill_1
XFILLER_15_668 VPWR VGND sg13g2_decap_8
XFILLER_35_1021 VPWR VGND sg13g2_decap_8
XFILLER_11_841 VPWR VGND sg13g2_decap_8
XFILLER_11_874 VPWR VGND sg13g2_fill_1
XFILLER_10_373 VPWR VGND sg13g2_fill_2
XFILLER_6_355 VPWR VGND sg13g2_fill_1
XFILLER_35_7 VPWR VGND sg13g2_fill_2
XFILLER_18_462 VPWR VGND sg13g2_fill_2
XFILLER_19_963 VPWR VGND sg13g2_decap_8
XFILLER_34_922 VPWR VGND sg13g2_decap_8
XFILLER_34_933 VPWR VGND sg13g2_fill_1
X_4910_ _2211_ _2212_ _0619_ VPWR VGND sg13g2_nor2_1
X_4841_ net708 net753 _0176_ VPWR VGND sg13g2_nor2_1
XFILLER_34_977 VPWR VGND sg13g2_decap_8
XFILLER_21_638 VPWR VGND sg13g2_decap_8
X_4772_ net675 net720 _0107_ VPWR VGND sg13g2_nor2_1
X_3723_ videogen.test_lut_thingy.pixel_feeder_inst.row\[9\]\[1\] net568 _1376_ VPWR
+ VGND sg13g2_nor2_1
XFILLER_9_171 VPWR VGND sg13g2_decap_8
X_3654_ _1303_ _1304_ _1305_ _1306_ _1307_ VPWR VGND sg13g2_nor4_1
X_3585_ _1224_ _1231_ _1238_ VPWR VGND sg13g2_and2_1
X_5324_ net293 VGND VPWR _0652_ serialize.shift_reg_g\[2\] clknet_3_7_0_clk_regs sg13g2_dfrbpq_1
X_5255_ net183 VGND VPWR _0583_ videogen.test_lut_thingy.pixel_feeder_inst.row\[41\]\[3\]
+ _0212_ sg13g2_dfrbpq_1
X_4948__132 VPWR VGND net132 sg13g2_tiehi
X_4206_ _1851_ VPWR _1852_ VGND _1835_ _1848_ sg13g2_o21ai_1
X_5186_ net84 VGND VPWR _0514_ tmds_blue.dc_balancing_reg\[3\] net653 sg13g2_dfrbpq_2
X_4137_ _1783_ _1096_ _1781_ VPWR VGND sg13g2_xnor2_1
X_4068_ _1701_ _1715_ _1716_ _1717_ VPWR VGND sg13g2_or3_1
XFILLER_25_900 VPWR VGND sg13g2_decap_4
XFILLER_43_229 VPWR VGND sg13g2_fill_1
XFILLER_25_933 VPWR VGND sg13g2_decap_8
X_3019_ videogen.test_lut_thingy.pixel_feeder_inst.row\[14\]\[1\] net796 _0819_ _0408_
+ VPWR VGND sg13g2_mux2_1
XFILLER_19_1005 VPWR VGND sg13g2_decap_8
XFILLER_24_454 VPWR VGND sg13g2_decap_4
XFILLER_40_936 VPWR VGND sg13g2_fill_1
XFILLER_22_11 VPWR VGND sg13g2_fill_1
XFILLER_20_682 VPWR VGND sg13g2_fill_1
XFILLER_4_815 VPWR VGND sg13g2_fill_2
XFILLER_3_303 VPWR VGND sg13g2_fill_2
XFILLER_47_535 VPWR VGND sg13g2_decap_8
XFILLER_16_900 VPWR VGND sg13g2_decap_8
XFILLER_34_218 VPWR VGND sg13g2_decap_8
XFILLER_43_730 VPWR VGND sg13g2_fill_2
XFILLER_15_421 VPWR VGND sg13g2_decap_4
XFILLER_16_977 VPWR VGND sg13g2_decap_8
XFILLER_15_465 VPWR VGND sg13g2_decap_4
XFILLER_31_969 VPWR VGND sg13g2_decap_8
XFILLER_8_57 VPWR VGND sg13g2_decap_4
XFILLER_8_46 VPWR VGND sg13g2_fill_1
XFILLER_7_642 VPWR VGND sg13g2_decap_4
XFILLER_11_671 VPWR VGND sg13g2_decap_8
X_3370_ _1023_ videogen.fancy_shader.video_y\[1\] videogen.fancy_shader.n646\[1\]
+ VPWR VGND sg13g2_xnor2_1
X_5040_ net394 VGND VPWR _0372_ red\[4\] net656 sg13g2_dfrbpq_2
XFILLER_33_4 VPWR VGND sg13g2_fill_2
XFILLER_38_502 VPWR VGND sg13g2_fill_2
XFILLER_38_524 VPWR VGND sg13g2_decap_8
X_4824_ net699 net744 _0159_ VPWR VGND sg13g2_nor2_1
XFILLER_22_947 VPWR VGND sg13g2_decap_8
XFILLER_33_284 VPWR VGND sg13g2_fill_2
X_4755_ net674 net719 _0090_ VPWR VGND sg13g2_nor2_1
X_3706_ videogen.test_lut_thingy.pixel_feeder_inst.row\[19\]\[1\] net575 _1359_ VPWR
+ VGND sg13g2_nor2_1
X_4686_ net684 net729 _0023_ VPWR VGND sg13g2_nor2_1
X_3637_ videogen.test_lut_thingy.pixel_feeder_inst.row\[8\]\[2\] net600 _1290_ VPWR
+ VGND sg13g2_nor2_1
XFILLER_1_818 VPWR VGND sg13g2_decap_8
X_3568_ _1212_ _1196_ _1208_ _1221_ VPWR VGND sg13g2_a21o_1
X_5184__88 VPWR VGND net88 sg13g2_tiehi
X_5307_ net144 VGND VPWR _0635_ videogen.test_lut_thingy.pixel_feeder_inst.row\[22\]\[1\]
+ _0254_ sg13g2_dfrbpq_1
XFILLER_0_317 VPWR VGND sg13g2_decap_4
XFILLER_0_339 VPWR VGND sg13g2_decap_8
X_3499_ _1151_ _1144_ _1152_ VPWR VGND sg13g2_nor2b_1
X_5238_ net255 VGND VPWR _0566_ videogen.test_lut_thingy.pixel_feeder_inst.row\[45\]\[2\]
+ _0195_ sg13g2_dfrbpq_1
X_5169_ net164 VGND VPWR _0497_ videogen.test_lut_thingy.pixel_feeder_inst.row\[56\]\[1\]
+ _0134_ sg13g2_dfrbpq_1
XFILLER_17_66 VPWR VGND sg13g2_decap_8
XFILLER_25_730 VPWR VGND sg13g2_decap_8
XFILLER_13_914 VPWR VGND sg13g2_decap_8
XFILLER_9_918 VPWR VGND sg13g2_decap_8
XFILLER_12_435 VPWR VGND sg13g2_fill_1
XFILLER_33_43 VPWR VGND sg13g2_fill_2
XFILLER_32_1024 VPWR VGND sg13g2_fill_1
XFILLER_4_634 VPWR VGND sg13g2_fill_2
XFILLER_4_612 VPWR VGND sg13g2_fill_1
XFILLER_3_122 VPWR VGND sg13g2_decap_8
XFILLER_4_678 VPWR VGND sg13g2_decap_8
XFILLER_3_166 VPWR VGND sg13g2_decap_8
XFILLER_0_895 VPWR VGND sg13g2_decap_8
Xhold6 _0284_ VPWR VGND net451 sg13g2_dlygate4sd3_1
XFILLER_48_866 VPWR VGND sg13g2_decap_8
XFILLER_47_365 VPWR VGND sg13g2_fill_1
X_2870_ videogen.test_lut_thingy.pixel_feeder_inst.row\[51\]\[2\] net786 _0787_ _0542_
+ VPWR VGND sg13g2_mux2_1
XFILLER_31_744 VPWR VGND sg13g2_fill_1
XFILLER_12_991 VPWR VGND sg13g2_decap_8
XFILLER_30_265 VPWR VGND sg13g2_decap_8
X_4540_ tmds_blue.dc_balancing_reg\[1\] _2152_ _2143_ _2157_ VPWR VGND sg13g2_mux2_1
X_4471_ net616 _2077_ _2096_ VPWR VGND sg13g2_nor2_1
XFILLER_8_995 VPWR VGND sg13g2_decap_8
XFILLER_48_1020 VPWR VGND sg13g2_decap_8
X_3422_ _1075_ videogen.fancy_shader.n646\[6\] videogen.fancy_shader.video_x\[6\]
+ VPWR VGND sg13g2_nand2_1
X_3353_ _1011_ _1012_ _0355_ VPWR VGND sg13g2_nor2b_1
X_3284_ _0959_ _0957_ videogen.fancy_shader.n646\[3\] VPWR VGND sg13g2_nand2b_1
X_5023_ net413 VGND VPWR _0355_ videogen.fancy_shader.video_y\[8\] net647 sg13g2_dfrbpq_2
XFILLER_38_365 VPWR VGND sg13g2_fill_1
XFILLER_0_1000 VPWR VGND sg13g2_decap_8
XFILLER_26_538 VPWR VGND sg13g2_decap_8
XFILLER_19_590 VPWR VGND sg13g2_decap_4
XFILLER_0_91 VPWR VGND sg13g2_decap_8
X_4807_ net690 net735 _0142_ VPWR VGND sg13g2_nor2_1
XFILLER_16_1019 VPWR VGND sg13g2_decap_8
XFILLER_21_254 VPWR VGND sg13g2_fill_1
XFILLER_10_939 VPWR VGND sg13g2_decap_8
X_2999_ net789 videogen.test_lut_thingy.pixel_feeder_inst.row\[31\]\[1\] _0815_ _0433_
+ VPWR VGND sg13g2_mux2_1
XFILLER_21_276 VPWR VGND sg13g2_fill_2
X_4738_ net686 net731 _0073_ VPWR VGND sg13g2_nor2_1
X_4669_ net710 net755 _0006_ VPWR VGND sg13g2_nor2_1
X_4952__128 VPWR VGND net128 sg13g2_tiehi
Xclkbuf_1_1__f_clk clknet_0_clk clknet_1_1__leaf_clk VPWR VGND sg13g2_buf_8
XFILLER_0_147 VPWR VGND sg13g2_fill_2
XFILLER_29_310 VPWR VGND sg13g2_fill_2
XFILLER_17_516 VPWR VGND sg13g2_decap_8
XFILLER_44_42 VPWR VGND sg13g2_fill_1
XFILLER_40_541 VPWR VGND sg13g2_decap_8
XFILLER_12_232 VPWR VGND sg13g2_fill_2
XFILLER_13_766 VPWR VGND sg13g2_decap_8
XFILLER_13_777 VPWR VGND sg13g2_fill_1
XFILLER_40_585 VPWR VGND sg13g2_fill_1
XFILLER_5_965 VPWR VGND sg13g2_decap_8
XFILLER_4_475 VPWR VGND sg13g2_fill_1
XFILLER_4_464 VPWR VGND sg13g2_decap_4
XFILLER_0_692 VPWR VGND sg13g2_decap_8
XFILLER_48_641 VPWR VGND sg13g2_decap_8
XFILLER_36_836 VPWR VGND sg13g2_fill_1
XFILLER_47_184 VPWR VGND sg13g2_decap_4
X_3971_ videogen.test_lut_thingy.pixel_feeder_inst.row\[43\]\[0\] net574 _1623_ VPWR
+ VGND sg13g2_nor2_1
XFILLER_16_560 VPWR VGND sg13g2_decap_8
XFILLER_23_508 VPWR VGND sg13g2_decap_8
X_2922_ net806 videogen.test_lut_thingy.pixel_feeder_inst.row\[57\]\[0\] _0797_ _0492_
+ VPWR VGND sg13g2_mux2_1
XFILLER_31_541 VPWR VGND sg13g2_decap_8
X_2853_ _0744_ _0749_ _0784_ VPWR VGND sg13g2_nor2_2
X_2784_ videogen.test_lut_thingy.pixel_feeder_inst.row\[29\]\[1\] net789 _0760_ _0601_
+ VPWR VGND sg13g2_mux2_1
X_4523_ _2141_ _2136_ VPWR VGND tmds_blue.dc_balancing_reg\[4\] sg13g2_nand2b_2
X_4454_ green\[7\] green\[6\] net615 _2079_ VPWR VGND sg13g2_nand3_1
X_3405_ _1058_ _1055_ _1057_ VPWR VGND sg13g2_nand2_1
X_4385_ _2024_ _1989_ _1986_ VPWR VGND sg13g2_nand2b_1
Xfanout705 net709 net705 VPWR VGND sg13g2_buf_8
Xfanout716 clockdiv.q2temp net716 VPWR VGND sg13g2_buf_8
Xfanout738 net739 net738 VPWR VGND sg13g2_buf_8
X_3336_ _1001_ _0998_ videogen.fancy_shader.video_y\[3\] _0994_ videogen.fancy_shader.video_y\[2\]
+ VPWR VGND sg13g2_a22oi_1
Xfanout749 net761 net749 VPWR VGND sg13g2_buf_8
Xfanout727 net729 net727 VPWR VGND sg13g2_buf_8
X_3267_ videogen.test_lut_thingy.pixel_feeder_inst.h_counter\[1\] _0834_ _0948_ VPWR
+ VGND sg13g2_nor2_1
X_5006_ net33 VGND VPWR _0338_ videogen.fancy_shader.n646\[1\] net655 sg13g2_dfrbpq_2
X_3198_ VGND VPWR videogen.fancy_shader.video_x\[8\] _0895_ _0898_ videogen.fancy_shader.video_x\[9\]
+ sg13g2_a21oi_1
XFILLER_26_313 VPWR VGND sg13g2_fill_2
XFILLER_38_195 VPWR VGND sg13g2_decap_8
XFILLER_14_45 VPWR VGND sg13g2_fill_1
XFILLER_22_541 VPWR VGND sg13g2_decap_8
X_5238__255 VPWR VGND net255 sg13g2_tiehi
XFILLER_30_88 VPWR VGND sg13g2_decap_4
XFILLER_2_946 VPWR VGND sg13g2_decap_8
XFILLER_49_405 VPWR VGND sg13g2_decap_8
XFILLER_7_1017 VPWR VGND sg13g2_decap_8
XFILLER_7_1028 VPWR VGND sg13g2_fill_1
X_5141__224 VPWR VGND net224 sg13g2_tiehi
XFILLER_29_140 VPWR VGND sg13g2_decap_8
XFILLER_45_633 VPWR VGND sg13g2_decap_8
XFILLER_18_858 VPWR VGND sg13g2_decap_8
XFILLER_45_677 VPWR VGND sg13g2_decap_4
XFILLER_9_501 VPWR VGND sg13g2_decap_4
X_4170_ _1816_ _1142_ _1815_ VPWR VGND sg13g2_xnor2_1
X_3121_ _0857_ _0859_ _0862_ VPWR VGND sg13g2_nor2_1
XFILLER_49_961 VPWR VGND sg13g2_decap_8
X_3052_ videogen.test_lut_thingy.pixel_feeder_inst.row\[35\]\[3\] net770 _0826_ _0332_
+ VPWR VGND sg13g2_mux2_1
XFILLER_36_655 VPWR VGND sg13g2_fill_1
XFILLER_24_817 VPWR VGND sg13g2_fill_2
XFILLER_23_338 VPWR VGND sg13g2_fill_2
XFILLER_35_176 VPWR VGND sg13g2_decap_8
XFILLER_36_699 VPWR VGND sg13g2_fill_2
X_3954_ videogen.test_lut_thingy.pixel_feeder_inst.row\[48\]\[0\] net602 _1606_ VPWR
+ VGND sg13g2_nor2_1
XFILLER_16_390 VPWR VGND sg13g2_fill_2
X_2905_ net781 videogen.test_lut_thingy.pixel_feeder_inst.row\[55\]\[2\] _0794_ _0506_
+ VPWR VGND sg13g2_mux2_1
X_3885_ videogen.test_lut_thingy.pixel_feeder_inst.row\[0\]\[3\] net601 _1538_ VPWR
+ VGND sg13g2_nor2_1
X_2836_ _0780_ net804 _0779_ VPWR VGND sg13g2_nand2_1
X_2767_ _0754_ net555 _0753_ VPWR VGND sg13g2_nand2_2
X_4506_ VGND VPWR _0688_ _2079_ _2129_ _2081_ sg13g2_a21oi_1
X_2698_ _0705_ net625 _0703_ VPWR VGND sg13g2_xnor2_1
X_4437_ VGND VPWR _1954_ _1996_ _0396_ _2069_ sg13g2_a21oi_1
Xfanout557 _0718_ net557 VPWR VGND sg13g2_buf_1
X_4368_ _2007_ _2006_ _1995_ _2008_ VPWR VGND sg13g2_a21o_1
XFILLER_47_909 VPWR VGND sg13g2_decap_8
Xfanout568 net570 net568 VPWR VGND sg13g2_buf_1
X_3319_ _0989_ _0988_ videogen.fancy_shader.n646\[8\] VPWR VGND sg13g2_nand2b_1
X_4299_ _1943_ _1648_ _1945_ VPWR VGND sg13g2_nor2b_1
Xfanout579 net580 net579 VPWR VGND sg13g2_buf_8
XFILLER_25_11 VPWR VGND sg13g2_decap_8
XFILLER_42_625 VPWR VGND sg13g2_decap_8
XFILLER_26_198 VPWR VGND sg13g2_decap_8
XFILLER_41_157 VPWR VGND sg13g2_fill_1
XFILLER_25_55 VPWR VGND sg13g2_decap_8
XFILLER_22_360 VPWR VGND sg13g2_fill_2
XFILLER_10_544 VPWR VGND sg13g2_fill_1
XFILLER_10_577 VPWR VGND sg13g2_fill_2
XFILLER_6_559 VPWR VGND sg13g2_decap_8
XFILLER_49_202 VPWR VGND sg13g2_decap_8
XFILLER_2_787 VPWR VGND sg13g2_fill_1
XFILLER_49_257 VPWR VGND sg13g2_fill_2
XFILLER_49_246 VPWR VGND sg13g2_decap_8
XFILLER_2_59 VPWR VGND sg13g2_decap_8
XFILLER_46_953 VPWR VGND sg13g2_decap_8
XFILLER_18_622 VPWR VGND sg13g2_fill_1
XFILLER_17_143 VPWR VGND sg13g2_decap_8
XFILLER_17_154 VPWR VGND sg13g2_fill_2
XFILLER_33_625 VPWR VGND sg13g2_decap_4
XFILLER_14_872 VPWR VGND sg13g2_decap_4
XFILLER_9_320 VPWR VGND sg13g2_decap_8
X_3670_ net634 VPWR _1323_ VGND _1319_ _1322_ sg13g2_o21ai_1
X_5340_ net38 VGND VPWR _0668_ serialize.shift_reg_c\[6\] clknet_3_2_0_clk_regs sg13g2_dfrbpq_1
X_5271_ net34 VGND VPWR _0599_ videogen.test_lut_thingy.pixel_feeder_inst.row\[38\]\[3\]
+ _0228_ sg13g2_dfrbpq_1
X_4222_ _1863_ _1866_ _1868_ VPWR VGND _1862_ sg13g2_nand3b_1
X_4153_ _1782_ _1792_ _1799_ VPWR VGND sg13g2_nor2_1
X_3104_ _0846_ _0850_ net810 _0853_ VPWR VGND _0851_ sg13g2_nand4_1
X_4084_ _1723_ _1731_ _1656_ _1733_ VPWR VGND sg13g2_nand3_1
X_3035_ videogen.test_lut_thingy.pixel_feeder_inst.row\[11\]\[0\] net809 _0822_ _0390_
+ VPWR VGND sg13g2_mux2_1
X_5202__438 VPWR VGND net438 sg13g2_tiehi
XFILLER_36_430 VPWR VGND sg13g2_decap_8
XFILLER_23_113 VPWR VGND sg13g2_decap_8
XFILLER_36_474 VPWR VGND sg13g2_decap_8
X_4986_ net73 VGND VPWR _0318_ videogen.test_lut_thingy.pixel_feeder_inst.v_counter\[1\]
+ net645 sg13g2_dfrbpq_1
X_3937_ videogen.test_lut_thingy.pixel_feeder_inst.row\[31\]\[0\] net571 _1589_ VPWR
+ VGND sg13g2_nor2_1
XFILLER_32_680 VPWR VGND sg13g2_decap_4
X_3868_ net610 VPWR _1521_ VGND videogen.test_lut_thingy.pixel_feeder_inst.row\[4\]\[3\]
+ net599 sg13g2_o21ai_1
X_2819_ _0774_ net614 _0773_ VPWR VGND sg13g2_nand2_2
X_3799_ videogen.test_lut_thingy.pixel_feeder_inst.row\[36\]\[3\] net595 _1452_ VPWR
+ VGND sg13g2_nor2_1
XFILLER_3_518 VPWR VGND sg13g2_decap_4
XFILLER_3_529 VPWR VGND sg13g2_fill_1
XFILLER_46_249 VPWR VGND sg13g2_decap_8
XFILLER_27_430 VPWR VGND sg13g2_fill_1
XFILLER_27_452 VPWR VGND sg13g2_fill_1
XFILLER_28_975 VPWR VGND sg13g2_decap_8
XFILLER_36_32 VPWR VGND sg13g2_decap_4
XFILLER_35_1000 VPWR VGND sg13g2_decap_8
XFILLER_42_499 VPWR VGND sg13g2_fill_1
XFILLER_42_1015 VPWR VGND sg13g2_decap_8
XFILLER_19_942 VPWR VGND sg13g2_decap_8
XFILLER_46_794 VPWR VGND sg13g2_fill_1
X_4840_ net707 net753 _0175_ VPWR VGND sg13g2_nor2_1
XFILLER_21_617 VPWR VGND sg13g2_decap_8
X_4771_ net675 net719 _0106_ VPWR VGND sg13g2_nor2_1
XFILLER_20_138 VPWR VGND sg13g2_fill_1
X_3722_ net608 VPWR _1375_ VGND videogen.test_lut_thingy.pixel_feeder_inst.row\[8\]\[1\]
+ net600 sg13g2_o21ai_1
X_5312__444 VPWR VGND net444 sg13g2_tiehi
X_3653_ videogen.test_lut_thingy.pixel_feeder_inst.row\[58\]\[2\] net586 _1306_ VPWR
+ VGND sg13g2_nor2_1
X_5323_ net301 VGND VPWR _0651_ serialize.shift_reg_g\[1\] clknet_3_4_0_clk_regs sg13g2_dfrbpq_1
X_3584_ _1236_ VPWR _1237_ VGND _1228_ _1233_ sg13g2_o21ai_1
X_5254_ net191 VGND VPWR _0582_ videogen.test_lut_thingy.pixel_feeder_inst.row\[41\]\[2\]
+ _0211_ sg13g2_dfrbpq_1
X_5185_ net86 VGND VPWR _0513_ tmds_blue.dc_balancing_reg\[2\] net654 sg13g2_dfrbpq_2
X_4205_ _1851_ _1825_ _1833_ VPWR VGND sg13g2_xnor2_1
X_4136_ _1782_ _1095_ _1781_ VPWR VGND sg13g2_xnor2_1
X_4067_ _1716_ _1029_ _1654_ VPWR VGND sg13g2_xnor2_1
X_3018_ videogen.test_lut_thingy.pixel_feeder_inst.row\[14\]\[2\] net785 _0819_ _0409_
+ VPWR VGND sg13g2_mux2_1
XFILLER_24_433 VPWR VGND sg13g2_decap_8
XFILLER_36_282 VPWR VGND sg13g2_fill_2
XFILLER_24_477 VPWR VGND sg13g2_fill_2
XFILLER_25_989 VPWR VGND sg13g2_decap_8
X_4969_ net103 VGND VPWR _0301_ videogen.fancy_shader.video_x\[7\] net649 sg13g2_dfrbpq_2
XFILLER_11_149 VPWR VGND sg13g2_fill_2
XFILLER_20_694 VPWR VGND sg13g2_decap_4
XFILLER_22_56 VPWR VGND sg13g2_fill_1
XFILLER_4_805 VPWR VGND sg13g2_fill_1
XFILLER_4_827 VPWR VGND sg13g2_fill_2
XFILLER_3_348 VPWR VGND sg13g2_fill_1
XFILLER_47_514 VPWR VGND sg13g2_decap_8
XFILLER_47_53 VPWR VGND sg13g2_decap_4
XFILLER_28_772 VPWR VGND sg13g2_decap_8
XFILLER_43_753 VPWR VGND sg13g2_fill_2
XFILLER_43_742 VPWR VGND sg13g2_fill_1
XFILLER_16_956 VPWR VGND sg13g2_decap_8
XFILLER_43_764 VPWR VGND sg13g2_fill_1
XFILLER_42_296 VPWR VGND sg13g2_decap_8
XFILLER_30_425 VPWR VGND sg13g2_decap_8
XFILLER_11_694 VPWR VGND sg13g2_decap_8
X_5038__396 VPWR VGND net396 sg13g2_tiehi
XFILLER_6_142 VPWR VGND sg13g2_fill_2
XFILLER_6_164 VPWR VGND sg13g2_decap_8
XFILLER_26_4 VPWR VGND sg13g2_decap_4
X_5045__389 VPWR VGND net389 sg13g2_tiehi
XFILLER_19_783 VPWR VGND sg13g2_decap_8
XFILLER_34_753 VPWR VGND sg13g2_fill_2
XFILLER_22_926 VPWR VGND sg13g2_decap_8
X_4823_ net699 net724 _0158_ VPWR VGND sg13g2_nor2_1
X_4754_ net674 net719 _0089_ VPWR VGND sg13g2_nor2_1
X_3705_ videogen.test_lut_thingy.pixel_feeder_inst.row\[16\]\[1\] net599 _1358_ VPWR
+ VGND sg13g2_nor2_1
X_5017__425 VPWR VGND net425 sg13g2_tiehi
XFILLER_30_992 VPWR VGND sg13g2_decap_8
X_4685_ net682 net727 _0022_ VPWR VGND sg13g2_nor2_1
X_3636_ net631 VPWR _1289_ VGND videogen.test_lut_thingy.pixel_feeder_inst.row\[11\]\[2\]
+ net577 sg13g2_o21ai_1
X_3567_ _1210_ VPWR _1220_ VGND _1195_ _1203_ sg13g2_o21ai_1
X_5306_ net165 VGND VPWR _0634_ videogen.test_lut_thingy.pixel_feeder_inst.row\[22\]\[0\]
+ _0253_ sg13g2_dfrbpq_1
X_5237_ net259 VGND VPWR _0565_ videogen.test_lut_thingy.pixel_feeder_inst.row\[45\]\[1\]
+ _0194_ sg13g2_dfrbpq_1
X_3498_ VGND VPWR _1150_ _1151_ _1132_ _1128_ sg13g2_a21oi_2
XFILLER_25_1010 VPWR VGND sg13g2_decap_8
X_5168_ net166 VGND VPWR _0496_ videogen.test_lut_thingy.pixel_feeder_inst.row\[56\]\[0\]
+ _0133_ sg13g2_dfrbpq_1
X_5099_ net308 VGND VPWR _0427_ videogen.test_lut_thingy.pixel_feeder_inst.row\[32\]\[3\]
+ _0064_ sg13g2_dfrbpq_1
X_4119_ _0982_ _1049_ _1765_ VPWR VGND sg13g2_nor2_1
XFILLER_17_34 VPWR VGND sg13g2_fill_1
XFILLER_17_45 VPWR VGND sg13g2_decap_8
X_5100__306 VPWR VGND net306 sg13g2_tiehi
XFILLER_25_742 VPWR VGND sg13g2_fill_2
XFILLER_24_230 VPWR VGND sg13g2_fill_1
XFILLER_33_77 VPWR VGND sg13g2_fill_2
XFILLER_8_429 VPWR VGND sg13g2_decap_8
XFILLER_21_992 VPWR VGND sg13g2_decap_8
XFILLER_20_480 VPWR VGND sg13g2_fill_2
XFILLER_0_874 VPWR VGND sg13g2_decap_8
XFILLER_48_845 VPWR VGND sg13g2_decap_8
Xhold7 serialize.shift_reg_c\[5\] VPWR VGND net452 sg13g2_dlygate4sd3_1
XFILLER_35_506 VPWR VGND sg13g2_decap_8
X_4989__67 VPWR VGND net67 sg13g2_tiehi
XFILLER_28_580 VPWR VGND sg13g2_decap_8
XFILLER_15_252 VPWR VGND sg13g2_decap_8
XFILLER_16_786 VPWR VGND sg13g2_decap_8
XFILLER_15_285 VPWR VGND sg13g2_fill_2
XFILLER_12_970 VPWR VGND sg13g2_decap_8
X_5151__204 VPWR VGND net204 sg13g2_tiehi
XFILLER_8_974 VPWR VGND sg13g2_decap_8
XFILLER_7_440 VPWR VGND sg13g2_decap_8
X_4470_ VPWR _2095_ _2094_ VGND sg13g2_inv_1
X_5231__283 VPWR VGND net283 sg13g2_tiehi
XFILLER_7_495 VPWR VGND sg13g2_fill_1
X_3421_ videogen.fancy_shader.video_x\[8\] videogen.fancy_shader.n646\[8\] _1074_
+ VPWR VGND sg13g2_xor2_1
X_3352_ net811 _1010_ _1012_ VPWR VGND sg13g2_and2_1
X_3283_ net766 _0956_ _0958_ _0339_ VPWR VGND sg13g2_nor3_1
X_5022_ net415 VGND VPWR _0354_ videogen.fancy_shader.video_y\[7\] net647 sg13g2_dfrbpq_2
XFILLER_38_333 VPWR VGND sg13g2_fill_1
XFILLER_26_528 VPWR VGND sg13g2_fill_2
XFILLER_0_70 VPWR VGND sg13g2_decap_8
XFILLER_10_918 VPWR VGND sg13g2_decap_8
XFILLER_21_222 VPWR VGND sg13g2_decap_4
X_4806_ net690 net735 _0141_ VPWR VGND sg13g2_nor2_1
X_2998_ net778 videogen.test_lut_thingy.pixel_feeder_inst.row\[31\]\[2\] _0815_ _0434_
+ VPWR VGND sg13g2_mux2_1
X_4737_ net673 net718 _0072_ VPWR VGND sg13g2_nor2_1
X_4668_ net495 net814 net668 _0668_ VPWR VGND sg13g2_a21o_1
X_3619_ videogen.test_lut_thingy.pixel_feeder_inst.row\[20\]\[2\] net593 _1272_ VPWR
+ VGND sg13g2_nor2_1
X_4599_ net814 VPWR _2212_ VGND net620 hsync sg13g2_o21ai_1
XFILLER_0_126 VPWR VGND sg13g2_decap_8
XFILLER_49_609 VPWR VGND sg13g2_decap_8
XFILLER_28_66 VPWR VGND sg13g2_decap_4
XFILLER_45_859 VPWR VGND sg13g2_decap_8
XFILLER_44_98 VPWR VGND sg13g2_fill_1
XFILLER_9_716 VPWR VGND sg13g2_fill_2
XFILLER_12_266 VPWR VGND sg13g2_decap_4
X_5002__41 VPWR VGND net41 sg13g2_tiehi
XFILLER_5_944 VPWR VGND sg13g2_decap_8
XFILLER_4_443 VPWR VGND sg13g2_decap_8
X_5035__399 VPWR VGND net399 sg13g2_tiehi
XFILLER_48_620 VPWR VGND sg13g2_decap_8
XFILLER_0_671 VPWR VGND sg13g2_decap_8
XFILLER_48_686 VPWR VGND sg13g2_decap_8
XFILLER_35_303 VPWR VGND sg13g2_fill_1
X_3970_ videogen.test_lut_thingy.pixel_feeder_inst.row\[42\]\[0\] net585 _1622_ VPWR
+ VGND sg13g2_nor2_1
X_2921_ net790 videogen.test_lut_thingy.pixel_feeder_inst.row\[57\]\[1\] _0797_ _0493_
+ VPWR VGND sg13g2_mux2_1
XFILLER_31_520 VPWR VGND sg13g2_decap_8
XFILLER_43_391 VPWR VGND sg13g2_decap_4
X_2852_ net803 videogen.test_lut_thingy.pixel_feeder_inst.row\[47\]\[0\] _0783_ _0556_
+ VPWR VGND sg13g2_mux2_1
X_2783_ videogen.test_lut_thingy.pixel_feeder_inst.row\[29\]\[2\] net778 _0760_ _0602_
+ VPWR VGND sg13g2_mux2_1
X_4522_ tmds_blue.dc_balancing_reg\[4\] _2136_ _2140_ VPWR VGND sg13g2_nor2b_1
X_4453_ VGND VPWR net605 _2076_ _0420_ _2078_ sg13g2_a21oi_1
X_3404_ videogen.fancy_shader.n646\[6\] videogen.fancy_shader.video_y\[6\] _1057_
+ VPWR VGND sg13g2_xor2_1
X_4384_ _2023_ tmds_red.dc_balancing_reg\[3\] _2022_ VPWR VGND sg13g2_xnor2_1
Xfanout706 net709 net706 VPWR VGND sg13g2_buf_8
Xfanout717 net721 net717 VPWR VGND sg13g2_buf_8
X_3335_ _0999_ _1000_ _0349_ VPWR VGND sg13g2_nor2_1
Xfanout739 net761 net739 VPWR VGND sg13g2_buf_8
Xfanout728 net729 net728 VPWR VGND sg13g2_buf_1
X_3266_ _0834_ _0946_ _0947_ _0321_ VPWR VGND sg13g2_nor3_1
XFILLER_39_642 VPWR VGND sg13g2_fill_2
XFILLER_39_631 VPWR VGND sg13g2_decap_8
XFILLER_22_1024 VPWR VGND sg13g2_decap_4
X_5005_ net35 VGND VPWR _0337_ videogen.fancy_shader.n646\[0\] net655 sg13g2_dfrbpq_2
X_3197_ _0889_ _0897_ _0302_ VPWR VGND sg13g2_nor2_1
XFILLER_27_815 VPWR VGND sg13g2_decap_8
XFILLER_30_56 VPWR VGND sg13g2_decap_8
XFILLER_2_925 VPWR VGND sg13g2_decap_8
X_5245__227 VPWR VGND net227 sg13g2_tiehi
XFILLER_39_98 VPWR VGND sg13g2_fill_1
XFILLER_45_612 VPWR VGND sg13g2_decap_8
XFILLER_18_815 VPWR VGND sg13g2_decap_8
X_4928__186 VPWR VGND net186 sg13g2_tiehi
XFILLER_44_122 VPWR VGND sg13g2_decap_8
XFILLER_44_133 VPWR VGND sg13g2_fill_2
XFILLER_33_807 VPWR VGND sg13g2_fill_1
XFILLER_44_199 VPWR VGND sg13g2_fill_1
XFILLER_44_166 VPWR VGND sg13g2_fill_2
XFILLER_38_1020 VPWR VGND sg13g2_decap_8
XFILLER_13_531 VPWR VGND sg13g2_decap_8
XFILLER_40_383 VPWR VGND sg13g2_fill_2
XFILLER_9_568 VPWR VGND sg13g2_decap_8
X_3120_ _0857_ _0858_ _0859_ _0860_ _0861_ VPWR VGND sg13g2_nor4_1
XFILLER_49_940 VPWR VGND sg13g2_decap_8
X_3051_ _0754_ _0765_ _0826_ VPWR VGND sg13g2_nor2_2
XFILLER_35_133 VPWR VGND sg13g2_decap_8
XFILLER_35_155 VPWR VGND sg13g2_decap_8
X_3953_ videogen.test_lut_thingy.pixel_feeder_inst.row\[51\]\[0\] net579 _1605_ VPWR
+ VGND sg13g2_nor2_1
X_3884_ net611 VPWR _1537_ VGND videogen.test_lut_thingy.pixel_feeder_inst.row\[3\]\[3\]
+ net577 sg13g2_o21ai_1
XFILLER_31_361 VPWR VGND sg13g2_decap_8
XFILLER_32_873 VPWR VGND sg13g2_fill_2
X_2904_ net769 videogen.test_lut_thingy.pixel_feeder_inst.row\[55\]\[3\] _0794_ _0507_
+ VPWR VGND sg13g2_mux2_1
XFILLER_31_383 VPWR VGND sg13g2_decap_8
XFILLER_31_394 VPWR VGND sg13g2_fill_2
X_2835_ videogen.test_lut_thingy.pixel_feeder_inst.row\[44\]\[1\] net793 _0779_ _0569_
+ VPWR VGND sg13g2_mux2_1
X_2766_ _0705_ _0746_ _0753_ VPWR VGND sg13g2_nor2_2
X_4505_ _2121_ VPWR _2128_ VGND _2102_ _2118_ sg13g2_o21ai_1
X_2697_ net625 _0703_ _0704_ VPWR VGND sg13g2_nor2b_1
XFILLER_6_80 VPWR VGND sg13g2_fill_1
X_4436_ _0879_ VPWR _2069_ VGND _1954_ _1996_ sg13g2_o21ai_1
X_4367_ _2007_ _1966_ _2003_ VPWR VGND sg13g2_nand2_1
X_3318_ _0344_ net810 _0987_ _0988_ VPWR VGND sg13g2_and3_1
Xfanout558 net559 net558 VPWR VGND sg13g2_buf_8
Xfanout569 net570 net569 VPWR VGND sg13g2_buf_8
X_4298_ VPWR _1944_ _1943_ VGND sg13g2_inv_1
X_3249_ _0849_ _0935_ _0316_ VPWR VGND sg13g2_nor2_1
XFILLER_27_634 VPWR VGND sg13g2_decap_4
XFILLER_27_667 VPWR VGND sg13g2_decap_8
XFILLER_41_11 VPWR VGND sg13g2_decap_4
XFILLER_22_372 VPWR VGND sg13g2_decap_4
XFILLER_22_394 VPWR VGND sg13g2_fill_2
XFILLER_23_895 VPWR VGND sg13g2_decap_8
XFILLER_41_44 VPWR VGND sg13g2_fill_2
XFILLER_41_33 VPWR VGND sg13g2_fill_1
XFILLER_49_225 VPWR VGND sg13g2_decap_8
XFILLER_46_932 VPWR VGND sg13g2_decap_8
XFILLER_45_453 VPWR VGND sg13g2_decap_4
XFILLER_17_122 VPWR VGND sg13g2_decap_8
XFILLER_45_486 VPWR VGND sg13g2_decap_4
XFILLER_45_475 VPWR VGND sg13g2_fill_1
XFILLER_13_361 VPWR VGND sg13g2_decap_4
XFILLER_9_365 VPWR VGND sg13g2_fill_1
XFILLER_12_1012 VPWR VGND sg13g2_decap_8
X_5270_ net42 VGND VPWR _0598_ videogen.test_lut_thingy.pixel_feeder_inst.row\[38\]\[2\]
+ _0227_ sg13g2_dfrbpq_1
X_4221_ _1771_ _1666_ _1867_ VPWR VGND sg13g2_xor2_1
X_4152_ _1769_ _1775_ _1793_ _1794_ _1798_ VPWR VGND sg13g2_or4_1
X_3103_ _0852_ net810 _0851_ VPWR VGND sg13g2_nand2_1
X_4083_ VGND VPWR _1723_ _1731_ _1732_ _1656_ sg13g2_a21oi_1
X_3034_ videogen.test_lut_thingy.pixel_feeder_inst.row\[11\]\[1\] net798 _0822_ _0391_
+ VPWR VGND sg13g2_mux2_1
XFILLER_37_932 VPWR VGND sg13g2_fill_1
X_4985_ net75 VGND VPWR _0317_ videogen.test_lut_thingy.pixel_feeder_inst.v_counter\[0\]
+ net643 sg13g2_dfrbpq_2
X_3936_ videogen.test_lut_thingy.pixel_feeder_inst.row\[29\]\[0\] net560 _1588_ VPWR
+ VGND sg13g2_nor2_1
X_3867_ _1520_ net626 _1519_ VPWR VGND sg13g2_nand2b_1
XFILLER_11_14 VPWR VGND sg13g2_fill_2
X_2818_ net636 _0720_ net575 _0773_ VPWR VGND sg13g2_nor3_2
X_3798_ net635 VPWR _1451_ VGND videogen.test_lut_thingy.pixel_feeder_inst.row\[39\]\[3\]
+ net573 sg13g2_o21ai_1
XFILLER_3_508 VPWR VGND sg13g2_fill_1
X_2749_ _0744_ net614 _0740_ VPWR VGND sg13g2_nand2_2
X_4419_ tmds_green.dc_balancing_reg\[0\] tmds_green.dc_balancing_reg\[1\] tmds_green.dc_balancing_reg\[3\]
+ tmds_green.dc_balancing_reg\[2\] _2055_ VPWR VGND sg13g2_nor4_1
XFILLER_39_291 VPWR VGND sg13g2_decap_8
XFILLER_42_412 VPWR VGND sg13g2_decap_4
XFILLER_42_401 VPWR VGND sg13g2_fill_1
XFILLER_15_604 VPWR VGND sg13g2_fill_2
XFILLER_43_979 VPWR VGND sg13g2_decap_8
XFILLER_43_946 VPWR VGND sg13g2_fill_2
XFILLER_27_497 VPWR VGND sg13g2_fill_2
XFILLER_6_335 VPWR VGND sg13g2_decap_8
XFILLER_10_397 VPWR VGND sg13g2_fill_1
XFILLER_2_530 VPWR VGND sg13g2_decap_4
XFILLER_35_9 VPWR VGND sg13g2_fill_1
XFILLER_37_217 VPWR VGND sg13g2_decap_4
XFILLER_19_921 VPWR VGND sg13g2_decap_8
XFILLER_18_486 VPWR VGND sg13g2_decap_8
XFILLER_19_998 VPWR VGND sg13g2_decap_8
X_4770_ net675 net719 _0105_ VPWR VGND sg13g2_nor2_1
X_3721_ _1374_ net628 _1373_ VPWR VGND sg13g2_nand2b_1
X_5334__169 VPWR VGND net169 sg13g2_tiehi
X_3652_ videogen.test_lut_thingy.pixel_feeder_inst.row\[59\]\[2\] net576 _1305_ VPWR
+ VGND sg13g2_nor2_1
X_3583_ _1218_ _1223_ _1236_ VPWR VGND sg13g2_nor2_1
X_5338__70 VPWR VGND net70 sg13g2_tiehi
X_5322_ net309 VGND VPWR _0650_ serialize.shift_reg_g\[0\] clknet_3_4_0_clk_regs sg13g2_dfrbpq_1
XFILLER_47_0 VPWR VGND sg13g2_decap_8
XFILLER_5_390 VPWR VGND sg13g2_decap_8
X_5253_ net195 VGND VPWR _0581_ videogen.test_lut_thingy.pixel_feeder_inst.row\[41\]\[1\]
+ _0210_ sg13g2_dfrbpq_1
X_4204_ _1825_ _1835_ _1848_ _1850_ VPWR VGND sg13g2_or3_1
X_5184_ net88 VGND VPWR _0512_ tmds_blue.dc_balancing_reg\[1\] net650 sg13g2_dfrbpq_2
X_4135_ _1780_ _1777_ _1781_ VPWR VGND sg13g2_xor2_1
XFILLER_29_718 VPWR VGND sg13g2_decap_4
XFILLER_28_217 VPWR VGND sg13g2_decap_8
XFILLER_37_740 VPWR VGND sg13g2_decap_4
X_4066_ _1715_ _1711_ _1714_ VPWR VGND sg13g2_nand2_1
X_5061__362 VPWR VGND net362 sg13g2_tiehi
X_3017_ videogen.test_lut_thingy.pixel_feeder_inst.row\[14\]\[3\] net774 _0819_ _0410_
+ VPWR VGND sg13g2_mux2_1
XFILLER_36_261 VPWR VGND sg13g2_decap_8
XFILLER_25_968 VPWR VGND sg13g2_decap_8
X_4968_ net104 VGND VPWR _0300_ videogen.fancy_shader.video_x\[6\] net649 sg13g2_dfrbpq_2
XFILLER_11_128 VPWR VGND sg13g2_decap_8
X_4899_ net695 net740 _0234_ VPWR VGND sg13g2_nor2_1
XFILLER_11_139 VPWR VGND sg13g2_fill_2
X_3919_ videogen.test_lut_thingy.pixel_feeder_inst.row\[7\]\[0\] net576 _1571_ VPWR
+ VGND sg13g2_nor2_1
XFILLER_4_817 VPWR VGND sg13g2_fill_1
XFILLER_3_327 VPWR VGND sg13g2_decap_8
XFILLER_3_305 VPWR VGND sg13g2_fill_1
XFILLER_47_21 VPWR VGND sg13g2_decap_4
XFILLER_19_206 VPWR VGND sg13g2_fill_2
XFILLER_47_98 VPWR VGND sg13g2_fill_1
XFILLER_19_239 VPWR VGND sg13g2_decap_8
XFILLER_28_740 VPWR VGND sg13g2_decap_8
X_5107__292 VPWR VGND net292 sg13g2_tiehi
XFILLER_16_935 VPWR VGND sg13g2_decap_8
X_5220__336 VPWR VGND net336 sg13g2_tiehi
XFILLER_6_121 VPWR VGND sg13g2_decap_8
XFILLER_6_198 VPWR VGND sg13g2_decap_4
XFILLER_3_883 VPWR VGND sg13g2_decap_8
XFILLER_2_382 VPWR VGND sg13g2_decap_4
XFILLER_38_559 VPWR VGND sg13g2_decap_4
XFILLER_18_272 VPWR VGND sg13g2_decap_8
XFILLER_18_283 VPWR VGND sg13g2_fill_1
XFILLER_22_905 VPWR VGND sg13g2_decap_8
X_4822_ net695 net740 _0157_ VPWR VGND sg13g2_nor2_1
XFILLER_33_275 VPWR VGND sg13g2_fill_1
X_4753_ net699 net745 _0088_ VPWR VGND sg13g2_nor2_1
X_5158__190 VPWR VGND net190 sg13g2_tiehi
X_3704_ videogen.test_lut_thingy.pixel_feeder_inst.row\[17\]\[1\] net565 _1357_ VPWR
+ VGND sg13g2_nor2_1
XFILLER_30_971 VPWR VGND sg13g2_decap_8
X_4684_ net682 net727 _0021_ VPWR VGND sg13g2_nor2_1
X_3635_ net608 _1282_ _1287_ _1288_ VPWR VGND sg13g2_nor3_1
X_3566_ _1216_ _1217_ _1207_ _1219_ VPWR VGND sg13g2_nand3_1
X_5305_ net173 VGND VPWR _0633_ videogen.test_lut_thingy.pixel_feeder_inst.row\[23\]\[3\]
+ _0252_ sg13g2_dfrbpq_1
X_3497_ _1129_ _1134_ _1150_ VPWR VGND sg13g2_and2_1
X_5282__330 VPWR VGND net330 sg13g2_tiehi
X_5236_ net263 VGND VPWR _0564_ videogen.test_lut_thingy.pixel_feeder_inst.row\[45\]\[0\]
+ _0193_ sg13g2_dfrbpq_1
X_5165__172 VPWR VGND net172 sg13g2_tiehi
X_5167_ net168 VGND VPWR _0495_ videogen.test_lut_thingy.pixel_feeder_inst.row\[57\]\[3\]
+ _0132_ sg13g2_dfrbpq_1
X_5098_ net310 VGND VPWR _0426_ videogen.test_lut_thingy.pixel_feeder_inst.row\[32\]\[2\]
+ _0063_ sg13g2_dfrbpq_1
X_4118_ VPWR _1764_ _1763_ VGND sg13g2_inv_1
XFILLER_44_529 VPWR VGND sg13g2_fill_2
X_4049_ _1698_ _1142_ _1657_ VPWR VGND sg13g2_xnor2_1
XFILLER_13_949 VPWR VGND sg13g2_decap_8
XFILLER_8_408 VPWR VGND sg13g2_decap_8
XFILLER_21_971 VPWR VGND sg13g2_decap_8
XFILLER_32_1015 VPWR VGND sg13g2_decap_8
X_5183__90 VPWR VGND net90 sg13g2_tiehi
XFILLER_0_853 VPWR VGND sg13g2_decap_8
XFILLER_48_824 VPWR VGND sg13g2_decap_8
Xhold8 _0282_ VPWR VGND net453 sg13g2_dlygate4sd3_1
XFILLER_16_732 VPWR VGND sg13g2_decap_4
X_5044__390 VPWR VGND net390 sg13g2_tiehi
XFILLER_43_595 VPWR VGND sg13g2_decap_8
X_5075__339 VPWR VGND net339 sg13g2_tiehi
XFILLER_30_289 VPWR VGND sg13g2_fill_2
XFILLER_8_953 VPWR VGND sg13g2_decap_8
XFILLER_7_452 VPWR VGND sg13g2_decap_8
X_3420_ videogen.fancy_shader.n646\[8\] videogen.fancy_shader.video_x\[8\] _1073_
+ VPWR VGND sg13g2_and2_1
X_3351_ _0677_ _0706_ _1004_ _1011_ VPWR VGND sg13g2_nor3_1
X_3282_ VPWR _0958_ _0957_ VGND sg13g2_inv_1
X_5021_ net417 VGND VPWR _0353_ videogen.fancy_shader.video_y\[6\] net647 sg13g2_dfrbpq_2
XFILLER_38_345 VPWR VGND sg13g2_decap_8
X_4945__137 VPWR VGND net137 sg13g2_tiehi
XFILLER_22_735 VPWR VGND sg13g2_decap_8
X_4805_ net705 net750 _0140_ VPWR VGND sg13g2_nor2_1
X_2997_ net767 videogen.test_lut_thingy.pixel_feeder_inst.row\[31\]\[3\] _0815_ _0435_
+ VPWR VGND sg13g2_mux2_1
X_4736_ net673 net718 _0071_ VPWR VGND sg13g2_nor2_1
X_4667_ net458 net814 net667 _0667_ VPWR VGND sg13g2_a21o_1
X_3618_ net612 VPWR _1271_ VGND videogen.test_lut_thingy.pixel_feeder_inst.row\[21\]\[2\]
+ net561 sg13g2_o21ai_1
X_4598_ VGND VPWR _2210_ _2211_ _2209_ _2136_ sg13g2_a21oi_2
XFILLER_0_105 VPWR VGND sg13g2_decap_8
X_3549_ _1202_ _1200_ _1201_ _1120_ _1102_ VPWR VGND sg13g2_a22oi_1
X_5219_ net340 VGND VPWR _0547_ videogen.test_lut_thingy.pixel_feeder_inst.row\[50\]\[3\]
+ _0176_ sg13g2_dfrbpq_1
XFILLER_29_312 VPWR VGND sg13g2_fill_1
XFILLER_45_838 VPWR VGND sg13g2_decap_8
XFILLER_9_706 VPWR VGND sg13g2_fill_2
XFILLER_12_234 VPWR VGND sg13g2_fill_1
XFILLER_9_739 VPWR VGND sg13g2_decap_4
XFILLER_5_923 VPWR VGND sg13g2_decap_8
X_4968__104 VPWR VGND net104 sg13g2_tiehi
XFILLER_0_650 VPWR VGND sg13g2_decap_8
XFILLER_10_8 VPWR VGND sg13g2_decap_4
XFILLER_35_315 VPWR VGND sg13g2_fill_1
XFILLER_35_326 VPWR VGND sg13g2_decap_4
XFILLER_16_540 VPWR VGND sg13g2_fill_2
X_2920_ net783 videogen.test_lut_thingy.pixel_feeder_inst.row\[57\]\[2\] _0797_ _0494_
+ VPWR VGND sg13g2_mux2_1
X_2851_ net792 videogen.test_lut_thingy.pixel_feeder_inst.row\[47\]\[1\] _0783_ _0557_
+ VPWR VGND sg13g2_mux2_1
X_2782_ videogen.test_lut_thingy.pixel_feeder_inst.row\[29\]\[3\] net767 _0760_ _0603_
+ VPWR VGND sg13g2_mux2_1
XFILLER_31_598 VPWR VGND sg13g2_decap_8
X_4521_ _2138_ net619 _2139_ VPWR VGND sg13g2_xor2_1
X_4452_ _0879_ VPWR _2078_ VGND net605 _2076_ sg13g2_o21ai_1
X_3403_ videogen.fancy_shader.video_y\[6\] videogen.fancy_shader.n646\[6\] _1056_
+ VPWR VGND sg13g2_and2_1
X_4383_ _1987_ _2021_ _2022_ VPWR VGND sg13g2_nor2_1
Xfanout707 net709 net707 VPWR VGND sg13g2_buf_8
Xfanout718 net721 net718 VPWR VGND sg13g2_buf_2
X_3334_ _1000_ videogen.fancy_shader.video_y\[2\] _0994_ VPWR VGND sg13g2_xnor2_1
Xfanout729 net733 net729 VPWR VGND sg13g2_buf_8
X_3265_ videogen.test_lut_thingy.pixel_feeder_inst.h_counter\[0\] _0833_ _0947_ VPWR
+ VGND sg13g2_nor2_1
X_5311__46 VPWR VGND net46 sg13g2_tiehi
XFILLER_22_1003 VPWR VGND sg13g2_decap_8
X_5205__426 VPWR VGND net426 sg13g2_tiehi
X_5004_ net37 VGND VPWR _0336_ videogen.test_lut_thingy.pixel_feeder_inst.row\[36\]\[3\]
+ _0032_ sg13g2_dfrbpq_1
X_3196_ _0897_ videogen.fancy_shader.video_x\[8\] _0895_ VPWR VGND sg13g2_xnor2_1
X_4976__93 VPWR VGND net93 sg13g2_tiehi
XFILLER_10_705 VPWR VGND sg13g2_fill_2
XFILLER_14_58 VPWR VGND sg13g2_fill_2
XFILLER_10_738 VPWR VGND sg13g2_decap_4
X_4991__63 VPWR VGND net63 sg13g2_tiehi
X_4719_ net715 net757 _0054_ VPWR VGND sg13g2_nor2_1
XFILLER_2_904 VPWR VGND sg13g2_decap_8
XFILLER_39_44 VPWR VGND sg13g2_fill_2
X_5325__285 VPWR VGND net285 sg13g2_tiehi
XFILLER_39_77 VPWR VGND sg13g2_decap_4
X_5041__393 VPWR VGND net393 sg13g2_tiehi
XFILLER_13_587 VPWR VGND sg13g2_fill_1
XFILLER_5_764 VPWR VGND sg13g2_fill_2
X_3050_ videogen.test_lut_thingy.pixel_feeder_inst.row\[36\]\[0\] net802 _0825_ _0333_
+ VPWR VGND sg13g2_mux2_1
XFILLER_48_462 VPWR VGND sg13g2_decap_8
XFILLER_49_996 VPWR VGND sg13g2_decap_8
XFILLER_48_473 VPWR VGND sg13g2_fill_1
X_5274__424 VPWR VGND net424 sg13g2_tiehi
X_3952_ net609 VPWR _1604_ VGND videogen.test_lut_thingy.pixel_feeder_inst.row\[49\]\[0\]
+ net569 sg13g2_o21ai_1
XFILLER_32_830 VPWR VGND sg13g2_decap_8
X_3883_ _1532_ _1533_ _1534_ _1535_ _1536_ VPWR VGND sg13g2_nor4_1
X_2903_ _0794_ _0748_ _0755_ VPWR VGND sg13g2_nand2_2
X_2834_ videogen.test_lut_thingy.pixel_feeder_inst.row\[44\]\[2\] net782 _0779_ _0570_
+ VPWR VGND sg13g2_mux2_1
XFILLER_31_373 VPWR VGND sg13g2_fill_2
X_4504_ _2110_ _2126_ _2063_ _2127_ VPWR VGND sg13g2_nand3_1
X_2765_ videogen.test_lut_thingy.pixel_feeder_inst.row\[49\]\[0\] net807 _0752_ _0612_
+ VPWR VGND sg13g2_mux2_1
X_2696_ _0683_ _0702_ _0703_ VPWR VGND sg13g2_and2_1
X_4435_ net558 _1996_ _0395_ VPWR VGND sg13g2_nor2_1
X_4366_ _1976_ net552 _2004_ _2006_ VPWR VGND sg13g2_a21o_1
X_3317_ _0988_ videogen.fancy_shader.n646\[7\] _0986_ VPWR VGND sg13g2_nand2_1
Xfanout559 _0880_ net559 VPWR VGND sg13g2_buf_8
X_4297_ net1 _1547_ _1652_ _1943_ VPWR VGND sg13g2_or3_1
X_3248_ _0934_ videogen.test_lut_thingy.pixel_feeder_inst.h_pix\[5\] _0935_ VPWR VGND
+ sg13g2_xor2_1
XFILLER_39_484 VPWR VGND sg13g2_fill_2
XFILLER_39_473 VPWR VGND sg13g2_decap_8
X_3179_ _0832_ _0840_ videogen.fancy_shader.video_x\[4\] _0888_ VPWR VGND _0886_ sg13g2_nand4_1
XFILLER_26_134 VPWR VGND sg13g2_fill_1
XFILLER_25_24 VPWR VGND sg13g2_decap_8
XFILLER_23_874 VPWR VGND sg13g2_decap_8
X_5216__352 VPWR VGND net352 sg13g2_tiehi
XFILLER_41_67 VPWR VGND sg13g2_fill_2
XFILLER_1_255 VPWR VGND sg13g2_decap_8
XFILLER_2_39 VPWR VGND sg13g2_fill_2
X_4965__107 VPWR VGND net107 sg13g2_tiehi
XFILLER_46_911 VPWR VGND sg13g2_decap_8
XFILLER_17_101 VPWR VGND sg13g2_decap_4
XFILLER_45_432 VPWR VGND sg13g2_decap_8
XFILLER_46_988 VPWR VGND sg13g2_decap_8
XFILLER_32_115 VPWR VGND sg13g2_fill_2
XFILLER_13_340 VPWR VGND sg13g2_fill_1
XFILLER_32_148 VPWR VGND sg13g2_fill_2
XFILLER_9_344 VPWR VGND sg13g2_fill_2
X_5117__272 VPWR VGND net272 sg13g2_tiehi
X_4220_ _1866_ _1666_ _1771_ VPWR VGND sg13g2_xnor2_1
X_5263__125 VPWR VGND net125 sg13g2_tiehi
X_4151_ _1797_ _1774_ _1793_ VPWR VGND sg13g2_xnor2_1
X_3102_ VGND VPWR _0851_ videogen.test_lut_thingy.pixel_feeder_inst.state\[3\] videogen.test_lut_thingy.pixel_feeder_inst.state\[1\]
+ sg13g2_or2_1
X_4082_ _1729_ _1730_ _1727_ _1731_ VPWR VGND sg13g2_nand3_1
XFILLER_49_793 VPWR VGND sg13g2_decap_8
X_3033_ videogen.test_lut_thingy.pixel_feeder_inst.row\[11\]\[2\] net787 _0822_ _0392_
+ VPWR VGND sg13g2_mux2_1
XFILLER_37_955 VPWR VGND sg13g2_fill_2
XFILLER_36_421 VPWR VGND sg13g2_fill_1
XFILLER_24_627 VPWR VGND sg13g2_decap_8
X_4984_ net77 VGND VPWR _0316_ videogen.test_lut_thingy.pixel_feeder_inst.h_pix\[5\]
+ net644 sg13g2_dfrbpq_2
XFILLER_23_137 VPWR VGND sg13g2_decap_4
XFILLER_36_498 VPWR VGND sg13g2_fill_1
X_3935_ videogen.test_lut_thingy.pixel_feeder_inst.row\[28\]\[0\] net594 _1587_ VPWR
+ VGND sg13g2_nor2_1
XFILLER_20_811 VPWR VGND sg13g2_fill_1
X_3866_ net606 _1513_ _1518_ _1519_ VPWR VGND sg13g2_nor3_1
X_2817_ videogen.test_lut_thingy.pixel_feeder_inst.row\[41\]\[0\] net803 _0772_ _0580_
+ VPWR VGND sg13g2_mux2_1
X_3797_ VGND VPWR _1450_ _1449_ _1351_ sg13g2_or2_1
X_2748_ _0743_ _0726_ _0742_ VPWR VGND sg13g2_nand2_2
X_4418_ net605 net558 _0383_ VPWR VGND sg13g2_nor2_1
X_2679_ VPWR _0687_ videogen.fancy_shader.video_x\[7\] VGND sg13g2_inv_1
X_4349_ _1990_ _1986_ _1989_ VPWR VGND sg13g2_nand2_1
XFILLER_39_270 VPWR VGND sg13g2_decap_8
XFILLER_28_911 VPWR VGND sg13g2_decap_4
XFILLER_28_933 VPWR VGND sg13g2_fill_1
XFILLER_28_944 VPWR VGND sg13g2_fill_1
XFILLER_27_487 VPWR VGND sg13g2_fill_2
XFILLER_42_435 VPWR VGND sg13g2_decap_4
XFILLER_11_800 VPWR VGND sg13g2_decap_4
XFILLER_14_159 VPWR VGND sg13g2_decap_4
XFILLER_7_826 VPWR VGND sg13g2_decap_8
XFILLER_19_900 VPWR VGND sg13g2_decap_8
XFILLER_28_9 VPWR VGND sg13g2_decap_8
XFILLER_19_977 VPWR VGND sg13g2_decap_8
XFILLER_33_446 VPWR VGND sg13g2_decap_4
XFILLER_34_969 VPWR VGND sg13g2_fill_2
XFILLER_42_980 VPWR VGND sg13g2_decap_8
X_3720_ net610 _1367_ _1372_ _1373_ VPWR VGND sg13g2_nor3_1
XFILLER_20_129 VPWR VGND sg13g2_decap_8
X_3651_ videogen.test_lut_thingy.pixel_feeder_inst.row\[56\]\[2\] net598 _1304_ VPWR
+ VGND sg13g2_nor2_1
X_5234__271 VPWR VGND net271 sg13g2_tiehi
X_3582_ _1171_ _1234_ _1235_ VPWR VGND sg13g2_nor2_1
X_5321_ net326 VGND VPWR _0649_ serialize.shift_reg_b\[7\] clknet_3_0_0_clk_regs sg13g2_dfrbpq_1
XFILLER_6_892 VPWR VGND sg13g2_decap_8
X_5252_ net199 VGND VPWR _0580_ videogen.test_lut_thingy.pixel_feeder_inst.row\[41\]\[0\]
+ _0209_ sg13g2_dfrbpq_1
X_5183_ net90 VGND VPWR _0511_ green_tmds_par\[9\] net660 sg13g2_dfrbpq_1
X_4203_ _1847_ _1848_ _1834_ _1849_ VPWR VGND sg13g2_nand3_1
X_4134_ _1110_ _1772_ _1104_ _1780_ VPWR VGND sg13g2_nand3_1
X_4065_ _1706_ _1710_ _1698_ _1714_ VPWR VGND sg13g2_nand3_1
X_3016_ _0761_ _0806_ _0819_ VPWR VGND sg13g2_nor2_2
XFILLER_24_413 VPWR VGND sg13g2_decap_8
XFILLER_25_947 VPWR VGND sg13g2_decap_8
XFILLER_36_295 VPWR VGND sg13g2_fill_2
XFILLER_19_1019 VPWR VGND sg13g2_decap_4
X_4967_ net105 VGND VPWR _0299_ videogen.fancy_shader.video_x\[5\] net647 sg13g2_dfrbpq_1
X_4898_ net696 net741 _0233_ VPWR VGND sg13g2_nor2_1
X_3918_ videogen.test_lut_thingy.pixel_feeder_inst.row\[4\]\[0\] net598 _1570_ VPWR
+ VGND sg13g2_nor2_1
X_3849_ _1498_ _1499_ _1500_ _1501_ _1502_ VPWR VGND sg13g2_nor4_1
XFILLER_0_7 VPWR VGND sg13g2_decap_8
XFILLER_47_549 VPWR VGND sg13g2_decap_8
XFILLER_16_914 VPWR VGND sg13g2_decap_8
XFILLER_27_262 VPWR VGND sg13g2_fill_2
XFILLER_42_221 VPWR VGND sg13g2_fill_1
XFILLER_43_755 VPWR VGND sg13g2_fill_1
XFILLER_42_232 VPWR VGND sg13g2_fill_2
XFILLER_31_906 VPWR VGND sg13g2_decap_8
XFILLER_31_928 VPWR VGND sg13g2_decap_4
XFILLER_15_479 VPWR VGND sg13g2_decap_4
XFILLER_6_144 VPWR VGND sg13g2_fill_1
XFILLER_7_689 VPWR VGND sg13g2_decap_8
XFILLER_3_862 VPWR VGND sg13g2_decap_8
XFILLER_19_730 VPWR VGND sg13g2_fill_2
XFILLER_19_763 VPWR VGND sg13g2_decap_8
XFILLER_46_582 VPWR VGND sg13g2_decap_8
X_4821_ net700 net745 _0156_ VPWR VGND sg13g2_nor2_1
XFILLER_33_243 VPWR VGND sg13g2_fill_1
XFILLER_15_980 VPWR VGND sg13g2_decap_8
XFILLER_21_405 VPWR VGND sg13g2_fill_2
XFILLER_21_449 VPWR VGND sg13g2_decap_4
X_4752_ net701 net746 _0087_ VPWR VGND sg13g2_nor2_1
XFILLER_30_950 VPWR VGND sg13g2_decap_8
X_3703_ _1352_ _1353_ _1354_ _1355_ _1356_ VPWR VGND sg13g2_nor4_1
X_4683_ net677 net722 _0020_ VPWR VGND sg13g2_nor2_1
X_3634_ _1283_ _1284_ _1285_ _1286_ _1287_ VPWR VGND sg13g2_nor4_1
X_3565_ _1216_ _1217_ _1218_ VPWR VGND sg13g2_and2_1
X_5304_ net181 VGND VPWR _0632_ videogen.test_lut_thingy.pixel_feeder_inst.row\[23\]\[2\]
+ _0251_ sg13g2_dfrbpq_1
X_3496_ _1146_ _1147_ _1144_ _1149_ VPWR VGND sg13g2_nand3_1
X_5235_ net267 VGND VPWR _0563_ videogen.test_lut_thingy.pixel_feeder_inst.row\[46\]\[3\]
+ _0192_ sg13g2_dfrbpq_1
X_5166_ net170 VGND VPWR _0494_ videogen.test_lut_thingy.pixel_feeder_inst.row\[57\]\[2\]
+ _0131_ sg13g2_dfrbpq_1
X_5097_ net312 VGND VPWR _0425_ videogen.test_lut_thingy.pixel_feeder_inst.row\[32\]\[1\]
+ _0062_ sg13g2_dfrbpq_1
X_4117_ _1763_ _1759_ _1762_ VPWR VGND sg13g2_xnor2_1
X_4048_ VGND VPWR _1697_ _1695_ _1683_ sg13g2_or2_1
XFILLER_25_744 VPWR VGND sg13g2_fill_1
XFILLER_13_928 VPWR VGND sg13g2_decap_8
XFILLER_25_799 VPWR VGND sg13g2_decap_8
XFILLER_21_950 VPWR VGND sg13g2_decap_8
XFILLER_20_482 VPWR VGND sg13g2_fill_1
X_5248__215 VPWR VGND net215 sg13g2_tiehi
XFILLER_3_136 VPWR VGND sg13g2_decap_8
XFILLER_0_832 VPWR VGND sg13g2_decap_8
XFILLER_48_803 VPWR VGND sg13g2_decap_8
XFILLER_47_313 VPWR VGND sg13g2_fill_2
Xhold9 serialize.shift_reg_c\[2\] VPWR VGND net454 sg13g2_dlygate4sd3_1
XFILLER_47_346 VPWR VGND sg13g2_decap_8
XFILLER_43_541 VPWR VGND sg13g2_fill_1
XFILLER_15_287 VPWR VGND sg13g2_fill_1
XFILLER_31_725 VPWR VGND sg13g2_fill_1
XFILLER_8_932 VPWR VGND sg13g2_decap_8
X_3350_ _0677_ VPWR _1010_ VGND _0706_ _1004_ sg13g2_o21ai_1
X_3281_ videogen.fancy_shader.n646\[1\] videogen.fancy_shader.n646\[0\] videogen.fancy_shader.n646\[2\]
+ _0957_ VPWR VGND _0908_ sg13g2_nand4_1
X_5020_ net419 VGND VPWR _0352_ videogen.fancy_shader.video_y\[5\] net651 sg13g2_dfrbpq_1
XFILLER_0_1014 VPWR VGND sg13g2_decap_8
XFILLER_22_747 VPWR VGND sg13g2_decap_8
X_4804_ net705 net750 _0139_ VPWR VGND sg13g2_nor2_1
X_4735_ net673 net718 _0070_ VPWR VGND sg13g2_nor2_1
X_2996_ _0742_ _0755_ _0726_ _0815_ VPWR VGND sg13g2_nand3_1
X_4666_ net763 clockdiv.q0 net446 _0666_ VPWR VGND sg13g2_nor3_1
X_3617_ _1266_ _1267_ _1268_ _1269_ _1270_ VPWR VGND sg13g2_nor4_1
X_4597_ _2210_ net620 tmds_blue.dc_balancing_reg\[4\] VPWR VGND sg13g2_nand2b_1
X_3548_ _1193_ _1197_ _1101_ _1201_ VPWR VGND sg13g2_nand3_1
X_3479_ net553 _1131_ _1130_ _1132_ VPWR VGND sg13g2_mux2_1
X_5218_ net344 VGND VPWR _0546_ videogen.test_lut_thingy.pixel_feeder_inst.row\[50\]\[2\]
+ _0175_ sg13g2_dfrbpq_1
X_5149_ net208 VGND VPWR _0477_ videogen.test_lut_thingy.pixel_feeder_inst.row\[61\]\[1\]
+ _0114_ sg13g2_dfrbpq_1
XFILLER_29_379 VPWR VGND sg13g2_decap_8
XFILLER_44_327 VPWR VGND sg13g2_fill_1
XFILLER_13_725 VPWR VGND sg13g2_decap_8
XFILLER_44_78 VPWR VGND sg13g2_fill_1
XFILLER_5_902 VPWR VGND sg13g2_decap_8
XFILLER_5_979 VPWR VGND sg13g2_decap_8
XFILLER_5_39 VPWR VGND sg13g2_fill_2
XFILLER_48_666 VPWR VGND sg13g2_fill_2
XFILLER_48_655 VPWR VGND sg13g2_decap_8
XFILLER_44_850 VPWR VGND sg13g2_decap_8
XFILLER_18_90 VPWR VGND sg13g2_decap_8
XFILLER_16_574 VPWR VGND sg13g2_decap_8
X_2850_ net782 videogen.test_lut_thingy.pixel_feeder_inst.row\[47\]\[2\] _0783_ _0558_
+ VPWR VGND sg13g2_mux2_1
XFILLER_15_1022 VPWR VGND sg13g2_decap_8
XFILLER_31_555 VPWR VGND sg13g2_fill_2
XFILLER_8_740 VPWR VGND sg13g2_decap_4
X_2781_ _0743_ _0759_ _0760_ VPWR VGND sg13g2_nor2_2
X_4520_ tmds_blue.dc_balancing_reg\[4\] _0690_ _2137_ _2138_ VPWR VGND sg13g2_a21o_2
XFILLER_8_773 VPWR VGND sg13g2_decap_8
X_4451_ VPWR _2077_ _2076_ VGND sg13g2_inv_1
X_3402_ videogen.fancy_shader.n646\[7\] videogen.fancy_shader.video_y\[7\] _1055_
+ VPWR VGND sg13g2_xor2_1
X_4382_ _1984_ _1986_ _2021_ VPWR VGND sg13g2_and2_1
Xfanout708 net709 net708 VPWR VGND sg13g2_buf_8
X_3333_ _0999_ net813 _0998_ VPWR VGND sg13g2_nand2_1
Xfanout719 net720 net719 VPWR VGND sg13g2_buf_8
XFILLER_39_611 VPWR VGND sg13g2_fill_2
X_3264_ _0946_ _0848_ _0924_ VPWR VGND sg13g2_nand2_2
X_5127__252 VPWR VGND net252 sg13g2_tiehi
X_5003_ net39 VGND VPWR _0335_ videogen.test_lut_thingy.pixel_feeder_inst.row\[36\]\[2\]
+ _0031_ sg13g2_dfrbpq_1
X_3195_ _0889_ _0895_ _0896_ _0301_ VPWR VGND sg13g2_nor3_1
XFILLER_22_500 VPWR VGND sg13g2_fill_2
X_5058__368 VPWR VGND net368 sg13g2_tiehi
XFILLER_14_37 VPWR VGND sg13g2_decap_4
XFILLER_22_577 VPWR VGND sg13g2_decap_4
X_5767_ net613 net12 VPWR VGND sg13g2_buf_1
X_2979_ videogen.test_lut_thingy.pixel_feeder_inst.row\[6\]\[1\] net795 _0811_ _0449_
+ VPWR VGND sg13g2_mux2_1
X_4718_ net710 net755 _0053_ VPWR VGND sg13g2_nor2_1
X_4649_ VPWR _0657_ _2239_ VGND sg13g2_inv_1
XFILLER_1_415 VPWR VGND sg13g2_decap_4
XFILLER_1_448 VPWR VGND sg13g2_decap_8
XFILLER_1_459 VPWR VGND sg13g2_fill_1
XFILLER_49_419 VPWR VGND sg13g2_decap_8
XFILLER_29_121 VPWR VGND sg13g2_fill_1
XFILLER_29_154 VPWR VGND sg13g2_fill_1
XFILLER_45_647 VPWR VGND sg13g2_fill_2
XFILLER_44_179 VPWR VGND sg13g2_decap_8
XFILLER_44_168 VPWR VGND sg13g2_fill_1
XFILLER_25_360 VPWR VGND sg13g2_decap_4
XFILLER_40_385 VPWR VGND sg13g2_fill_1
XFILLER_9_537 VPWR VGND sg13g2_decap_8
XFILLER_9_548 VPWR VGND sg13g2_fill_2
XFILLER_5_721 VPWR VGND sg13g2_fill_1
XFILLER_5_787 VPWR VGND sg13g2_decap_4
XFILLER_4_264 VPWR VGND sg13g2_decap_8
XFILLER_45_1004 VPWR VGND sg13g2_decap_8
XFILLER_1_993 VPWR VGND sg13g2_decap_8
XFILLER_49_975 VPWR VGND sg13g2_decap_8
XFILLER_48_441 VPWR VGND sg13g2_decap_8
XFILLER_36_636 VPWR VGND sg13g2_fill_2
XFILLER_36_647 VPWR VGND sg13g2_fill_1
X_5337__113 VPWR VGND net113 sg13g2_tiehi
XFILLER_16_360 VPWR VGND sg13g2_decap_8
X_3951_ _1599_ _1600_ _1601_ _1602_ _1603_ VPWR VGND sg13g2_nor4_1
X_2902_ videogen.test_lut_thingy.pixel_feeder_inst.row\[28\]\[0\] net800 _0793_ _0516_
+ VPWR VGND sg13g2_mux2_1
X_3882_ videogen.test_lut_thingy.pixel_feeder_inst.row\[8\]\[3\] net600 _1535_ VPWR
+ VGND sg13g2_nor2_1
XFILLER_32_875 VPWR VGND sg13g2_fill_1
XFILLER_32_886 VPWR VGND sg13g2_fill_2
X_2833_ videogen.test_lut_thingy.pixel_feeder_inst.row\[44\]\[3\] net769 _0779_ _0571_
+ VPWR VGND sg13g2_mux2_1
X_2764_ videogen.test_lut_thingy.pixel_feeder_inst.row\[49\]\[1\] net797 _0752_ _0613_
+ VPWR VGND sg13g2_mux2_1
X_4503_ _2126_ _2110_ _2115_ VPWR VGND sg13g2_nand2_1
XFILLER_8_570 VPWR VGND sg13g2_fill_1
X_2695_ net629 net634 net593 _0702_ VPWR VGND sg13g2_nor3_1
X_4434_ net558 _2068_ _0394_ VPWR VGND sg13g2_nor2_1
X_4365_ VPWR _2005_ _2004_ VGND sg13g2_inv_1
X_3316_ _0679_ VPWR _0987_ VGND _0680_ _0984_ sg13g2_o21ai_1
X_4296_ _1942_ _1937_ _1940_ VPWR VGND sg13g2_nand2_1
XFILLER_39_452 VPWR VGND sg13g2_decap_8
X_3247_ _0315_ _0848_ _0933_ _0934_ VPWR VGND sg13g2_and3_1
X_3178_ _0887_ _0832_ _0841_ _0886_ VPWR VGND sg13g2_and3_2
XFILLER_14_308 VPWR VGND sg13g2_fill_2
XFILLER_42_639 VPWR VGND sg13g2_fill_2
XFILLER_41_116 VPWR VGND sg13g2_decap_4
XFILLER_23_853 VPWR VGND sg13g2_decap_8
XFILLER_10_514 VPWR VGND sg13g2_decap_8
XFILLER_10_525 VPWR VGND sg13g2_fill_1
XFILLER_49_216 VPWR VGND sg13g2_decap_4
XFILLER_2_18 VPWR VGND sg13g2_decap_8
X_5223__324 VPWR VGND net324 sg13g2_tiehi
XFILLER_45_400 VPWR VGND sg13g2_decap_4
XFILLER_46_967 VPWR VGND sg13g2_decap_8
XFILLER_18_658 VPWR VGND sg13g2_decap_8
XFILLER_45_466 VPWR VGND sg13g2_decap_8
XFILLER_32_127 VPWR VGND sg13g2_decap_4
XFILLER_33_639 VPWR VGND sg13g2_decap_4
XFILLER_9_301 VPWR VGND sg13g2_fill_1
XFILLER_15_80 VPWR VGND sg13g2_decap_8
XFILLER_9_356 VPWR VGND sg13g2_decap_8
XFILLER_31_90 VPWR VGND sg13g2_decap_8
XFILLER_5_584 VPWR VGND sg13g2_fill_1
X_4150_ _1796_ _1770_ _1795_ VPWR VGND sg13g2_nand2b_1
X_3101_ _0850_ videogen.test_lut_thingy.pixel_feeder_inst.state\[1\] _0833_ VPWR VGND
+ sg13g2_nand2b_1
XFILLER_37_901 VPWR VGND sg13g2_fill_1
X_4081_ _1728_ _1714_ _1701_ _1730_ VPWR VGND sg13g2_a21o_1
XFILLER_49_772 VPWR VGND sg13g2_decap_8
X_3032_ videogen.test_lut_thingy.pixel_feeder_inst.row\[11\]\[3\] net776 _0822_ _0393_
+ VPWR VGND sg13g2_mux2_1
XFILLER_36_400 VPWR VGND sg13g2_fill_2
XFILLER_48_282 VPWR VGND sg13g2_decap_4
XFILLER_36_444 VPWR VGND sg13g2_fill_2
XFILLER_24_606 VPWR VGND sg13g2_decap_8
X_4983_ net79 VGND VPWR _0315_ videogen.test_lut_thingy.pixel_feeder_inst.h_pix\[4\]
+ net644 sg13g2_dfrbpq_2
X_3934_ net629 VPWR _1586_ VGND videogen.test_lut_thingy.pixel_feeder_inst.row\[30\]\[0\]
+ net582 sg13g2_o21ai_1
X_3865_ _1514_ _1515_ _1516_ _1517_ _1518_ VPWR VGND sg13g2_nor4_1
XFILLER_20_823 VPWR VGND sg13g2_decap_8
X_2816_ videogen.test_lut_thingy.pixel_feeder_inst.row\[41\]\[1\] net792 _0772_ _0581_
+ VPWR VGND sg13g2_mux2_1
XFILLER_20_856 VPWR VGND sg13g2_fill_1
XFILLER_31_182 VPWR VGND sg13g2_decap_4
XFILLER_9_890 VPWR VGND sg13g2_decap_8
X_3796_ _1448_ VPWR _1449_ VGND _0693_ net2 sg13g2_o21ai_1
X_2747_ _0742_ net555 VPWR VGND net554 sg13g2_nand2b_2
X_2678_ VPWR _0686_ videogen.test_lut_thingy.pixel_feeder_inst.v_pix\[2\] VGND sg13g2_inv_1
X_4417_ VGND VPWR _2047_ _2054_ _0378_ net558 sg13g2_a21oi_1
XFILLER_28_1010 VPWR VGND sg13g2_decap_8
X_5027__407 VPWR VGND net407 sg13g2_tiehi
X_4348_ _1984_ _1987_ _1989_ VPWR VGND sg13g2_nor2_2
XFILLER_47_709 VPWR VGND sg13g2_fill_2
X_4279_ VPWR _1925_ _1924_ VGND sg13g2_inv_1
XFILLER_46_208 VPWR VGND sg13g2_decap_4
XFILLER_27_400 VPWR VGND sg13g2_decap_4
XFILLER_27_422 VPWR VGND sg13g2_fill_2
XFILLER_27_444 VPWR VGND sg13g2_fill_2
XFILLER_36_46 VPWR VGND sg13g2_decap_8
XFILLER_28_989 VPWR VGND sg13g2_decap_8
XFILLER_35_1014 VPWR VGND sg13g2_decap_8
XFILLER_22_182 VPWR VGND sg13g2_decap_4
X_4971__101 VPWR VGND net101 sg13g2_tiehi
XFILLER_6_348 VPWR VGND sg13g2_fill_2
XFILLER_18_422 VPWR VGND sg13g2_fill_2
XFILLER_19_956 VPWR VGND sg13g2_decap_8
XFILLER_46_786 VPWR VGND sg13g2_fill_2
XFILLER_45_252 VPWR VGND sg13g2_fill_1
XFILLER_34_915 VPWR VGND sg13g2_decap_8
XFILLER_9_120 VPWR VGND sg13g2_decap_4
XFILLER_9_164 VPWR VGND sg13g2_fill_2
X_3650_ net632 VPWR _1303_ VGND videogen.test_lut_thingy.pixel_feeder_inst.row\[57\]\[2\]
+ net565 sg13g2_o21ai_1
X_3581_ _1231_ _1232_ _1227_ _1234_ VPWR VGND sg13g2_nand3_1
X_5320_ net334 VGND VPWR _0648_ serialize.shift_reg_b\[6\] clknet_3_0_0_clk_regs sg13g2_dfrbpq_1
X_5251_ net203 VGND VPWR _0579_ videogen.test_lut_thingy.pixel_feeder_inst.row\[42\]\[3\]
+ _0208_ sg13g2_dfrbpq_1
X_4202_ _1754_ VPWR _1848_ VGND _1843_ _1846_ sg13g2_o21ai_1
X_5182_ net92 VGND VPWR _0510_ green_tmds_par\[8\] net656 sg13g2_dfrbpq_1
X_4133_ _1779_ _1104_ _1772_ VPWR VGND sg13g2_nand2_1
X_4064_ _1713_ _1682_ _1712_ VPWR VGND sg13g2_xnor2_1
X_5241__243 VPWR VGND net243 sg13g2_tiehi
XFILLER_3_1023 VPWR VGND sg13g2_decap_4
X_3015_ videogen.test_lut_thingy.pixel_feeder_inst.row\[13\]\[0\] net808 _0818_ _0411_
+ VPWR VGND sg13g2_mux2_1
XFILLER_25_904 VPWR VGND sg13g2_fill_1
XFILLER_25_926 VPWR VGND sg13g2_decap_8
XFILLER_24_447 VPWR VGND sg13g2_decap_8
XFILLER_24_458 VPWR VGND sg13g2_fill_2
X_4966_ net106 VGND VPWR _0298_ videogen.fancy_shader.video_x\[4\] net647 sg13g2_dfrbpq_2
X_4897_ net673 net718 _0232_ VPWR VGND sg13g2_nor2_1
X_3917_ videogen.test_lut_thingy.pixel_feeder_inst.row\[5\]\[0\] net566 _1569_ VPWR
+ VGND sg13g2_nor2_1
X_3848_ videogen.test_lut_thingy.pixel_feeder_inst.row\[25\]\[3\] net565 _1501_ VPWR
+ VGND sg13g2_nor2_1
X_3779_ _1428_ _1429_ _1430_ _1431_ _1432_ VPWR VGND sg13g2_nor4_1
XFILLER_47_528 VPWR VGND sg13g2_decap_8
XFILLER_19_208 VPWR VGND sg13g2_fill_1
XFILLER_28_786 VPWR VGND sg13g2_fill_2
XFILLER_43_723 VPWR VGND sg13g2_decap_8
XFILLER_15_425 VPWR VGND sg13g2_fill_2
XFILLER_15_458 VPWR VGND sg13g2_decap_8
XFILLER_15_469 VPWR VGND sg13g2_fill_1
XFILLER_8_39 VPWR VGND sg13g2_decap_8
XFILLER_7_624 VPWR VGND sg13g2_fill_2
XFILLER_7_602 VPWR VGND sg13g2_decap_8
XFILLER_10_130 VPWR VGND sg13g2_fill_1
XFILLER_7_646 VPWR VGND sg13g2_fill_1
XFILLER_10_196 VPWR VGND sg13g2_fill_2
XFILLER_6_178 VPWR VGND sg13g2_fill_2
XFILLER_46_561 VPWR VGND sg13g2_decap_8
XFILLER_19_797 VPWR VGND sg13g2_decap_4
X_4820_ net700 net744 _0155_ VPWR VGND sg13g2_nor2_1
X_4751_ net700 net745 _0086_ VPWR VGND sg13g2_nor2_1
X_3702_ net636 VPWR _1355_ VGND videogen.test_lut_thingy.pixel_feeder_inst.row\[23\]\[1\]
+ net575 sg13g2_o21ai_1
X_4682_ net677 net722 _0019_ VPWR VGND sg13g2_nor2_1
X_3633_ videogen.test_lut_thingy.pixel_feeder_inst.row\[12\]\[2\] net600 _1286_ VPWR
+ VGND sg13g2_nor2_1
X_3564_ _1217_ _1039_ _1213_ VPWR VGND sg13g2_nand2b_1
X_5303_ net193 VGND VPWR _0631_ videogen.test_lut_thingy.pixel_feeder_inst.row\[23\]\[1\]
+ _0250_ sg13g2_dfrbpq_1
X_3495_ _1146_ _1147_ _1148_ VPWR VGND sg13g2_and2_1
X_5234_ net271 VGND VPWR _0562_ videogen.test_lut_thingy.pixel_feeder_inst.row\[46\]\[2\]
+ _0191_ sg13g2_dfrbpq_1
X_5208__414 VPWR VGND net414 sg13g2_tiehi
X_5165_ net172 VGND VPWR _0493_ videogen.test_lut_thingy.pixel_feeder_inst.row\[57\]\[1\]
+ _0130_ sg13g2_dfrbpq_1
XFILLER_25_1024 VPWR VGND sg13g2_decap_4
X_4116_ _1760_ _1038_ _1762_ VPWR VGND sg13g2_xor2_1
X_5096_ net314 VGND VPWR _0424_ videogen.test_lut_thingy.pixel_feeder_inst.row\[32\]\[0\]
+ _0061_ sg13g2_dfrbpq_1
XFILLER_37_550 VPWR VGND sg13g2_decap_8
X_4047_ _1683_ _1695_ _1696_ VPWR VGND sg13g2_and2_1
XFILLER_13_907 VPWR VGND sg13g2_decap_8
X_4949_ net131 VGND VPWR net449 serialize.shift_reg_c\[2\] clknet_3_2_0_clk_regs sg13g2_dfrbpq_1
X_5137__232 VPWR VGND net232 sg13g2_tiehi
XFILLER_20_472 VPWR VGND sg13g2_decap_4
XFILLER_20_494 VPWR VGND sg13g2_decap_4
XFILLER_3_148 VPWR VGND sg13g2_fill_2
XFILLER_0_811 VPWR VGND sg13g2_decap_8
XFILLER_0_888 VPWR VGND sg13g2_decap_8
XFILLER_48_859 VPWR VGND sg13g2_decap_8
XFILLER_43_586 VPWR VGND sg13g2_fill_1
XFILLER_15_266 VPWR VGND sg13g2_decap_4
XFILLER_31_737 VPWR VGND sg13g2_decap_8
XFILLER_8_911 VPWR VGND sg13g2_decap_8
XFILLER_12_984 VPWR VGND sg13g2_decap_8
XFILLER_8_988 VPWR VGND sg13g2_decap_8
XFILLER_48_1013 VPWR VGND sg13g2_decap_8
XFILLER_3_682 VPWR VGND sg13g2_fill_1
XFILLER_3_671 VPWR VGND sg13g2_decap_8
X_3280_ videogen.fancy_shader.n646\[2\] _0954_ _0956_ VPWR VGND sg13g2_nor2b_1
XFILLER_24_4 VPWR VGND sg13g2_decap_8
XFILLER_38_358 VPWR VGND sg13g2_decap_8
XFILLER_47_881 VPWR VGND sg13g2_decap_8
XFILLER_0_84 VPWR VGND sg13g2_decap_8
XFILLER_19_594 VPWR VGND sg13g2_fill_1
X_4803_ net690 net735 _0138_ VPWR VGND sg13g2_nor2_1
XFILLER_21_214 VPWR VGND sg13g2_decap_4
X_2995_ videogen.test_lut_thingy.pixel_feeder_inst.row\[34\]\[0\] net802 _0814_ _0436_
+ VPWR VGND sg13g2_mux2_1
X_4734_ net673 net718 _0069_ VPWR VGND sg13g2_nor2_1
XFILLER_21_247 VPWR VGND sg13g2_decap_8
XFILLER_21_269 VPWR VGND sg13g2_decap_8
X_4665_ VPWR _0665_ _2247_ VGND sg13g2_inv_1
X_3616_ videogen.test_lut_thingy.pixel_feeder_inst.row\[30\]\[2\] net582 _1269_ VPWR
+ VGND sg13g2_nor2_1
X_4596_ net619 blue\[1\] _2209_ VPWR VGND sg13g2_xor2_1
X_3547_ _1114_ VPWR _1200_ VGND _1095_ net553 sg13g2_o21ai_1
X_3478_ _1131_ net553 _1115_ VPWR VGND sg13g2_xnor2_1
X_5217_ net348 VGND VPWR _0545_ videogen.test_lut_thingy.pixel_feeder_inst.row\[50\]\[1\]
+ _0174_ sg13g2_dfrbpq_1
XFILLER_29_303 VPWR VGND sg13g2_decap_8
X_5148_ net210 VGND VPWR _0476_ videogen.test_lut_thingy.pixel_feeder_inst.row\[61\]\[0\]
+ _0113_ sg13g2_dfrbpq_1
X_5079_ net331 VGND VPWR _0411_ videogen.test_lut_thingy.pixel_feeder_inst.row\[13\]\[0\]
+ _0057_ sg13g2_dfrbpq_1
XFILLER_44_306 VPWR VGND sg13g2_fill_2
X_5219__340 VPWR VGND net340 sg13g2_tiehi
XFILLER_40_534 VPWR VGND sg13g2_decap_8
X_5074__341 VPWR VGND net341 sg13g2_tiehi
XFILLER_5_958 VPWR VGND sg13g2_decap_8
XFILLER_4_468 VPWR VGND sg13g2_fill_1
XFILLER_4_457 VPWR VGND sg13g2_fill_2
XFILLER_48_634 VPWR VGND sg13g2_decap_8
XFILLER_0_685 VPWR VGND sg13g2_decap_8
XFILLER_47_188 VPWR VGND sg13g2_fill_1
XFILLER_36_829 VPWR VGND sg13g2_decap_8
XFILLER_16_542 VPWR VGND sg13g2_fill_1
XFILLER_31_534 VPWR VGND sg13g2_decap_8
XFILLER_15_1001 VPWR VGND sg13g2_decap_8
XFILLER_12_770 VPWR VGND sg13g2_fill_1
X_2780_ _0730_ _0732_ net613 _0759_ VPWR VGND sg13g2_nand3_1
XFILLER_11_280 VPWR VGND sg13g2_decap_8
X_4450_ _2076_ tmds_green.dc_balancing_reg\[1\] _2060_ VPWR VGND sg13g2_xnor2_1
X_3401_ videogen.fancy_shader.video_y\[7\] videogen.fancy_shader.n646\[7\] _1054_
+ VPWR VGND sg13g2_nor2_1
X_4381_ VGND VPWR _1976_ _2012_ _2020_ _2011_ sg13g2_a21oi_1
X_3332_ _0900_ _0996_ _0887_ _0998_ VPWR VGND _0997_ sg13g2_nand4_1
Xfanout709 net716 net709 VPWR VGND sg13g2_buf_8
X_3263_ _0936_ _0945_ _0320_ VPWR VGND sg13g2_nor2_1
XFILLER_38_100 VPWR VGND sg13g2_fill_1
X_3194_ videogen.fancy_shader.video_x\[7\] _0844_ _0896_ VPWR VGND sg13g2_nor2_1
X_5002_ net41 VGND VPWR _0334_ videogen.test_lut_thingy.pixel_feeder_inst.row\[36\]\[1\]
+ _0030_ sg13g2_dfrbpq_1
XFILLER_38_188 VPWR VGND sg13g2_decap_8
XFILLER_26_306 VPWR VGND sg13g2_decap_8
XFILLER_27_829 VPWR VGND sg13g2_fill_1
XFILLER_34_361 VPWR VGND sg13g2_decap_8
XFILLER_22_534 VPWR VGND sg13g2_decap_8
XFILLER_34_372 VPWR VGND sg13g2_fill_1
XFILLER_35_895 VPWR VGND sg13g2_fill_2
X_5766_ videogen.mem_row net11 VPWR VGND sg13g2_buf_8
X_2978_ videogen.test_lut_thingy.pixel_feeder_inst.row\[6\]\[2\] net784 _0811_ _0450_
+ VPWR VGND sg13g2_mux2_1
X_4717_ net706 net751 _0052_ VPWR VGND sg13g2_nor2_1
X_4648_ _2239_ net665 net474 net669 green_tmds_par\[7\] VPWR VGND sg13g2_a22oi_1
X_4579_ _2195_ _2141_ _2194_ VPWR VGND sg13g2_nand2_1
XFILLER_2_939 VPWR VGND sg13g2_decap_8
XFILLER_39_57 VPWR VGND sg13g2_fill_1
XFILLER_29_133 VPWR VGND sg13g2_decap_8
XFILLER_45_626 VPWR VGND sg13g2_decap_8
XFILLER_17_328 VPWR VGND sg13g2_decap_4
XFILLER_18_829 VPWR VGND sg13g2_decap_8
XFILLER_29_199 VPWR VGND sg13g2_decap_4
XFILLER_1_972 VPWR VGND sg13g2_decap_8
XFILLER_0_482 VPWR VGND sg13g2_decap_8
XFILLER_49_954 VPWR VGND sg13g2_decap_8
XFILLER_35_114 VPWR VGND sg13g2_fill_2
XFILLER_35_147 VPWR VGND sg13g2_decap_4
XFILLER_17_862 VPWR VGND sg13g2_decap_4
X_3950_ videogen.test_lut_thingy.pixel_feeder_inst.row\[55\]\[0\] net579 _1602_ VPWR
+ VGND sg13g2_nor2_1
XFILLER_35_169 VPWR VGND sg13g2_decap_8
X_2901_ videogen.test_lut_thingy.pixel_feeder_inst.row\[28\]\[1\] net789 _0793_ _0517_
+ VPWR VGND sg13g2_mux2_1
X_3881_ videogen.test_lut_thingy.pixel_feeder_inst.row\[10\]\[3\] net589 _1534_ VPWR
+ VGND sg13g2_nor2_1
XFILLER_32_854 VPWR VGND sg13g2_fill_2
X_2832_ _0770_ _0778_ _0779_ VPWR VGND sg13g2_nor2_2
X_2763_ videogen.test_lut_thingy.pixel_feeder_inst.row\[49\]\[2\] net786 _0752_ _0614_
+ VPWR VGND sg13g2_mux2_1
X_4502_ net559 _2125_ _0422_ VPWR VGND sg13g2_nor2_1
X_2694_ net634 net593 _0701_ VPWR VGND sg13g2_nor2_2
XFILLER_6_94 VPWR VGND sg13g2_decap_8
X_4433_ _2068_ red\[0\] _2067_ VPWR VGND sg13g2_xnor2_1
X_4364_ _2004_ _1976_ _2002_ VPWR VGND sg13g2_xnor2_1
X_3315_ net762 _0985_ _0986_ _0343_ VPWR VGND sg13g2_nor3_1
X_4295_ VPWR VGND _1932_ _1939_ _1925_ _1849_ _1941_ _1853_ sg13g2_a221oi_1
X_3246_ _0934_ net628 _0932_ VPWR VGND sg13g2_nand2_1
XFILLER_39_486 VPWR VGND sg13g2_fill_1
X_3177_ videogen.fancy_shader.video_x\[6\] videogen.fancy_shader.video_x\[7\] net642
+ _0886_ VPWR VGND sg13g2_nor3_1
XFILLER_42_618 VPWR VGND sg13g2_decap_8
XFILLER_23_832 VPWR VGND sg13g2_decap_8
XFILLER_22_353 VPWR VGND sg13g2_decap_8
XFILLER_6_519 VPWR VGND sg13g2_fill_2
XFILLER_2_703 VPWR VGND sg13g2_decap_8
XFILLER_49_239 VPWR VGND sg13g2_decap_8
XFILLER_18_615 VPWR VGND sg13g2_decap_8
XFILLER_46_946 VPWR VGND sg13g2_decap_8
XFILLER_17_136 VPWR VGND sg13g2_decap_8
XFILLER_26_681 VPWR VGND sg13g2_fill_1
XFILLER_33_629 VPWR VGND sg13g2_fill_2
XFILLER_14_843 VPWR VGND sg13g2_decap_4
XFILLER_14_865 VPWR VGND sg13g2_decap_8
XFILLER_14_876 VPWR VGND sg13g2_fill_2
XFILLER_9_313 VPWR VGND sg13g2_decap_8
XFILLER_13_397 VPWR VGND sg13g2_decap_8
XFILLER_12_1026 VPWR VGND sg13g2_fill_2
XFILLER_5_574 VPWR VGND sg13g2_fill_1
XFILLER_5_596 VPWR VGND sg13g2_decap_8
X_3100_ _0849_ net810 VPWR VGND videogen.test_lut_thingy.pixel_feeder_inst.state\[0\]
+ sg13g2_nand2b_2
XFILLER_0_290 VPWR VGND sg13g2_decap_8
X_4080_ _1714_ _1728_ _1701_ _1729_ VPWR VGND sg13g2_nand3_1
XFILLER_48_250 VPWR VGND sg13g2_decap_4
X_3031_ _0765_ _0806_ _0822_ VPWR VGND sg13g2_nor2_2
XFILLER_37_957 VPWR VGND sg13g2_fill_1
XFILLER_36_412 VPWR VGND sg13g2_decap_8
XFILLER_45_990 VPWR VGND sg13g2_decap_8
X_4982_ net81 VGND VPWR _0314_ videogen.test_lut_thingy.pixel_feeder_inst.h_pix\[3\]
+ net643 sg13g2_dfrbpq_1
XFILLER_23_106 VPWR VGND sg13g2_decap_8
X_3933_ net636 _1579_ _1584_ _1585_ VPWR VGND sg13g2_nor3_1
XFILLER_16_180 VPWR VGND sg13g2_fill_2
X_3864_ net612 VPWR _1517_ VGND videogen.test_lut_thingy.pixel_feeder_inst.row\[20\]\[3\]
+ net593 sg13g2_o21ai_1
X_2815_ videogen.test_lut_thingy.pixel_feeder_inst.row\[41\]\[2\] net781 _0772_ _0582_
+ VPWR VGND sg13g2_mux2_1
X_3795_ _1399_ _1447_ net2 _1448_ VPWR VGND sg13g2_nand3_1
X_2746_ net554 net555 _0741_ VPWR VGND sg13g2_nor2b_1
X_2677_ VPWR _0685_ net637 VGND sg13g2_inv_1
X_4416_ VPWR VGND _2017_ _2053_ _2051_ _2018_ _2054_ _2045_ sg13g2_a221oi_1
X_4347_ VPWR _1988_ _1987_ VGND sg13g2_inv_1
X_4278_ _1922_ _1923_ _1924_ VPWR VGND sg13g2_nor2b_1
X_3229_ _0910_ VPWR _0922_ VGND videogen.test_lut_thingy.pixel_feeder_inst.v_pix\[5\]
+ _0921_ sg13g2_o21ai_1
XFILLER_28_902 VPWR VGND sg13g2_decap_4
XFILLER_28_968 VPWR VGND sg13g2_decap_8
XFILLER_36_69 VPWR VGND sg13g2_fill_1
XFILLER_6_305 VPWR VGND sg13g2_decap_4
X_5147__212 VPWR VGND net212 sg13g2_tiehi
XFILLER_42_1008 VPWR VGND sg13g2_decap_8
XFILLER_2_599 VPWR VGND sg13g2_decap_8
XFILLER_46_743 VPWR VGND sg13g2_decap_8
XFILLER_19_935 VPWR VGND sg13g2_decap_8
X_5201__442 VPWR VGND net442 sg13g2_tiehi
XFILLER_45_297 VPWR VGND sg13g2_fill_1
XFILLER_27_990 VPWR VGND sg13g2_decap_8
XFILLER_26_91 VPWR VGND sg13g2_fill_2
XFILLER_14_673 VPWR VGND sg13g2_fill_1
X_3580_ _1231_ _1232_ _1233_ VPWR VGND sg13g2_and2_1
X_5250_ net207 VGND VPWR _0578_ videogen.test_lut_thingy.pixel_feeder_inst.row\[42\]\[2\]
+ _0207_ sg13g2_dfrbpq_1
X_4201_ _1754_ _1842_ _1846_ _1847_ VPWR VGND sg13g2_or3_1
X_5181_ net94 VGND VPWR _0509_ green_tmds_par\[6\] net660 sg13g2_dfrbpq_1
X_4132_ VPWR _1778_ _1777_ VGND sg13g2_inv_1
XFILLER_3_1002 VPWR VGND sg13g2_decap_8
X_4063_ _1697_ VPWR _1712_ VGND _1696_ _1711_ sg13g2_o21ai_1
XFILLER_49_581 VPWR VGND sg13g2_decap_8
X_3014_ videogen.test_lut_thingy.pixel_feeder_inst.row\[13\]\[1\] net796 _0818_ _0412_
+ VPWR VGND sg13g2_mux2_1
XFILLER_24_426 VPWR VGND sg13g2_decap_8
XFILLER_36_275 VPWR VGND sg13g2_decap_8
X_4965_ net107 VGND VPWR _0297_ videogen.fancy_shader.video_x\[3\] net647 sg13g2_dfrbpq_2
X_3916_ net610 VPWR _1568_ VGND videogen.test_lut_thingy.pixel_feeder_inst.row\[6\]\[0\]
+ net587 sg13g2_o21ai_1
XFILLER_33_982 VPWR VGND sg13g2_decap_8
X_4896_ net672 net717 _0231_ VPWR VGND sg13g2_nor2_1
XFILLER_20_621 VPWR VGND sg13g2_fill_1
XFILLER_32_481 VPWR VGND sg13g2_decap_4
X_3847_ videogen.test_lut_thingy.pixel_feeder_inst.row\[26\]\[3\] net586 _1500_ VPWR
+ VGND sg13g2_nor2_1
XFILLER_20_687 VPWR VGND sg13g2_decap_8
XFILLER_20_698 VPWR VGND sg13g2_fill_2
X_5033__401 VPWR VGND net401 sg13g2_tiehi
X_3778_ videogen.test_lut_thingy.pixel_feeder_inst.row\[46\]\[1\] net584 _1431_ VPWR
+ VGND sg13g2_nor2_1
X_2729_ videogen.test_lut_thingy.pixel_feeder_inst.row\[21\]\[1\] net790 _0733_ _0639_
+ VPWR VGND sg13g2_mux2_1
XFILLER_47_507 VPWR VGND sg13g2_decap_8
XFILLER_47_79 VPWR VGND sg13g2_fill_1
XFILLER_47_57 VPWR VGND sg13g2_fill_1
XFILLER_47_68 VPWR VGND sg13g2_fill_2
XFILLER_43_702 VPWR VGND sg13g2_fill_1
XFILLER_28_765 VPWR VGND sg13g2_decap_8
XFILLER_43_713 VPWR VGND sg13g2_decap_4
XFILLER_16_949 VPWR VGND sg13g2_decap_8
XFILLER_24_982 VPWR VGND sg13g2_decap_8
XFILLER_30_418 VPWR VGND sg13g2_fill_2
XFILLER_42_289 VPWR VGND sg13g2_decap_8
XFILLER_7_636 VPWR VGND sg13g2_fill_2
XFILLER_6_135 VPWR VGND sg13g2_decap_8
XFILLER_12_60 VPWR VGND sg13g2_fill_2
XFILLER_2_341 VPWR VGND sg13g2_decap_4
XFILLER_3_897 VPWR VGND sg13g2_decap_8
XFILLER_19_732 VPWR VGND sg13g2_fill_1
XFILLER_46_540 VPWR VGND sg13g2_decap_8
XFILLER_37_90 VPWR VGND sg13g2_fill_1
XFILLER_18_297 VPWR VGND sg13g2_decap_8
XFILLER_34_746 VPWR VGND sg13g2_decap_8
XFILLER_18_1021 VPWR VGND sg13g2_decap_8
XFILLER_22_919 VPWR VGND sg13g2_decap_8
X_4750_ net700 net745 _0085_ VPWR VGND sg13g2_nor2_1
X_3701_ videogen.test_lut_thingy.pixel_feeder_inst.row\[21\]\[1\] net561 _1354_ VPWR
+ VGND sg13g2_nor2_1
X_4681_ net677 net722 _0018_ VPWR VGND sg13g2_nor2_1
X_3632_ videogen.test_lut_thingy.pixel_feeder_inst.row\[13\]\[2\] net567 _1285_ VPWR
+ VGND sg13g2_nor2_1
XFILLER_30_985 VPWR VGND sg13g2_decap_8
X_5302_ net201 VGND VPWR _0630_ videogen.test_lut_thingy.pixel_feeder_inst.row\[23\]\[0\]
+ _0249_ sg13g2_dfrbpq_1
X_3563_ _1040_ VPWR _1216_ VGND _1209_ _1213_ sg13g2_o21ai_1
XFILLER_45_0 VPWR VGND sg13g2_decap_4
X_3494_ _1117_ _1125_ _1145_ _1147_ VPWR VGND sg13g2_or3_1
X_5233_ net275 VGND VPWR _0561_ videogen.test_lut_thingy.pixel_feeder_inst.row\[46\]\[1\]
+ _0190_ sg13g2_dfrbpq_1
X_5164_ net174 VGND VPWR _0492_ videogen.test_lut_thingy.pixel_feeder_inst.row\[57\]\[0\]
+ _0129_ sg13g2_dfrbpq_1
XFILLER_25_1003 VPWR VGND sg13g2_decap_8
X_4115_ _1139_ _1757_ _1761_ VPWR VGND _1038_ sg13g2_nand3b_1
X_5095_ net315 VGND VPWR _0423_ tmds_green.dc_balancing_reg\[4\] net659 sg13g2_dfrbpq_2
X_4046_ VGND VPWR _1686_ _1695_ _1693_ _1689_ sg13g2_a21oi_2
X_4961__112 VPWR VGND net112 sg13g2_tiehi
XFILLER_17_27 VPWR VGND sg13g2_fill_1
X_4998__49 VPWR VGND net49 sg13g2_tiehi
XFILLER_37_595 VPWR VGND sg13g2_fill_2
X_4948_ net132 VGND VPWR net457 serialize.shift_reg_c\[1\] clknet_3_6_0_clk_regs sg13g2_dfrbpq_1
X_4879_ net691 net737 _0214_ VPWR VGND sg13g2_nor2_1
X_5172__146 VPWR VGND net146 sg13g2_tiehi
XFILLER_21_985 VPWR VGND sg13g2_decap_8
XFILLER_4_617 VPWR VGND sg13g2_fill_2
XFILLER_0_867 VPWR VGND sg13g2_decap_8
XFILLER_48_838 VPWR VGND sg13g2_decap_8
XFILLER_28_573 VPWR VGND sg13g2_fill_2
XFILLER_11_440 VPWR VGND sg13g2_fill_1
XFILLER_11_451 VPWR VGND sg13g2_decap_8
XFILLER_12_963 VPWR VGND sg13g2_decap_8
XFILLER_8_967 VPWR VGND sg13g2_decap_8
XFILLER_7_466 VPWR VGND sg13g2_fill_1
XFILLER_3_650 VPWR VGND sg13g2_decap_8
XFILLER_39_827 VPWR VGND sg13g2_fill_1
XFILLER_38_326 VPWR VGND sg13g2_decap_8
XFILLER_47_860 VPWR VGND sg13g2_decap_8
XFILLER_0_63 VPWR VGND sg13g2_decap_8
X_2994_ videogen.test_lut_thingy.pixel_feeder_inst.row\[34\]\[1\] net791 _0814_ _0437_
+ VPWR VGND sg13g2_mux2_1
XFILLER_21_226 VPWR VGND sg13g2_fill_2
X_4802_ net705 net750 _0137_ VPWR VGND sg13g2_nor2_1
X_4733_ net714 net759 _0068_ VPWR VGND sg13g2_nor2_1
X_4664_ _2247_ net664 net460 net669 red_tmds_par\[7\] VPWR VGND sg13g2_a22oi_1
X_3615_ videogen.test_lut_thingy.pixel_feeder_inst.row\[28\]\[2\] net594 _1268_ VPWR
+ VGND sg13g2_nor2_1
X_5030__404 VPWR VGND net404 sg13g2_tiehi
X_4595_ VGND VPWR _2207_ _2208_ _0616_ net763 sg13g2_a21oi_1
X_3546_ _1051_ _1196_ _1198_ _1199_ VPWR VGND sg13g2_nor3_1
X_5216_ net352 VGND VPWR _0544_ videogen.test_lut_thingy.pixel_feeder_inst.row\[50\]\[0\]
+ _0173_ sg13g2_dfrbpq_1
XFILLER_0_119 VPWR VGND sg13g2_decap_8
X_3477_ _1050_ _1117_ _1124_ _1130_ VPWR VGND sg13g2_or3_1
X_5180__96 VPWR VGND net96 sg13g2_tiehi
X_5147_ net212 VGND VPWR _0475_ videogen.test_lut_thingy.pixel_feeder_inst.row\[7\]\[3\]
+ _0112_ sg13g2_dfrbpq_1
XFILLER_45_819 VPWR VGND sg13g2_fill_2
XFILLER_28_59 VPWR VGND sg13g2_decap_8
X_5078_ net333 VGND VPWR _0410_ videogen.test_lut_thingy.pixel_feeder_inst.row\[14\]\[3\]
+ _0056_ sg13g2_dfrbpq_1
XFILLER_38_860 VPWR VGND sg13g2_decap_4
X_4029_ _1675_ _1677_ _1678_ VPWR VGND _1673_ sg13g2_nand3b_1
XFILLER_25_521 VPWR VGND sg13g2_decap_8
X_5104__298 VPWR VGND net298 sg13g2_tiehi
XFILLER_40_524 VPWR VGND sg13g2_decap_4
XFILLER_12_204 VPWR VGND sg13g2_fill_2
XFILLER_12_259 VPWR VGND sg13g2_decap_8
XFILLER_5_937 VPWR VGND sg13g2_decap_8
XFILLER_4_436 VPWR VGND sg13g2_decap_8
Xheichips25_bagel_30 VPWR VGND uio_out[5] sg13g2_tielo
XFILLER_0_664 VPWR VGND sg13g2_decap_8
XFILLER_48_613 VPWR VGND sg13g2_decap_8
XFILLER_48_679 VPWR VGND sg13g2_decap_8
XFILLER_44_830 VPWR VGND sg13g2_fill_2
XFILLER_28_392 VPWR VGND sg13g2_decap_8
XFILLER_43_351 VPWR VGND sg13g2_fill_1
XFILLER_16_554 VPWR VGND sg13g2_fill_1
XFILLER_31_502 VPWR VGND sg13g2_decap_8
XFILLER_44_896 VPWR VGND sg13g2_decap_8
XFILLER_43_384 VPWR VGND sg13g2_decap_8
XFILLER_31_513 VPWR VGND sg13g2_fill_2
X_5155__196 VPWR VGND net196 sg13g2_tiehi
X_3400_ videogen.fancy_shader.n646\[8\] videogen.fancy_shader.video_y\[8\] _1053_
+ VPWR VGND sg13g2_xor2_1
X_4380_ VGND VPWR _2008_ _2019_ _0376_ net558 sg13g2_a21oi_1
X_3331_ _0676_ videogen.fancy_shader.video_y\[8\] _0859_ _0997_ VPWR VGND sg13g2_nor3_1
X_3262_ VGND VPWR videogen.test_lut_thingy.pixel_feeder_inst.v_counter\[2\] _0942_
+ _0945_ videogen.test_lut_thingy.pixel_feeder_inst.v_counter\[3\] sg13g2_a21oi_1
X_5307__144 VPWR VGND net144 sg13g2_tiehi
XFILLER_39_613 VPWR VGND sg13g2_fill_1
X_3193_ videogen.fancy_shader.video_x\[7\] _0844_ _0895_ VPWR VGND sg13g2_and2_1
X_5001_ net43 VGND VPWR _0333_ videogen.test_lut_thingy.pixel_feeder_inst.row\[36\]\[0\]
+ _0029_ sg13g2_dfrbpq_1
X_5162__178 VPWR VGND net178 sg13g2_tiehi
XFILLER_22_1017 VPWR VGND sg13g2_decap_8
XFILLER_22_1028 VPWR VGND sg13g2_fill_1
XFILLER_22_568 VPWR VGND sg13g2_decap_4
X_2977_ videogen.test_lut_thingy.pixel_feeder_inst.row\[6\]\[3\] net773 _0811_ _0451_
+ VPWR VGND sg13g2_mux2_1
X_4716_ net706 net751 _0051_ VPWR VGND sg13g2_nor2_1
X_4647_ VPWR _0656_ net465 VGND sg13g2_inv_1
X_4578_ _2194_ _2191_ _2193_ _2190_ _2138_ VPWR VGND sg13g2_a22oi_1
XFILLER_2_918 VPWR VGND sg13g2_decap_8
X_3529_ _1182_ videogen.fancy_shader.video_y\[0\] videogen.fancy_shader.video_x\[0\]
+ VPWR VGND sg13g2_xnor2_1
XFILLER_29_112 VPWR VGND sg13g2_decap_8
XFILLER_45_605 VPWR VGND sg13g2_decap_8
XFILLER_29_167 VPWR VGND sg13g2_fill_1
XFILLER_44_159 VPWR VGND sg13g2_decap_8
XFILLER_38_1013 VPWR VGND sg13g2_decap_8
XFILLER_26_863 VPWR VGND sg13g2_fill_2
XFILLER_41_833 VPWR VGND sg13g2_decap_8
XFILLER_5_712 VPWR VGND sg13g2_fill_1
XFILLER_1_951 VPWR VGND sg13g2_decap_8
XFILLER_49_933 VPWR VGND sg13g2_decap_8
XFILLER_0_461 VPWR VGND sg13g2_decap_8
XFILLER_36_616 VPWR VGND sg13g2_fill_1
XFILLER_44_671 VPWR VGND sg13g2_decap_8
X_2900_ videogen.test_lut_thingy.pixel_feeder_inst.row\[28\]\[2\] net778 _0793_ _0518_
+ VPWR VGND sg13g2_mux2_1
X_3880_ videogen.test_lut_thingy.pixel_feeder_inst.row\[11\]\[3\] net578 _1533_ VPWR
+ VGND sg13g2_nor2_1
X_2831_ _0732_ _0738_ net613 _0778_ VPWR VGND sg13g2_nand3_1
XFILLER_31_354 VPWR VGND sg13g2_decap_8
X_2762_ videogen.test_lut_thingy.pixel_feeder_inst.row\[49\]\[3\] net775 _0752_ _0615_
+ VPWR VGND sg13g2_mux2_1
X_5057__370 VPWR VGND net370 sg13g2_tiehi
X_4501_ VPWR VGND _2064_ _2056_ _2124_ _2110_ _2125_ _2111_ sg13g2_a221oi_1
X_4973__99 VPWR VGND net99 sg13g2_tiehi
X_2693_ VGND VPWR _0700_ net640 net639 sg13g2_or2_1
X_4432_ _2067_ _1993_ VPWR VGND _2018_ sg13g2_nand2b_2
X_4363_ _1976_ _2002_ _2003_ VPWR VGND sg13g2_and2_1
X_3314_ _0680_ _0984_ _0986_ VPWR VGND sg13g2_nor2_1
X_4294_ VGND VPWR _1925_ _1932_ _1940_ _1939_ sg13g2_a21oi_1
X_5244__231 VPWR VGND net231 sg13g2_tiehi
XFILLER_6_1011 VPWR VGND sg13g2_decap_8
X_3245_ VGND VPWR _0933_ _0932_ net628 sg13g2_or2_1
X_3176_ net814 _0885_ _0285_ VPWR VGND sg13g2_and2_1
XFILLER_27_638 VPWR VGND sg13g2_fill_1
XFILLER_23_888 VPWR VGND sg13g2_decap_8
XFILLER_41_26 VPWR VGND sg13g2_decap_8
XFILLER_6_509 VPWR VGND sg13g2_decap_4
XFILLER_46_925 VPWR VGND sg13g2_decap_8
XFILLER_45_446 VPWR VGND sg13g2_decap_8
XFILLER_45_413 VPWR VGND sg13g2_fill_2
XFILLER_14_822 VPWR VGND sg13g2_decap_8
XFILLER_25_170 VPWR VGND sg13g2_fill_2
XFILLER_25_192 VPWR VGND sg13g2_decap_4
X_5256__179 VPWR VGND net179 sg13g2_tiehi
XFILLER_13_354 VPWR VGND sg13g2_decap_8
XFILLER_13_365 VPWR VGND sg13g2_fill_2
XFILLER_15_60 VPWR VGND sg13g2_decap_8
XFILLER_12_1005 VPWR VGND sg13g2_decap_8
XFILLER_49_7 VPWR VGND sg13g2_decap_8
XFILLER_49_752 VPWR VGND sg13g2_fill_2
X_3030_ net806 videogen.test_lut_thingy.pixel_feeder_inst.row\[16\]\[0\] _0821_ _0399_
+ VPWR VGND sg13g2_mux2_1
XFILLER_36_457 VPWR VGND sg13g2_decap_4
X_4981_ net83 VGND VPWR _0313_ videogen.test_lut_thingy.pixel_feeder_inst.h_pix\[2\]
+ net645 sg13g2_dfrbpq_1
X_3932_ _1580_ _1581_ _1582_ _1583_ _1584_ VPWR VGND sg13g2_nor4_1
XFILLER_32_641 VPWR VGND sg13g2_decap_8
X_3863_ videogen.test_lut_thingy.pixel_feeder_inst.row\[22\]\[3\] net583 _1516_ VPWR
+ VGND sg13g2_nor2_1
XFILLER_32_652 VPWR VGND sg13g2_fill_2
X_2814_ videogen.test_lut_thingy.pixel_feeder_inst.row\[41\]\[3\] net769 _0772_ _0583_
+ VPWR VGND sg13g2_mux2_1
X_3794_ _1446_ VPWR _1447_ VGND _1410_ _1422_ sg13g2_o21ai_1
X_2745_ net636 net554 net566 _0740_ VPWR VGND sg13g2_nor3_1
X_2676_ net632 _0684_ VPWR VGND sg13g2_inv_4
X_4415_ VGND VPWR _2039_ _2052_ _2053_ _1995_ sg13g2_a21oi_1
X_4346_ _1977_ _1982_ _1987_ VPWR VGND sg13g2_nor2_2
X_4277_ VGND VPWR _1856_ _1921_ _1923_ _1916_ sg13g2_a21oi_1
X_3228_ _0909_ _0920_ _0921_ _0309_ VPWR VGND sg13g2_nor3_1
XFILLER_39_284 VPWR VGND sg13g2_decap_8
X_3159_ net496 net450 _0882_ VPWR VGND sg13g2_nor2_1
XFILLER_43_939 VPWR VGND sg13g2_decap_8
XFILLER_42_427 VPWR VGND sg13g2_decap_4
XFILLER_42_416 VPWR VGND sg13g2_fill_1
XFILLER_23_630 VPWR VGND sg13g2_decap_4
XFILLER_7_807 VPWR VGND sg13g2_fill_1
XFILLER_10_324 VPWR VGND sg13g2_decap_4
XFILLER_6_328 VPWR VGND sg13g2_decap_8
XFILLER_2_501 VPWR VGND sg13g2_decap_8
XFILLER_2_534 VPWR VGND sg13g2_fill_2
XFILLER_19_914 VPWR VGND sg13g2_decap_8
XFILLER_18_424 VPWR VGND sg13g2_fill_1
XFILLER_46_799 VPWR VGND sg13g2_decap_8
XFILLER_46_788 VPWR VGND sg13g2_fill_1
XFILLER_33_405 VPWR VGND sg13g2_fill_2
XFILLER_14_630 VPWR VGND sg13g2_decap_8
XFILLER_14_641 VPWR VGND sg13g2_fill_1
XFILLER_42_961 VPWR VGND sg13g2_fill_1
XFILLER_41_460 VPWR VGND sg13g2_fill_1
XFILLER_42_994 VPWR VGND sg13g2_decap_8
XFILLER_41_493 VPWR VGND sg13g2_fill_2
XFILLER_13_173 VPWR VGND sg13g2_decap_4
XFILLER_14_696 VPWR VGND sg13g2_decap_8
XFILLER_9_166 VPWR VGND sg13g2_fill_1
XFILLER_13_195 VPWR VGND sg13g2_decap_8
XFILLER_6_840 VPWR VGND sg13g2_fill_2
X_4200_ _1831_ _1845_ _1846_ VPWR VGND sg13g2_nor2b_1
X_5180_ net96 VGND VPWR _0508_ green_tmds_par\[2\] net659 sg13g2_dfrbpq_1
X_4131_ _1108_ _1776_ _1777_ VPWR VGND sg13g2_nor2_1
XFILLER_49_560 VPWR VGND sg13g2_decap_8
X_4062_ _1699_ VPWR _1711_ VGND _1707_ _1709_ sg13g2_o21ai_1
XFILLER_37_711 VPWR VGND sg13g2_fill_2
X_3013_ videogen.test_lut_thingy.pixel_feeder_inst.row\[13\]\[2\] net785 _0818_ _0413_
+ VPWR VGND sg13g2_mux2_1
XFILLER_36_254 VPWR VGND sg13g2_decap_8
X_4964_ net108 VGND VPWR _0296_ videogen.fancy_shader.video_x\[2\] net647 sg13g2_dfrbpq_2
X_3915_ _1563_ _1564_ _1565_ _1566_ _1567_ VPWR VGND sg13g2_nor4_1
XFILLER_32_460 VPWR VGND sg13g2_fill_2
X_4895_ net672 net717 _0230_ VPWR VGND sg13g2_nor2_1
X_3846_ videogen.test_lut_thingy.pixel_feeder_inst.row\[27\]\[3\] net576 _1499_ VPWR
+ VGND sg13g2_nor2_1
X_3777_ videogen.test_lut_thingy.pixel_feeder_inst.row\[45\]\[1\] net563 _1430_ VPWR
+ VGND sg13g2_nor2_1
X_5213__369 VPWR VGND net369 sg13g2_tiehi
X_2728_ videogen.test_lut_thingy.pixel_feeder_inst.row\[21\]\[2\] net779 _0733_ _0640_
+ VPWR VGND sg13g2_mux2_1
X_4329_ net552 red\[4\] _1970_ VPWR VGND sg13g2_xor2_1
XFILLER_47_25 VPWR VGND sg13g2_fill_1
XFILLER_47_14 VPWR VGND sg13g2_decap_8
XFILLER_28_733 VPWR VGND sg13g2_decap_8
XFILLER_16_928 VPWR VGND sg13g2_decap_8
XFILLER_28_788 VPWR VGND sg13g2_fill_1
XFILLER_24_961 VPWR VGND sg13g2_decap_8
XFILLER_7_626 VPWR VGND sg13g2_fill_1
XFILLER_7_659 VPWR VGND sg13g2_fill_1
XFILLER_10_198 VPWR VGND sg13g2_fill_1
X_5114__278 VPWR VGND net278 sg13g2_tiehi
XFILLER_3_876 VPWR VGND sg13g2_decap_8
XFILLER_2_375 VPWR VGND sg13g2_decap_8
XFILLER_2_386 VPWR VGND sg13g2_fill_1
XFILLER_2_397 VPWR VGND sg13g2_decap_4
Xfanout690 net694 net690 VPWR VGND sg13g2_buf_8
XFILLER_19_8 VPWR VGND sg13g2_decap_4
XFILLER_18_265 VPWR VGND sg13g2_decap_8
XFILLER_19_777 VPWR VGND sg13g2_fill_1
XFILLER_46_596 VPWR VGND sg13g2_decap_8
XFILLER_18_1000 VPWR VGND sg13g2_decap_8
XFILLER_42_791 VPWR VGND sg13g2_fill_2
X_3700_ videogen.test_lut_thingy.pixel_feeder_inst.row\[22\]\[1\] net583 _1353_ VPWR
+ VGND sg13g2_nor2_1
XFILLER_14_471 VPWR VGND sg13g2_fill_1
XFILLER_14_482 VPWR VGND sg13g2_decap_8
XFILLER_15_994 VPWR VGND sg13g2_decap_8
X_4680_ net678 net723 _0017_ VPWR VGND sg13g2_nor2_1
XFILLER_30_964 VPWR VGND sg13g2_decap_8
X_5316__371 VPWR VGND net371 sg13g2_tiehi
X_3631_ videogen.test_lut_thingy.pixel_feeder_inst.row\[15\]\[2\] net577 _1284_ VPWR
+ VGND sg13g2_nor2_1
X_3562_ _1039_ _1214_ _1215_ VPWR VGND sg13g2_nor2_1
XFILLER_6_670 VPWR VGND sg13g2_fill_2
X_5301_ net209 VGND VPWR _0629_ videogen.test_lut_thingy.pixel_feeder_inst.row\[24\]\[3\]
+ _0248_ sg13g2_dfrbpq_1
X_3493_ _1117_ VPWR _1146_ VGND _1125_ _1145_ sg13g2_o21ai_1
X_5232_ net279 VGND VPWR _0560_ videogen.test_lut_thingy.pixel_feeder_inst.row\[46\]\[0\]
+ _0189_ sg13g2_dfrbpq_1
X_5163_ net176 VGND VPWR _0491_ videogen.test_lut_thingy.pixel_feeder_inst.row\[58\]\[3\]
+ _0128_ sg13g2_dfrbpq_1
XFILLER_38_0 VPWR VGND sg13g2_decap_8
X_4114_ _1760_ _1139_ _1757_ VPWR VGND sg13g2_nand2_1
X_5094_ net316 VGND VPWR _0422_ tmds_green.dc_balancing_reg\[3\] net657 sg13g2_dfrbpq_2
X_4045_ _1694_ _1689_ _1693_ VPWR VGND sg13g2_nand2_1
XFILLER_25_703 VPWR VGND sg13g2_fill_1
XFILLER_25_758 VPWR VGND sg13g2_fill_2
XFILLER_40_728 VPWR VGND sg13g2_fill_2
XFILLER_24_268 VPWR VGND sg13g2_decap_4
X_4947_ net133 VGND VPWR net455 serialize.shift_reg_c\[0\] clknet_3_6_0_clk_regs sg13g2_dfrbpq_1
X_4878_ net693 net738 _0213_ VPWR VGND sg13g2_nor2_1
XFILLER_21_964 VPWR VGND sg13g2_decap_8
XFILLER_32_1008 VPWR VGND sg13g2_decap_8
X_3829_ videogen.test_lut_thingy.pixel_feeder_inst.row\[54\]\[3\] net590 _1482_ VPWR
+ VGND sg13g2_nor2_1
XFILLER_0_846 VPWR VGND sg13g2_decap_8
XFILLER_48_817 VPWR VGND sg13g2_decap_8
XFILLER_16_725 VPWR VGND sg13g2_decap_8
XFILLER_28_552 VPWR VGND sg13g2_decap_8
X_5294__249 VPWR VGND net249 sg13g2_tiehi
XFILLER_15_235 VPWR VGND sg13g2_decap_4
XFILLER_16_736 VPWR VGND sg13g2_fill_1
XFILLER_12_942 VPWR VGND sg13g2_decap_8
XFILLER_8_946 VPWR VGND sg13g2_decap_8
XFILLER_7_478 VPWR VGND sg13g2_decap_8
XFILLER_31_7 VPWR VGND sg13g2_decap_8
XFILLER_38_338 VPWR VGND sg13g2_decap_8
XFILLER_19_530 VPWR VGND sg13g2_decap_8
XFILLER_0_42 VPWR VGND sg13g2_decap_8
XFILLER_0_1028 VPWR VGND sg13g2_fill_1
XFILLER_19_585 VPWR VGND sg13g2_fill_1
XFILLER_22_706 VPWR VGND sg13g2_decap_4
X_2993_ videogen.test_lut_thingy.pixel_feeder_inst.row\[34\]\[2\] net781 _0814_ _0438_
+ VPWR VGND sg13g2_mux2_1
X_4801_ net679 net725 _0136_ VPWR VGND sg13g2_nor2_1
X_4732_ net713 net760 _0067_ VPWR VGND sg13g2_nor2_1
XFILLER_14_290 VPWR VGND sg13g2_fill_1
XFILLER_30_783 VPWR VGND sg13g2_fill_2
X_4663_ VPWR _0664_ _2246_ VGND sg13g2_inv_1
X_3614_ videogen.test_lut_thingy.pixel_feeder_inst.row\[29\]\[2\] net560 _1267_ VPWR
+ VGND sg13g2_nor2_1
XFILLER_30_794 VPWR VGND sg13g2_decap_4
X_4594_ _2139_ _2141_ net620 _2208_ VPWR VGND sg13g2_nand3_1
X_3545_ VPWR _1198_ _1197_ VGND sg13g2_inv_1
X_3476_ _1116_ _1126_ _1039_ _1129_ VPWR VGND sg13g2_nand3_1
X_5215_ net361 VGND VPWR _0543_ videogen.test_lut_thingy.pixel_feeder_inst.row\[51\]\[3\]
+ _0172_ sg13g2_dfrbpq_1
X_5146_ net214 VGND VPWR _0474_ videogen.test_lut_thingy.pixel_feeder_inst.row\[7\]\[2\]
+ _0111_ sg13g2_dfrbpq_1
X_5077_ net335 VGND VPWR _0409_ videogen.test_lut_thingy.pixel_feeder_inst.row\[14\]\[2\]
+ _0055_ sg13g2_dfrbpq_1
XFILLER_44_308 VPWR VGND sg13g2_fill_1
X_4028_ _1662_ _1666_ _1677_ VPWR VGND sg13g2_nor2b_1
XFILLER_44_15 VPWR VGND sg13g2_fill_1
XFILLER_37_393 VPWR VGND sg13g2_decap_4
XFILLER_13_706 VPWR VGND sg13g2_decap_4
XFILLER_5_916 VPWR VGND sg13g2_decap_8
XFILLER_4_426 VPWR VGND sg13g2_fill_2
XFILLER_0_632 VPWR VGND sg13g2_decap_8
XFILLER_0_643 VPWR VGND sg13g2_decap_8
X_5302__201 VPWR VGND net201 sg13g2_tiehi
XFILLER_47_179 VPWR VGND sg13g2_fill_1
XFILLER_47_168 VPWR VGND sg13g2_fill_1
XFILLER_16_522 VPWR VGND sg13g2_decap_4
XFILLER_44_864 VPWR VGND sg13g2_decap_4
XFILLER_16_588 VPWR VGND sg13g2_fill_2
X_4985__75 VPWR VGND net75 sg13g2_tiehi
XFILLER_34_92 VPWR VGND sg13g2_decap_8
XFILLER_12_794 VPWR VGND sg13g2_decap_8
X_3330_ videogen.fancy_shader.video_y\[7\] videogen.fancy_shader.video_y\[6\] net623
+ net624 _0996_ VPWR VGND sg13g2_nor4_1
XFILLER_4_993 VPWR VGND sg13g2_decap_8
XFILLER_3_481 VPWR VGND sg13g2_fill_2
X_5000_ net45 VGND VPWR _0332_ videogen.test_lut_thingy.pixel_feeder_inst.row\[35\]\[3\]
+ _0028_ sg13g2_dfrbpq_1
X_3261_ VPWR _0319_ _0944_ VGND sg13g2_inv_1
X_3192_ _0844_ _0889_ _0894_ _0300_ VPWR VGND sg13g2_nor3_1
X_5320__334 VPWR VGND net334 sg13g2_tiehi
XFILLER_34_341 VPWR VGND sg13g2_fill_2
X_2976_ _0761_ _0768_ _0811_ VPWR VGND sg13g2_nor2_2
X_4715_ net706 net751 _0050_ VPWR VGND sg13g2_nor2_1
X_4646_ _2238_ net666 net464 net671 green_tmds_par\[6\] VPWR VGND sg13g2_a22oi_1
X_4577_ _2138_ _2192_ _2193_ VPWR VGND sg13g2_nor2_1
X_3528_ _1181_ _1171_ _1179_ VPWR VGND sg13g2_xnor2_1
X_3459_ _1109_ _1067_ _1108_ _1112_ VPWR VGND sg13g2_a21o_1
X_5129_ net248 VGND VPWR _0457_ videogen.test_lut_thingy.pixel_feeder_inst.row\[10\]\[1\]
+ _0094_ sg13g2_dfrbpq_1
XFILLER_26_897 VPWR VGND sg13g2_fill_2
XFILLER_40_344 VPWR VGND sg13g2_fill_2
XFILLER_25_396 VPWR VGND sg13g2_decap_8
XFILLER_5_746 VPWR VGND sg13g2_decap_4
XFILLER_4_212 VPWR VGND sg13g2_fill_1
XFILLER_4_201 VPWR VGND sg13g2_decap_8
X_5013__433 VPWR VGND net433 sg13g2_tiehi
XFILLER_4_234 VPWR VGND sg13g2_fill_2
XFILLER_1_930 VPWR VGND sg13g2_decap_8
XFILLER_45_1018 VPWR VGND sg13g2_decap_8
XFILLER_0_440 VPWR VGND sg13g2_decap_8
XFILLER_49_912 VPWR VGND sg13g2_decap_8
XFILLER_49_989 VPWR VGND sg13g2_decap_8
XFILLER_48_455 VPWR VGND sg13g2_decap_8
X_5204__430 VPWR VGND net430 sg13g2_tiehi
XFILLER_35_127 VPWR VGND sg13g2_fill_2
XFILLER_43_160 VPWR VGND sg13g2_fill_1
XFILLER_16_374 VPWR VGND sg13g2_fill_2
XFILLER_32_823 VPWR VGND sg13g2_decap_8
X_2830_ _0777_ _0732_ _0738_ VPWR VGND sg13g2_nand2_2
XFILLER_32_867 VPWR VGND sg13g2_fill_1
X_2761_ _0749_ _0751_ _0752_ VPWR VGND sg13g2_nor2_2
X_4500_ _2124_ _2116_ _2122_ VPWR VGND sg13g2_xnor2_1
X_2692_ net639 net640 _0699_ VPWR VGND sg13g2_nor2_2
X_4431_ VGND VPWR _2061_ _2065_ _0385_ _2066_ sg13g2_a21oi_1
X_4362_ _2002_ _1999_ _2001_ VPWR VGND sg13g2_xnor2_1
X_3313_ _0680_ _0984_ _0985_ VPWR VGND sg13g2_and2_1
X_4293_ _1935_ _1936_ _1933_ _1939_ VPWR VGND _1938_ sg13g2_nand4_1
X_3244_ _0849_ _0931_ _0932_ _0314_ VPWR VGND sg13g2_nor3_1
XFILLER_39_466 VPWR VGND sg13g2_decap_8
X_3175_ _0882_ _0884_ _0885_ VPWR VGND sg13g2_nor2b_1
XFILLER_23_801 VPWR VGND sg13g2_decap_8
XFILLER_35_661 VPWR VGND sg13g2_decap_8
XFILLER_35_672 VPWR VGND sg13g2_decap_8
X_4958__118 VPWR VGND net118 sg13g2_tiehi
XFILLER_23_867 VPWR VGND sg13g2_decap_8
XFILLER_34_193 VPWR VGND sg13g2_fill_2
X_5251__203 VPWR VGND net203 sg13g2_tiehi
X_2959_ videogen.test_lut_thingy.pixel_feeder_inst.row\[8\]\[1\] net796 _0807_ _0465_
+ VPWR VGND sg13g2_mux2_1
XFILLER_22_388 VPWR VGND sg13g2_fill_2
X_4629_ VPWR _0647_ net486 VGND sg13g2_inv_1
XFILLER_1_248 VPWR VGND sg13g2_decap_8
XFILLER_46_904 VPWR VGND sg13g2_decap_8
XFILLER_45_425 VPWR VGND sg13g2_decap_8
XFILLER_17_105 VPWR VGND sg13g2_fill_2
XFILLER_13_333 VPWR VGND sg13g2_fill_2
XFILLER_41_675 VPWR VGND sg13g2_decap_4
XFILLER_40_141 VPWR VGND sg13g2_decap_4
XFILLER_15_94 VPWR VGND sg13g2_decap_8
XFILLER_5_521 VPWR VGND sg13g2_fill_1
XFILLER_12_1028 VPWR VGND sg13g2_fill_1
Xoutput3 net3 tmds_b VPWR VGND sg13g2_buf_1
XFILLER_49_731 VPWR VGND sg13g2_decap_8
XFILLER_49_720 VPWR VGND sg13g2_fill_1
XFILLER_1_793 VPWR VGND sg13g2_decap_8
XFILLER_49_786 VPWR VGND sg13g2_decap_8
X_5124__258 VPWR VGND net258 sg13g2_tiehi
X_4980_ net85 VGND VPWR _0312_ videogen.test_lut_thingy.pixel_feeder_inst.h_pix\[1\]
+ net646 sg13g2_dfrbpq_2
X_3931_ videogen.test_lut_thingy.pixel_feeder_inst.row\[17\]\[0\] net565 _1583_ VPWR
+ VGND sg13g2_nor2_1
XFILLER_17_694 VPWR VGND sg13g2_decap_8
X_3862_ videogen.test_lut_thingy.pixel_feeder_inst.row\[21\]\[3\] net561 _1515_ VPWR
+ VGND sg13g2_nor2_1
XFILLER_32_675 VPWR VGND sg13g2_fill_1
X_2813_ _0751_ _0770_ _0772_ VPWR VGND sg13g2_nor2_2
X_3793_ _1445_ net625 _1446_ VPWR VGND sg13g2_nor2b_1
X_2744_ _0739_ net641 VPWR VGND net639 sg13g2_nand2b_2
X_2675_ VPWR _0683_ net626 VGND sg13g2_inv_1
X_4414_ _2052_ _2048_ _2050_ VPWR VGND sg13g2_xnor2_1
X_4345_ _1974_ _1985_ _1986_ VPWR VGND sg13g2_nor2b_2
XFILLER_28_1024 VPWR VGND sg13g2_decap_4
X_4276_ _1856_ _1920_ _1922_ VPWR VGND sg13g2_nor2b_1
XFILLER_39_241 VPWR VGND sg13g2_decap_4
X_3227_ _0921_ videogen.test_lut_thingy.pixel_feeder_inst.v_pix\[4\] videogen.test_lut_thingy.pixel_feeder_inst.v_pix\[3\]
+ _0917_ VPWR VGND sg13g2_and3_1
XFILLER_28_915 VPWR VGND sg13g2_fill_1
XFILLER_28_926 VPWR VGND sg13g2_decap_8
XFILLER_39_263 VPWR VGND sg13g2_decap_8
X_3158_ _0264_ net815 net756 net491 VPWR VGND sg13g2_and3_1
XFILLER_27_458 VPWR VGND sg13g2_decap_4
X_3089_ _0840_ videogen.fancy_shader.video_x\[3\] videogen.fancy_shader.video_x\[2\]
+ _0839_ VPWR VGND sg13g2_and3_2
XFILLER_14_119 VPWR VGND sg13g2_fill_2
XFILLER_36_970 VPWR VGND sg13g2_decap_8
XFILLER_42_439 VPWR VGND sg13g2_fill_2
XFILLER_35_1028 VPWR VGND sg13g2_fill_1
X_5175__134 VPWR VGND net134 sg13g2_tiehi
XFILLER_7_819 VPWR VGND sg13g2_decap_8
XFILLER_7_4 VPWR VGND sg13g2_decap_8
XFILLER_2_568 VPWR VGND sg13g2_fill_2
X_5262__140 VPWR VGND net140 sg13g2_tiehi
XFILLER_45_222 VPWR VGND sg13g2_fill_2
XFILLER_34_929 VPWR VGND sg13g2_decap_4
XFILLER_33_439 VPWR VGND sg13g2_fill_1
XFILLER_42_973 VPWR VGND sg13g2_decap_8
XFILLER_13_141 VPWR VGND sg13g2_fill_2
XFILLER_13_152 VPWR VGND sg13g2_decap_8
X_5196__48 VPWR VGND net48 sg13g2_tiehi
XFILLER_9_178 VPWR VGND sg13g2_fill_2
XFILLER_6_863 VPWR VGND sg13g2_fill_1
XFILLER_6_885 VPWR VGND sg13g2_decap_8
XFILLER_5_362 VPWR VGND sg13g2_fill_1
X_4130_ _1079_ _0981_ _1776_ VPWR VGND _1049_ sg13g2_nand3b_1
XFILLER_3_64 VPWR VGND sg13g2_fill_2
X_4061_ _1710_ _1694_ _1708_ VPWR VGND sg13g2_nand2_1
X_3012_ videogen.test_lut_thingy.pixel_feeder_inst.row\[13\]\[3\] net774 _0818_ _0414_
+ VPWR VGND sg13g2_mux2_1
XFILLER_24_406 VPWR VGND sg13g2_decap_8
X_4963_ net109 VGND VPWR _0295_ videogen.fancy_shader.video_x\[1\] net648 sg13g2_dfrbpq_2
XFILLER_36_288 VPWR VGND sg13g2_decap_8
X_3914_ videogen.test_lut_thingy.pixel_feeder_inst.row\[15\]\[0\] net577 _1566_ VPWR
+ VGND sg13g2_nor2_1
X_4894_ net673 net718 _0229_ VPWR VGND sg13g2_nor2_1
X_3845_ net632 VPWR _1498_ VGND videogen.test_lut_thingy.pixel_feeder_inst.row\[24\]\[3\]
+ net598 sg13g2_o21ai_1
X_3776_ videogen.test_lut_thingy.pixel_feeder_inst.row\[44\]\[1\] net596 _1429_ VPWR
+ VGND sg13g2_nor2_1
X_2727_ videogen.test_lut_thingy.pixel_feeder_inst.row\[21\]\[3\] net768 _0733_ _0641_
+ VPWR VGND sg13g2_mux2_1
X_4328_ _1956_ _1968_ _1969_ VPWR VGND sg13g2_nor2b_1
XFILLER_41_1010 VPWR VGND sg13g2_decap_8
X_4259_ _1897_ _1901_ _1905_ VPWR VGND sg13g2_and2_1
XFILLER_27_200 VPWR VGND sg13g2_decap_8
XFILLER_16_907 VPWR VGND sg13g2_decap_8
XFILLER_42_214 VPWR VGND sg13g2_fill_1
XFILLER_24_940 VPWR VGND sg13g2_decap_8
XFILLER_42_269 VPWR VGND sg13g2_fill_2
XFILLER_7_638 VPWR VGND sg13g2_fill_1
XFILLER_3_800 VPWR VGND sg13g2_fill_1
XFILLER_3_855 VPWR VGND sg13g2_decap_8
XFILLER_3_833 VPWR VGND sg13g2_decap_4
Xfanout691 net693 net691 VPWR VGND sg13g2_buf_8
Xfanout680 net681 net680 VPWR VGND sg13g2_buf_2
XFILLER_46_575 VPWR VGND sg13g2_decap_8
XFILLER_33_236 VPWR VGND sg13g2_decap_8
XFILLER_15_973 VPWR VGND sg13g2_decap_8
XFILLER_30_943 VPWR VGND sg13g2_decap_8
X_3630_ net631 VPWR _1283_ VGND videogen.test_lut_thingy.pixel_feeder_inst.row\[14\]\[2\]
+ net588 sg13g2_o21ai_1
X_3561_ _1209_ _1213_ _1214_ VPWR VGND sg13g2_nor2_1
X_5300_ net217 VGND VPWR _0628_ videogen.test_lut_thingy.pixel_feeder_inst.row\[24\]\[2\]
+ _0247_ sg13g2_dfrbpq_1
XFILLER_6_660 VPWR VGND sg13g2_fill_2
XFILLER_6_693 VPWR VGND sg13g2_fill_2
X_3492_ _1040_ _1127_ _1135_ _1145_ VPWR VGND sg13g2_nor3_1
X_5231_ net283 VGND VPWR _0559_ videogen.test_lut_thingy.pixel_feeder_inst.row\[47\]\[3\]
+ _0188_ sg13g2_dfrbpq_1
X_5162_ net178 VGND VPWR _0490_ videogen.test_lut_thingy.pixel_feeder_inst.row\[58\]\[2\]
+ _0127_ sg13g2_dfrbpq_1
X_5093_ net317 VGND VPWR _0421_ tmds_green.dc_balancing_reg\[2\] net657 sg13g2_dfrbpq_1
X_4113_ _1759_ _0977_ _0980_ VPWR VGND sg13g2_xnor2_1
XFILLER_49_391 VPWR VGND sg13g2_decap_8
XFILLER_37_542 VPWR VGND sg13g2_decap_4
X_4044_ _1684_ _1687_ _1682_ _1693_ VPWR VGND _1690_ sg13g2_nand4_1
XFILLER_37_564 VPWR VGND sg13g2_decap_4
X_4946_ net135 VGND VPWR _0278_ videogen.test_lut_thingy.pixel_feeder_inst.row\[17\]\[3\]
+ _0012_ sg13g2_dfrbpq_1
X_4877_ net691 net736 _0212_ VPWR VGND sg13g2_nor2_1
XFILLER_21_943 VPWR VGND sg13g2_decap_8
X_3828_ videogen.test_lut_thingy.pixel_feeder_inst.row\[52\]\[3\] net602 _1481_ VPWR
+ VGND sg13g2_nor2_1
XFILLER_4_619 VPWR VGND sg13g2_fill_1
XFILLER_4_608 VPWR VGND sg13g2_decap_4
X_3759_ videogen.test_lut_thingy.pixel_feeder_inst.row\[63\]\[1\] net572 _1412_ VPWR
+ VGND sg13g2_nor2_1
XFILLER_3_129 VPWR VGND sg13g2_decap_8
X_5328__221 VPWR VGND net221 sg13g2_tiehi
XFILLER_0_825 VPWR VGND sg13g2_decap_8
XFILLER_47_339 VPWR VGND sg13g2_decap_8
XFILLER_28_575 VPWR VGND sg13g2_fill_1
X_4997__51 VPWR VGND net51 sg13g2_tiehi
XFILLER_15_214 VPWR VGND sg13g2_fill_2
XFILLER_12_921 VPWR VGND sg13g2_decap_8
XFILLER_8_925 VPWR VGND sg13g2_decap_8
XFILLER_12_998 VPWR VGND sg13g2_decap_8
XFILLER_48_1027 VPWR VGND sg13g2_fill_2
XFILLER_0_21 VPWR VGND sg13g2_decap_8
XFILLER_0_1007 VPWR VGND sg13g2_decap_8
X_5023__413 VPWR VGND net413 sg13g2_tiehi
XFILLER_47_895 VPWR VGND sg13g2_decap_8
XFILLER_0_98 VPWR VGND sg13g2_decap_8
X_4800_ net690 net726 _0135_ VPWR VGND sg13g2_nor2_1
X_2992_ videogen.test_lut_thingy.pixel_feeder_inst.row\[34\]\[3\] net770 _0814_ _0439_
+ VPWR VGND sg13g2_mux2_1
X_4731_ net714 net760 _0066_ VPWR VGND sg13g2_nor2_1
X_4662_ _2246_ net663 net477 net668 red_tmds_par\[6\] VPWR VGND sg13g2_a22oi_1
X_3613_ net629 VPWR _1266_ VGND videogen.test_lut_thingy.pixel_feeder_inst.row\[31\]\[2\]
+ net571 sg13g2_o21ai_1
X_4593_ _2207_ hsync net620 VPWR VGND sg13g2_nand2b_1
X_3544_ VGND VPWR _1096_ _1114_ _1197_ net553 sg13g2_a21oi_1
X_3475_ _1040_ _1117_ _1127_ _1128_ VPWR VGND sg13g2_nor3_1
X_5214_ net365 VGND VPWR _0542_ videogen.test_lut_thingy.pixel_feeder_inst.row\[51\]\[2\]
+ _0171_ sg13g2_dfrbpq_1
X_5145_ net216 VGND VPWR _0473_ videogen.test_lut_thingy.pixel_feeder_inst.row\[7\]\[1\]
+ _0110_ sg13g2_dfrbpq_1
X_5076_ net337 VGND VPWR _0408_ videogen.test_lut_thingy.pixel_feeder_inst.row\[14\]\[1\]
+ _0054_ sg13g2_dfrbpq_1
X_4027_ _1676_ _1675_ _1673_ VPWR VGND sg13g2_nand2b_1
X_4929_ net160 VGND VPWR _0262_ tmds_blue.dc_balancing_reg\[0\] net653 sg13g2_dfrbpq_1
XFILLER_40_548 VPWR VGND sg13g2_fill_2
XFILLER_4_405 VPWR VGND sg13g2_decap_8
Xheichips25_bagel_21 VPWR VGND uio_oe[0] sg13g2_tielo
X_5226__303 VPWR VGND net303 sg13g2_tiehi
XFILLER_0_611 VPWR VGND sg13g2_decap_8
XFILLER_0_699 VPWR VGND sg13g2_decap_8
XFILLER_48_648 VPWR VGND sg13g2_decap_8
XFILLER_44_843 VPWR VGND sg13g2_decap_8
XFILLER_18_83 VPWR VGND sg13g2_decap_8
X_5259__167 VPWR VGND net167 sg13g2_tiehi
XFILLER_16_567 VPWR VGND sg13g2_decap_8
XFILLER_31_515 VPWR VGND sg13g2_fill_1
XFILLER_31_548 VPWR VGND sg13g2_decap_8
XFILLER_15_1015 VPWR VGND sg13g2_decap_8
XFILLER_8_744 VPWR VGND sg13g2_fill_1
XFILLER_8_799 VPWR VGND sg13g2_decap_8
XFILLER_11_294 VPWR VGND sg13g2_decap_4
XFILLER_4_972 VPWR VGND sg13g2_decap_8
X_3260_ _0943_ VPWR _0944_ VGND videogen.test_lut_thingy.pixel_feeder_inst.v_counter\[2\]
+ _0942_ sg13g2_o21ai_1
XFILLER_39_604 VPWR VGND sg13g2_decap_8
X_3191_ videogen.fancy_shader.video_x\[6\] _0843_ _0894_ VPWR VGND sg13g2_nor2_1
XFILLER_22_4 VPWR VGND sg13g2_decap_8
XFILLER_38_114 VPWR VGND sg13g2_decap_4
XFILLER_38_147 VPWR VGND sg13g2_fill_1
XFILLER_22_548 VPWR VGND sg13g2_fill_2
X_2975_ net800 videogen.test_lut_thingy.pixel_feeder_inst.row\[63\]\[0\] _0810_ _0452_
+ VPWR VGND sg13g2_mux2_1
X_4714_ net706 net744 _0049_ VPWR VGND sg13g2_nor2_1
X_5134__238 VPWR VGND net238 sg13g2_tiehi
X_4645_ VPWR _0655_ _2237_ VGND sg13g2_inv_1
X_4576_ _2168_ _2185_ _2192_ VPWR VGND sg13g2_nor2_1
X_3527_ _1180_ _1172_ _1179_ VPWR VGND sg13g2_nand2_1
XFILLER_1_419 VPWR VGND sg13g2_fill_2
X_3458_ _1108_ _1109_ _1067_ _1111_ VPWR VGND sg13g2_nand3_1
X_3389_ videogen.fancy_shader.n646\[5\] net623 _1042_ VPWR VGND sg13g2_xor2_1
X_5128_ net250 VGND VPWR _0456_ videogen.test_lut_thingy.pixel_feeder_inst.row\[10\]\[0\]
+ _0093_ sg13g2_dfrbpq_1
X_5310__62 VPWR VGND net62 sg13g2_tiehi
XFILLER_17_309 VPWR VGND sg13g2_decap_4
XFILLER_29_147 VPWR VGND sg13g2_decap_8
X_5059_ net366 VGND VPWR _0391_ videogen.test_lut_thingy.pixel_feeder_inst.row\[11\]\[1\]
+ _0042_ sg13g2_dfrbpq_1
XFILLER_44_139 VPWR VGND sg13g2_decap_4
XFILLER_25_331 VPWR VGND sg13g2_decap_4
XFILLER_26_865 VPWR VGND sg13g2_fill_1
XFILLER_25_353 VPWR VGND sg13g2_decap_8
XFILLER_25_364 VPWR VGND sg13g2_fill_1
XFILLER_21_592 VPWR VGND sg13g2_decap_8
XFILLER_1_986 VPWR VGND sg13g2_decap_8
XFILLER_49_968 VPWR VGND sg13g2_decap_8
XFILLER_48_434 VPWR VGND sg13g2_decap_8
XFILLER_0_496 VPWR VGND sg13g2_decap_8
X_5161__180 VPWR VGND net180 sg13g2_tiehi
XFILLER_17_821 VPWR VGND sg13g2_decap_8
XFILLER_17_832 VPWR VGND sg13g2_fill_1
XFILLER_44_640 VPWR VGND sg13g2_decap_4
XFILLER_45_81 VPWR VGND sg13g2_decap_8
XFILLER_43_150 VPWR VGND sg13g2_fill_2
X_2760_ _0751_ net614 _0750_ VPWR VGND sg13g2_nand2_2
XFILLER_8_563 VPWR VGND sg13g2_decap_8
X_4430_ _0879_ VPWR _2066_ VGND _2061_ _2065_ sg13g2_o21ai_1
XFILLER_8_596 VPWR VGND sg13g2_fill_2
X_4361_ VGND VPWR _1974_ _1985_ _2001_ _1975_ sg13g2_a21oi_1
X_3312_ _0342_ net812 _0983_ _0984_ VPWR VGND sg13g2_and3_1
X_4292_ _1847_ _1848_ _1183_ _1938_ VPWR VGND _1851_ sg13g2_nand4_1
XFILLER_39_401 VPWR VGND sg13g2_fill_1
X_3243_ net632 _0929_ _0932_ VPWR VGND sg13g2_and2_1
XFILLER_39_445 VPWR VGND sg13g2_decap_8
X_3174_ _0884_ net496 net450 VPWR VGND sg13g2_nand2_1
XFILLER_26_106 VPWR VGND sg13g2_fill_1
XFILLER_19_191 VPWR VGND sg13g2_decap_4
XFILLER_25_18 VPWR VGND sg13g2_fill_2
XFILLER_23_846 VPWR VGND sg13g2_decap_8
XFILLER_10_507 VPWR VGND sg13g2_fill_2
X_2958_ videogen.test_lut_thingy.pixel_feeder_inst.row\[8\]\[2\] net785 _0807_ _0466_
+ VPWR VGND sg13g2_mux2_1
X_5071__347 VPWR VGND net347 sg13g2_tiehi
X_4628_ _2229_ net662 net485 net667 serialize.tmds_parallel_b\[5\] VPWR VGND sg13g2_a22oi_1
X_2889_ videogen.test_lut_thingy.pixel_feeder_inst.row\[26\]\[3\] net772 _0791_ _0527_
+ VPWR VGND sg13g2_mux2_1
XFILLER_2_717 VPWR VGND sg13g2_fill_1
X_4559_ VGND VPWR _2175_ _2153_ tmds_blue.dc_balancing_reg\[3\] sg13g2_or2_1
XFILLER_49_209 VPWR VGND sg13g2_decap_8
XFILLER_45_404 VPWR VGND sg13g2_fill_1
X_4941__145 VPWR VGND net145 sg13g2_tiehi
XFILLER_14_802 VPWR VGND sg13g2_fill_2
XFILLER_25_172 VPWR VGND sg13g2_fill_1
XFILLER_13_345 VPWR VGND sg13g2_decap_4
XFILLER_9_327 VPWR VGND sg13g2_fill_2
XFILLER_31_61 VPWR VGND sg13g2_decap_8
XFILLER_31_83 VPWR VGND sg13g2_decap_8
Xoutput4 net4 tmds_clk VPWR VGND sg13g2_buf_1
XFILLER_1_772 VPWR VGND sg13g2_decap_8
XFILLER_48_286 VPWR VGND sg13g2_fill_1
XFILLER_36_437 VPWR VGND sg13g2_decap_8
X_3930_ videogen.test_lut_thingy.pixel_feeder_inst.row\[16\]\[0\] net599 _1582_ VPWR
+ VGND sg13g2_nor2_1
XFILLER_16_150 VPWR VGND sg13g2_fill_2
X_3861_ videogen.test_lut_thingy.pixel_feeder_inst.row\[23\]\[3\] net572 _1514_ VPWR
+ VGND sg13g2_nor2_1
X_2812_ videogen.test_lut_thingy.pixel_feeder_inst.row\[40\]\[0\] net803 _0771_ _0584_
+ VPWR VGND sg13g2_mux2_1
XFILLER_31_175 VPWR VGND sg13g2_fill_2
XFILLER_31_186 VPWR VGND sg13g2_fill_2
X_3792_ net627 _1433_ _1444_ _1445_ VPWR VGND sg13g2_nor3_1
X_2743_ net639 net640 _0738_ VPWR VGND sg13g2_nor2b_2
XFILLER_8_393 VPWR VGND sg13g2_decap_4
X_2674_ VPWR _0682_ videogen.fancy_shader.n646\[1\] VGND sg13g2_inv_1
X_4413_ _2050_ _2048_ _2051_ VPWR VGND sg13g2_xor2_1
X_4344_ _1985_ _1968_ _1981_ VPWR VGND sg13g2_xnor2_1
XFILLER_28_1003 VPWR VGND sg13g2_decap_8
X_4275_ _1921_ _1918_ _1920_ VPWR VGND sg13g2_nand2_1
X_3226_ VGND VPWR videogen.test_lut_thingy.pixel_feeder_inst.v_pix\[3\] _0917_ _0920_
+ videogen.test_lut_thingy.pixel_feeder_inst.v_pix\[4\] sg13g2_a21oi_1
XFILLER_27_404 VPWR VGND sg13g2_fill_2
X_3157_ VGND VPWR net756 net491 _0263_ _0881_ sg13g2_a21oi_1
X_3088_ videogen.fancy_shader.video_x\[1\] videogen.fancy_shader.video_x\[0\] _0839_
+ VPWR VGND sg13g2_and2_1
XFILLER_35_1007 VPWR VGND sg13g2_decap_8
XFILLER_22_153 VPWR VGND sg13g2_fill_1
XFILLER_22_164 VPWR VGND sg13g2_fill_2
XFILLER_22_175 VPWR VGND sg13g2_decap_8
XFILLER_19_949 VPWR VGND sg13g2_decap_8
X_5297__237 VPWR VGND net237 sg13g2_tiehi
XFILLER_34_908 VPWR VGND sg13g2_decap_8
XFILLER_46_779 VPWR VGND sg13g2_decap_8
X_5303__193 VPWR VGND net193 sg13g2_tiehi
XFILLER_33_407 VPWR VGND sg13g2_fill_1
XFILLER_26_470 VPWR VGND sg13g2_decap_8
XFILLER_13_131 VPWR VGND sg13g2_fill_1
XFILLER_9_124 VPWR VGND sg13g2_fill_2
XFILLER_14_687 VPWR VGND sg13g2_fill_1
XFILLER_42_71 VPWR VGND sg13g2_fill_2
XFILLER_9_157 VPWR VGND sg13g2_decap_8
XFILLER_3_32 VPWR VGND sg13g2_decap_4
X_4060_ _1694_ _1708_ _1709_ VPWR VGND sg13g2_and2_1
XFILLER_3_1027 VPWR VGND sg13g2_fill_2
XFILLER_3_1016 VPWR VGND sg13g2_decap_8
X_3011_ _0759_ _0806_ _0818_ VPWR VGND sg13g2_nor2_2
XFILLER_49_595 VPWR VGND sg13g2_decap_8
XFILLER_25_908 VPWR VGND sg13g2_decap_8
XFILLER_25_919 VPWR VGND sg13g2_decap_8
XFILLER_36_245 VPWR VGND sg13g2_decap_4
X_4962_ net110 VGND VPWR _0294_ videogen.fancy_shader.video_x\[0\] net646 sg13g2_dfrbpq_2
XFILLER_18_993 VPWR VGND sg13g2_decap_8
XFILLER_33_941 VPWR VGND sg13g2_fill_2
X_4893_ net682 net727 _0228_ VPWR VGND sg13g2_nor2_1
X_3913_ videogen.test_lut_thingy.pixel_feeder_inst.row\[14\]\[0\] net588 _1565_ VPWR
+ VGND sg13g2_nor2_1
XFILLER_32_440 VPWR VGND sg13g2_decap_8
X_3844_ VGND VPWR _1497_ _1496_ _1473_ sg13g2_or2_1
XFILLER_33_996 VPWR VGND sg13g2_decap_8
X_3775_ net635 VPWR _1428_ VGND videogen.test_lut_thingy.pixel_feeder_inst.row\[47\]\[1\]
+ net574 sg13g2_o21ai_1
X_2726_ net606 net554 _0729_ _0733_ VGND VPWR net583 sg13g2_nor4_2
X_4327_ _1968_ _1954_ _1966_ VPWR VGND sg13g2_xnor2_1
X_4258_ VGND VPWR _1901_ _1902_ _1904_ _1897_ sg13g2_a21oi_1
X_3209_ _0711_ _0723_ _0903_ _0907_ VGND VPWR _0906_ sg13g2_nor4_2
XFILLER_28_713 VPWR VGND sg13g2_fill_2
XFILLER_28_724 VPWR VGND sg13g2_decap_4
X_4189_ VPWR _1835_ _1834_ VGND sg13g2_inv_1
XFILLER_28_779 VPWR VGND sg13g2_decap_8
XFILLER_24_996 VPWR VGND sg13g2_decap_8
XFILLER_7_617 VPWR VGND sg13g2_decap_8
XFILLER_6_149 VPWR VGND sg13g2_fill_1
XFILLER_2_355 VPWR VGND sg13g2_fill_2
Xfanout692 net693 net692 VPWR VGND sg13g2_buf_1
Xfanout670 net671 net670 VPWR VGND sg13g2_buf_1
Xfanout681 net716 net681 VPWR VGND sg13g2_buf_8
XFILLER_46_554 VPWR VGND sg13g2_decap_8
XFILLER_37_82 VPWR VGND sg13g2_fill_2
X_5271__34 VPWR VGND net34 sg13g2_tiehi
XFILLER_15_952 VPWR VGND sg13g2_decap_8
XFILLER_30_933 VPWR VGND sg13g2_decap_4
XFILLER_42_793 VPWR VGND sg13g2_fill_1
XFILLER_30_999 VPWR VGND sg13g2_decap_8
X_3560_ VGND VPWR _1210_ _1211_ _1213_ _1199_ sg13g2_a21oi_1
X_3491_ _1137_ _1142_ _1126_ _1144_ VPWR VGND sg13g2_nand3_1
X_5230_ net287 VGND VPWR _0558_ videogen.test_lut_thingy.pixel_feeder_inst.row\[47\]\[2\]
+ _0187_ sg13g2_dfrbpq_1
X_5161_ net180 VGND VPWR _0489_ videogen.test_lut_thingy.pixel_feeder_inst.row\[58\]\[1\]
+ _0126_ sg13g2_dfrbpq_1
X_5092_ net318 VGND VPWR _0420_ tmds_green.dc_balancing_reg\[1\] net659 sg13g2_dfrbpq_2
X_4112_ _1758_ _1029_ _1755_ VPWR VGND sg13g2_xnor2_1
XFILLER_25_1017 VPWR VGND sg13g2_decap_8
XFILLER_25_1028 VPWR VGND sg13g2_fill_1
X_4043_ _1692_ _1682_ _1684_ VPWR VGND sg13g2_nand2_1
XFILLER_49_370 VPWR VGND sg13g2_decap_8
XFILLER_24_226 VPWR VGND sg13g2_decap_4
X_4945_ net137 VGND VPWR _0277_ videogen.test_lut_thingy.pixel_feeder_inst.row\[17\]\[2\]
+ _0011_ sg13g2_dfrbpq_1
XFILLER_21_922 VPWR VGND sg13g2_decap_8
X_4876_ net687 net732 _0211_ VPWR VGND sg13g2_nor2_1
XFILLER_32_270 VPWR VGND sg13g2_fill_1
XFILLER_21_999 VPWR VGND sg13g2_decap_8
X_3827_ videogen.test_lut_thingy.pixel_feeder_inst.row\[55\]\[3\] net579 _1480_ VPWR
+ VGND sg13g2_nor2_1
X_3758_ net634 VPWR _1411_ VGND videogen.test_lut_thingy.pixel_feeder_inst.row\[62\]\[1\]
+ net582 sg13g2_o21ai_1
XFILLER_20_487 VPWR VGND sg13g2_decap_8
X_2709_ videogen.fancy_shader.video_x\[1\] videogen.fancy_shader.video_x\[0\] _0716_
+ VPWR VGND sg13g2_nor2_1
X_3689_ videogen.test_lut_thingy.pixel_feeder_inst.row\[32\]\[2\] net595 _1342_ VPWR
+ VGND sg13g2_nor2_1
X_5113__280 VPWR VGND net280 sg13g2_tiehi
XFILLER_0_804 VPWR VGND sg13g2_decap_8
X_5144__218 VPWR VGND net218 sg13g2_tiehi
XFILLER_28_521 VPWR VGND sg13g2_decap_8
XFILLER_15_259 VPWR VGND sg13g2_decap_8
XFILLER_12_900 VPWR VGND sg13g2_decap_8
XFILLER_8_904 VPWR VGND sg13g2_decap_8
XFILLER_11_465 VPWR VGND sg13g2_fill_2
XFILLER_12_977 VPWR VGND sg13g2_decap_8
XFILLER_23_51 VPWR VGND sg13g2_fill_1
XFILLER_7_447 VPWR VGND sg13g2_fill_1
XFILLER_11_498 VPWR VGND sg13g2_decap_8
XFILLER_48_1006 VPWR VGND sg13g2_decap_8
XFILLER_3_664 VPWR VGND sg13g2_decap_8
XFILLER_2_130 VPWR VGND sg13g2_decap_8
XFILLER_2_196 VPWR VGND sg13g2_fill_2
XFILLER_48_81 VPWR VGND sg13g2_fill_2
XFILLER_47_874 VPWR VGND sg13g2_decap_8
XFILLER_46_340 VPWR VGND sg13g2_decap_8
XFILLER_0_77 VPWR VGND sg13g2_decap_8
XFILLER_34_535 VPWR VGND sg13g2_decap_8
X_2991_ _0754_ _0774_ _0814_ VPWR VGND sg13g2_nor2_2
XFILLER_21_207 VPWR VGND sg13g2_decap_8
X_4730_ net713 net758 _0065_ VPWR VGND sg13g2_nor2_1
XFILLER_9_31 VPWR VGND sg13g2_fill_2
X_4661_ VPWR _0663_ _2245_ VGND sg13g2_inv_1
X_3612_ net636 _1259_ _1264_ _1265_ VPWR VGND sg13g2_nor3_1
XFILLER_30_785 VPWR VGND sg13g2_fill_1
X_4592_ net559 _2206_ _0515_ VPWR VGND sg13g2_nor2_1
X_3543_ _1192_ _1193_ _1101_ _1196_ VPWR VGND sg13g2_mux2_1
XFILLER_43_0 VPWR VGND sg13g2_fill_1
X_3474_ VPWR _1127_ _1126_ VGND sg13g2_inv_1
X_5213_ net369 VGND VPWR _0541_ videogen.test_lut_thingy.pixel_feeder_inst.row\[51\]\[1\]
+ _0170_ sg13g2_dfrbpq_1
X_5144_ net218 VGND VPWR _0472_ videogen.test_lut_thingy.pixel_feeder_inst.row\[7\]\[0\]
+ _0109_ sg13g2_dfrbpq_1
X_5075_ net339 VGND VPWR _0407_ videogen.test_lut_thingy.pixel_feeder_inst.row\[14\]\[0\]
+ _0053_ sg13g2_dfrbpq_1
X_4026_ _1671_ _1672_ _1668_ _1675_ VPWR VGND sg13g2_nand3_1
XFILLER_25_535 VPWR VGND sg13g2_decap_8
XFILLER_25_557 VPWR VGND sg13g2_decap_4
XFILLER_40_516 VPWR VGND sg13g2_decap_4
X_4928_ net186 VGND VPWR _0261_ tmds_green.dc_balancing_reg\[0\] net652 sg13g2_dfrbpq_1
X_4859_ net687 net733 _0194_ VPWR VGND sg13g2_nor2_1
Xheichips25_bagel_22 VPWR VGND uio_oe[1] sg13g2_tielo
XFILLER_48_627 VPWR VGND sg13g2_decap_8
XFILLER_0_678 VPWR VGND sg13g2_decap_8
X_5081__327 VPWR VGND net327 sg13g2_tiehi
XFILLER_31_527 VPWR VGND sg13g2_decap_8
XFILLER_8_712 VPWR VGND sg13g2_fill_1
XFILLER_7_222 VPWR VGND sg13g2_fill_2
XFILLER_11_273 VPWR VGND sg13g2_decap_8
XFILLER_7_255 VPWR VGND sg13g2_fill_2
XFILLER_4_951 VPWR VGND sg13g2_decap_8
XFILLER_3_483 VPWR VGND sg13g2_fill_1
X_3190_ _0843_ _0889_ _0893_ _0299_ VPWR VGND sg13g2_nor3_1
XFILLER_39_638 VPWR VGND sg13g2_decap_4
XFILLER_15_4 VPWR VGND sg13g2_fill_1
XFILLER_19_340 VPWR VGND sg13g2_decap_4
XFILLER_19_362 VPWR VGND sg13g2_decap_4
X_5097__312 VPWR VGND net312 sg13g2_tiehi
XFILLER_34_343 VPWR VGND sg13g2_fill_1
X_2974_ net789 videogen.test_lut_thingy.pixel_feeder_inst.row\[63\]\[1\] _0810_ _0453_
+ VPWR VGND sg13g2_mux2_1
X_4713_ net703 net748 _0048_ VPWR VGND sg13g2_nor2_1
X_4644_ _2237_ net665 net470 net670 green_tmds_par\[1\] VPWR VGND sg13g2_a22oi_1
X_4575_ _2191_ _2168_ _2186_ VPWR VGND sg13g2_nand2_1
X_3526_ VGND VPWR _1178_ _1179_ _1177_ _1175_ sg13g2_a21oi_2
X_3457_ _1067_ _1109_ _1110_ VPWR VGND sg13g2_and2_1
X_3388_ net623 videogen.fancy_shader.n646\[5\] _1041_ VPWR VGND sg13g2_nor2_1
X_5127_ net252 VGND VPWR _0455_ videogen.test_lut_thingy.pixel_feeder_inst.row\[63\]\[3\]
+ _0092_ sg13g2_dfrbpq_1
XFILLER_29_126 VPWR VGND sg13g2_decap_8
X_5058_ net368 VGND VPWR _0390_ videogen.test_lut_thingy.pixel_feeder_inst.row\[11\]\[0\]
+ _0041_ sg13g2_dfrbpq_1
XFILLER_45_619 VPWR VGND sg13g2_decap_8
X_4009_ _1658_ _1033_ _1657_ VPWR VGND sg13g2_nand2_2
XFILLER_26_822 VPWR VGND sg13g2_decap_8
XFILLER_38_1027 VPWR VGND sg13g2_fill_2
XFILLER_13_538 VPWR VGND sg13g2_fill_2
XFILLER_4_236 VPWR VGND sg13g2_fill_1
XFILLER_20_41 VPWR VGND sg13g2_fill_1
XFILLER_48_402 VPWR VGND sg13g2_decap_8
XFILLER_1_965 VPWR VGND sg13g2_decap_8
XFILLER_49_947 VPWR VGND sg13g2_decap_8
Xhold50 serialize.shift_reg_c\[8\] VPWR VGND net495 sg13g2_dlygate4sd3_1
XFILLER_0_475 VPWR VGND sg13g2_decap_8
XFILLER_29_50 VPWR VGND sg13g2_fill_1
XFILLER_21_1020 VPWR VGND sg13g2_decap_8
XFILLER_29_94 VPWR VGND sg13g2_fill_1
XFILLER_17_866 VPWR VGND sg13g2_fill_1
XFILLER_28_181 VPWR VGND sg13g2_decap_4
XFILLER_44_685 VPWR VGND sg13g2_decap_4
XFILLER_44_696 VPWR VGND sg13g2_fill_1
XFILLER_31_368 VPWR VGND sg13g2_fill_1
X_2690_ VPWR _0698_ tmds_red.dc_balancing_reg\[4\] VGND sg13g2_inv_1
XFILLER_6_76 VPWR VGND sg13g2_decap_4
X_4360_ VPWR _2000_ _1999_ VGND sg13g2_inv_1
X_3311_ _0908_ _0981_ videogen.fancy_shader.n646\[5\] _0984_ VPWR VGND sg13g2_nand3_1
XFILLER_4_781 VPWR VGND sg13g2_decap_8
XFILLER_3_280 VPWR VGND sg13g2_fill_2
X_4291_ _1937_ _1849_ _1853_ VPWR VGND sg13g2_nand2_1
X_3242_ net632 _0929_ _0931_ VPWR VGND sg13g2_nor2_1
X_3173_ net450 net662 _0284_ VPWR VGND sg13g2_nor2b_1
XFILLER_22_313 VPWR VGND sg13g2_decap_4
XFILLER_22_324 VPWR VGND sg13g2_fill_2
XFILLER_34_195 VPWR VGND sg13g2_fill_1
X_2957_ videogen.test_lut_thingy.pixel_feeder_inst.row\[8\]\[3\] net774 _0807_ _0467_
+ VPWR VGND sg13g2_mux2_1
X_5290__265 VPWR VGND net265 sg13g2_tiehi
X_2888_ _0743_ _0774_ _0791_ VPWR VGND sg13g2_nor2_2
X_4627_ VPWR _0646_ _2228_ VGND sg13g2_inv_1
X_4558_ VGND VPWR _2156_ _2157_ _2174_ _2159_ sg13g2_a21oi_1
X_4489_ _2079_ VPWR _2113_ VGND tmds_green.dc_balancing_reg\[3\] _2081_ sg13g2_o21ai_1
X_3509_ _1126_ VPWR _1162_ VGND _1136_ _1161_ sg13g2_o21ai_1
XFILLER_44_1020 VPWR VGND sg13g2_decap_8
XFILLER_46_939 VPWR VGND sg13g2_decap_8
XFILLER_17_129 VPWR VGND sg13g2_decap_8
XFILLER_13_324 VPWR VGND sg13g2_fill_1
XFILLER_14_836 VPWR VGND sg13g2_decap_8
XFILLER_14_847 VPWR VGND sg13g2_fill_1
XFILLER_9_306 VPWR VGND sg13g2_decap_8
XFILLER_15_74 VPWR VGND sg13g2_fill_2
XFILLER_22_891 VPWR VGND sg13g2_decap_8
XFILLER_5_512 VPWR VGND sg13g2_decap_8
XFILLER_12_1019 VPWR VGND sg13g2_decap_8
XFILLER_5_589 VPWR VGND sg13g2_decap_8
XFILLER_5_567 VPWR VGND sg13g2_decap_8
Xoutput5 net5 tmds_g VPWR VGND sg13g2_buf_1
XFILLER_49_700 VPWR VGND sg13g2_decap_4
XFILLER_48_243 VPWR VGND sg13g2_decap_8
XFILLER_0_283 VPWR VGND sg13g2_decap_8
XFILLER_48_254 VPWR VGND sg13g2_fill_1
XFILLER_37_928 VPWR VGND sg13g2_decap_4
XFILLER_45_983 VPWR VGND sg13g2_decap_8
XFILLER_44_493 VPWR VGND sg13g2_decap_8
X_3860_ _1509_ _1510_ _1511_ _1512_ _1513_ VPWR VGND sg13g2_nor4_1
X_5199__36 VPWR VGND net36 sg13g2_tiehi
XFILLER_16_195 VPWR VGND sg13g2_fill_2
X_2811_ videogen.test_lut_thingy.pixel_feeder_inst.row\[40\]\[1\] net792 _0771_ _0585_
+ VPWR VGND sg13g2_mux2_1
X_4957__120 VPWR VGND net120 sg13g2_tiehi
XFILLER_31_165 VPWR VGND sg13g2_decap_4
X_3791_ net630 _1438_ _1443_ _1444_ VPWR VGND sg13g2_nor3_1
X_2742_ net805 videogen.test_lut_thingy.pixel_feeder_inst.row\[23\]\[0\] _0737_ _0630_
+ VPWR VGND sg13g2_mux2_1
X_2673_ VPWR _0681_ videogen.fancy_shader.n646\[4\] VGND sg13g2_inv_1
X_4412_ _2050_ tmds_red.dc_balancing_reg\[4\] _2049_ VPWR VGND sg13g2_xnor2_1
X_4343_ _1983_ _1977_ _1984_ VPWR VGND sg13g2_nor2b_2
X_4274_ _1909_ _1895_ _1919_ _1920_ VPWR VGND sg13g2_mux2_1
X_3225_ VPWR _0308_ _0919_ VGND sg13g2_inv_1
XFILLER_27_416 VPWR VGND sg13g2_fill_2
X_3156_ net815 VPWR _0881_ VGND net756 net491 sg13g2_o21ai_1
XFILLER_39_298 VPWR VGND sg13g2_fill_2
X_3087_ _0838_ videogen.test_lut_thingy.pixel_feeder_inst.h_counter\[3\] _0836_ _0837_
+ VPWR VGND sg13g2_and3_1
XFILLER_36_961 VPWR VGND sg13g2_fill_2
X_3989_ net627 _1640_ _1641_ VPWR VGND sg13g2_nor2_1
XFILLER_6_309 VPWR VGND sg13g2_fill_2
XFILLER_19_928 VPWR VGND sg13g2_decap_8
XFILLER_45_224 VPWR VGND sg13g2_fill_1
X_5123__260 VPWR VGND net260 sg13g2_tiehi
XFILLER_26_51 VPWR VGND sg13g2_decap_8
XFILLER_26_62 VPWR VGND sg13g2_fill_2
XFILLER_27_983 VPWR VGND sg13g2_decap_8
XFILLER_14_655 VPWR VGND sg13g2_fill_2
XFILLER_13_143 VPWR VGND sg13g2_fill_1
XFILLER_5_320 VPWR VGND sg13g2_fill_1
X_5054__376 VPWR VGND net376 sg13g2_tiehi
XFILLER_47_7 VPWR VGND sg13g2_decap_8
XFILLER_5_397 VPWR VGND sg13g2_decap_8
XFILLER_3_11 VPWR VGND sg13g2_decap_8
XFILLER_3_66 VPWR VGND sg13g2_fill_1
XFILLER_49_574 VPWR VGND sg13g2_decap_8
X_3010_ videogen.test_lut_thingy.pixel_feeder_inst.row\[32\]\[0\] net802 _0817_ _0424_
+ VPWR VGND sg13g2_mux2_1
XFILLER_36_202 VPWR VGND sg13g2_fill_2
XFILLER_18_972 VPWR VGND sg13g2_decap_8
XFILLER_36_268 VPWR VGND sg13g2_decap_8
X_4961_ net112 VGND VPWR _0293_ videogen.test_lut_thingy.pixel_feeder_inst.row\[20\]\[3\]
+ _0020_ sg13g2_dfrbpq_1
XFILLER_17_471 VPWR VGND sg13g2_fill_1
X_3912_ videogen.test_lut_thingy.pixel_feeder_inst.row\[12\]\[0\] net600 _1564_ VPWR
+ VGND sg13g2_nor2_1
X_4892_ net682 net727 _0227_ VPWR VGND sg13g2_nor2_1
X_3843_ net625 VPWR _1496_ VGND _1484_ _1495_ sg13g2_o21ai_1
XFILLER_32_474 VPWR VGND sg13g2_decap_8
XFILLER_32_485 VPWR VGND sg13g2_fill_1
X_3774_ _1423_ _1424_ _1425_ _1426_ _1427_ VPWR VGND sg13g2_nor4_1
X_2725_ net606 net554 _0732_ VPWR VGND sg13g2_nor2_2
X_4326_ VPWR _1967_ net552 VGND sg13g2_inv_1
X_4257_ _1893_ _1894_ _1897_ _1903_ VPWR VGND sg13g2_nor3_1
X_3208_ videogen.mem_read _0851_ _0906_ VPWR VGND sg13g2_nor2_1
X_4188_ _1834_ _1758_ _1832_ VPWR VGND sg13g2_xnor2_1
X_3139_ VGND VPWR _0863_ _0875_ net20 _0864_ sg13g2_a21oi_1
XFILLER_28_747 VPWR VGND sg13g2_decap_8
XFILLER_28_758 VPWR VGND sg13g2_decap_8
XFILLER_43_717 VPWR VGND sg13g2_fill_1
X_5265__98 VPWR VGND net98 sg13g2_tiehi
XFILLER_23_441 VPWR VGND sg13g2_fill_1
XFILLER_24_975 VPWR VGND sg13g2_decap_8
XFILLER_11_625 VPWR VGND sg13g2_fill_2
XFILLER_11_647 VPWR VGND sg13g2_decap_8
XFILLER_10_135 VPWR VGND sg13g2_fill_1
XFILLER_6_128 VPWR VGND sg13g2_decap_8
XFILLER_12_42 VPWR VGND sg13g2_fill_1
XFILLER_12_53 VPWR VGND sg13g2_decap_8
XFILLER_2_334 VPWR VGND sg13g2_decap_8
Xfanout660 net661 net660 VPWR VGND sg13g2_buf_8
Xfanout693 net694 net693 VPWR VGND sg13g2_buf_8
Xfanout682 net684 net682 VPWR VGND sg13g2_buf_8
Xfanout671 _0669_ net671 VPWR VGND sg13g2_buf_8
XFILLER_37_72 VPWR VGND sg13g2_fill_2
XFILLER_37_61 VPWR VGND sg13g2_decap_8
XFILLER_15_931 VPWR VGND sg13g2_decap_8
XFILLER_18_279 VPWR VGND sg13g2_decap_4
XFILLER_34_739 VPWR VGND sg13g2_decap_8
XFILLER_18_1014 VPWR VGND sg13g2_decap_8
XFILLER_30_978 VPWR VGND sg13g2_decap_8
X_3490_ VPWR _1143_ _1142_ VGND sg13g2_inv_1
XFILLER_5_172 VPWR VGND sg13g2_fill_2
X_5192__64 VPWR VGND net64 sg13g2_tiehi
XFILLER_45_4 VPWR VGND sg13g2_fill_2
XFILLER_5_183 VPWR VGND sg13g2_fill_1
X_5160_ net182 VGND VPWR _0488_ videogen.test_lut_thingy.pixel_feeder_inst.row\[58\]\[0\]
+ _0125_ sg13g2_dfrbpq_1
X_5323__301 VPWR VGND net301 sg13g2_tiehi
XFILLER_2_890 VPWR VGND sg13g2_decap_8
X_4111_ _1027_ _1169_ _1757_ VPWR VGND sg13g2_nor2b_2
X_5091_ net319 VGND VPWR _0419_ red_tmds_par\[9\] net658 sg13g2_dfrbpq_1
X_4042_ _1691_ _1687_ _1690_ VPWR VGND sg13g2_nand2_1
X_4944_ net139 VGND VPWR _0276_ videogen.test_lut_thingy.pixel_feeder_inst.row\[17\]\[1\]
+ _0010_ sg13g2_dfrbpq_1
XFILLER_20_400 VPWR VGND sg13g2_decap_8
XFILLER_21_901 VPWR VGND sg13g2_decap_8
XFILLER_33_761 VPWR VGND sg13g2_fill_2
X_4875_ net691 net736 _0210_ VPWR VGND sg13g2_nor2_1
XFILLER_21_978 VPWR VGND sg13g2_decap_8
X_3826_ net638 VPWR _1479_ VGND videogen.test_lut_thingy.pixel_feeder_inst.row\[53\]\[3\]
+ net569 sg13g2_o21ai_1
X_3757_ net631 _1404_ _1409_ _1410_ VPWR VGND sg13g2_nor3_1
X_2708_ videogen.fancy_shader.video_x\[4\] videogen.fancy_shader.video_x\[3\] videogen.fancy_shader.video_x\[2\]
+ _0715_ VPWR VGND sg13g2_nor3_1
X_3688_ net612 VPWR _1341_ VGND videogen.test_lut_thingy.pixel_feeder_inst.row\[33\]\[2\]
+ net562 sg13g2_o21ai_1
X_4309_ net765 _1646_ _1943_ _1951_ VPWR VGND sg13g2_or3_1
XFILLER_47_308 VPWR VGND sg13g2_fill_1
X_5289_ net269 VGND VPWR _0617_ blue_tmds_par\[1\] net652 sg13g2_dfrbpq_1
XFILLER_28_533 VPWR VGND sg13g2_fill_1
XFILLER_16_706 VPWR VGND sg13g2_decap_4
XFILLER_28_566 VPWR VGND sg13g2_decap_8
XFILLER_43_525 VPWR VGND sg13g2_fill_2
XFILLER_15_216 VPWR VGND sg13g2_fill_1
XFILLER_12_956 VPWR VGND sg13g2_decap_8
X_5005__35 VPWR VGND net35 sg13g2_tiehi
XFILLER_7_459 VPWR VGND sg13g2_decap_8
X_5051__379 VPWR VGND net379 sg13g2_tiehi
XFILLER_3_643 VPWR VGND sg13g2_decap_8
XFILLER_2_164 VPWR VGND sg13g2_decap_8
XFILLER_2_175 VPWR VGND sg13g2_fill_1
XFILLER_47_853 VPWR VGND sg13g2_decap_8
XFILLER_19_544 VPWR VGND sg13g2_fill_1
XFILLER_0_56 VPWR VGND sg13g2_decap_8
XFILLER_19_599 VPWR VGND sg13g2_fill_2
XFILLER_34_525 VPWR VGND sg13g2_decap_4
X_2990_ videogen.test_lut_thingy.pixel_feeder_inst.row\[30\]\[0\] net800 _0813_ _0440_
+ VPWR VGND sg13g2_mux2_1
XFILLER_15_761 VPWR VGND sg13g2_decap_8
XFILLER_15_794 VPWR VGND sg13g2_decap_8
X_4660_ _2245_ net664 net462 net669 red_tmds_par\[5\] VPWR VGND sg13g2_a22oi_1
X_3611_ _1260_ _1261_ _1262_ _1263_ _1264_ VPWR VGND sg13g2_nor4_1
XFILLER_31_1011 VPWR VGND sg13g2_decap_8
X_4591_ _2205_ _2188_ _2206_ VPWR VGND sg13g2_nor2b_1
X_3542_ VGND VPWR _1100_ _1192_ _1195_ _1194_ sg13g2_a21oi_1
XFILLER_7_982 VPWR VGND sg13g2_decap_8
X_3473_ _1126_ _1051_ _1124_ VPWR VGND sg13g2_xnor2_1
X_5212_ net373 VGND VPWR _0540_ videogen.test_lut_thingy.pixel_feeder_inst.row\[51\]\[0\]
+ _0169_ sg13g2_dfrbpq_1
XFILLER_9_1023 VPWR VGND sg13g2_decap_4
X_5143_ net220 VGND VPWR _0471_ videogen.test_lut_thingy.pixel_feeder_inst.row\[62\]\[3\]
+ _0108_ sg13g2_dfrbpq_1
XFILLER_36_0 VPWR VGND sg13g2_decap_4
X_5074_ net341 VGND VPWR _0406_ videogen.test_lut_thingy.pixel_feeder_inst.row\[15\]\[3\]
+ _0052_ sg13g2_dfrbpq_1
XFILLER_38_864 VPWR VGND sg13g2_fill_1
X_4025_ VGND VPWR _1666_ _1673_ _1674_ _1664_ sg13g2_a21oi_1
XFILLER_40_528 VPWR VGND sg13g2_fill_2
X_4927_ net677 net722 _0260_ VPWR VGND sg13g2_nor2_1
X_4858_ net689 net734 _0193_ VPWR VGND sg13g2_nor2_1
X_3809_ net635 VPWR _1462_ VGND videogen.test_lut_thingy.pixel_feeder_inst.row\[46\]\[3\]
+ net585 sg13g2_o21ai_1
X_4789_ net702 net747 _0124_ VPWR VGND sg13g2_nor2_1
X_4937__151 VPWR VGND net151 sg13g2_tiehi
Xheichips25_bagel_23 VPWR VGND uio_oe[2] sg13g2_tielo
X_5085__420 VPWR VGND net420 sg13g2_tiehi
XFILLER_48_606 VPWR VGND sg13g2_decap_8
XFILLER_0_657 VPWR VGND sg13g2_decap_8
XFILLER_28_341 VPWR VGND sg13g2_fill_1
XFILLER_29_853 VPWR VGND sg13g2_decap_8
XFILLER_44_812 VPWR VGND sg13g2_decap_8
XFILLER_29_886 VPWR VGND sg13g2_fill_2
XFILLER_43_344 VPWR VGND sg13g2_decap_8
XFILLER_16_547 VPWR VGND sg13g2_decap_8
XFILLER_7_289 VPWR VGND sg13g2_decap_8
XFILLER_4_930 VPWR VGND sg13g2_decap_8
XFILLER_3_473 VPWR VGND sg13g2_decap_4
XFILLER_34_322 VPWR VGND sg13g2_decap_4
X_2973_ net778 videogen.test_lut_thingy.pixel_feeder_inst.row\[63\]\[2\] _0810_ _0454_
+ VPWR VGND sg13g2_mux2_1
X_4712_ net703 net748 _0047_ VPWR VGND sg13g2_nor2_1
X_4643_ VPWR _0654_ net488 VGND sg13g2_inv_1
X_4574_ _2190_ _2180_ _2189_ VPWR VGND sg13g2_xnor2_1
XFILLER_7_790 VPWR VGND sg13g2_fill_1
X_3525_ _1154_ _1164_ _1160_ _1178_ VPWR VGND sg13g2_mux2_1
X_3456_ _1066_ _1061_ _1053_ _1109_ VPWR VGND sg13g2_a21o_1
X_3387_ _1040_ _0977_ _1038_ VPWR VGND sg13g2_xnor2_1
X_5126_ net254 VGND VPWR _0454_ videogen.test_lut_thingy.pixel_feeder_inst.row\[63\]\[2\]
+ _0091_ sg13g2_dfrbpq_1
XFILLER_29_105 VPWR VGND sg13g2_decap_8
X_5057_ net370 VGND VPWR _0389_ videogen.test_lut_thingy.pixel_feeder_inst.row\[12\]\[3\]
+ _0040_ sg13g2_dfrbpq_1
X_4008_ _1027_ _1654_ _1657_ VPWR VGND sg13g2_nor2_1
XFILLER_38_1006 VPWR VGND sg13g2_decap_8
XFILLER_41_826 VPWR VGND sg13g2_decap_8
XFILLER_40_325 VPWR VGND sg13g2_fill_1
XFILLER_40_336 VPWR VGND sg13g2_fill_2
XFILLER_21_550 VPWR VGND sg13g2_decap_8
XFILLER_5_705 VPWR VGND sg13g2_decap_8
XFILLER_0_410 VPWR VGND sg13g2_decap_8
XFILLER_1_944 VPWR VGND sg13g2_decap_8
XFILLER_49_926 VPWR VGND sg13g2_decap_8
XFILLER_0_454 VPWR VGND sg13g2_decap_8
Xhold40 serialize.shift_reg_b\[7\] VPWR VGND net485 sg13g2_dlygate4sd3_1
XFILLER_48_469 VPWR VGND sg13g2_decap_4
Xhold51 serialize.bit_cnt\[1\] VPWR VGND net496 sg13g2_dlygate4sd3_1
XFILLER_29_650 VPWR VGND sg13g2_fill_1
XFILLER_45_61 VPWR VGND sg13g2_fill_1
XFILLER_16_344 VPWR VGND sg13g2_fill_2
XFILLER_32_837 VPWR VGND sg13g2_decap_8
XFILLER_8_510 VPWR VGND sg13g2_fill_1
XFILLER_12_550 VPWR VGND sg13g2_decap_8
X_5133__240 VPWR VGND net240 sg13g2_tiehi
X_3310_ _0981_ _0908_ videogen.fancy_shader.n646\[5\] _0983_ VPWR VGND sg13g2_a21o_1
X_4290_ _1936_ _1834_ _1848_ VPWR VGND sg13g2_xnor2_1
X_3241_ _0929_ _0930_ _0313_ VPWR VGND sg13g2_nor2_1
X_3172_ net458 net662 _0283_ VPWR VGND sg13g2_and2_1
XFILLER_6_1004 VPWR VGND sg13g2_decap_8
XFILLER_39_436 VPWR VGND sg13g2_fill_1
XFILLER_48_992 VPWR VGND sg13g2_decap_8
X_2956_ _0744_ _0806_ _0807_ VPWR VGND sg13g2_nor2_2
XFILLER_41_19 VPWR VGND sg13g2_decap_8
XFILLER_10_509 VPWR VGND sg13g2_fill_1
X_2887_ videogen.test_lut_thingy.pixel_feeder_inst.row\[25\]\[0\] net805 _0790_ _0528_
+ VPWR VGND sg13g2_mux2_1
XFILLER_31_892 VPWR VGND sg13g2_decap_8
X_4626_ _2228_ net662 net494 net668 blue_tmds_par\[2\] VPWR VGND sg13g2_a22oi_1
X_4934__154 VPWR VGND net154 sg13g2_tiehi
X_4557_ net559 _2173_ _0513_ VPWR VGND sg13g2_nor2_1
X_4488_ _2105_ VPWR _2112_ VGND _2106_ _2108_ sg13g2_o21ai_1
X_3508_ VPWR VGND _1151_ _1143_ _1149_ _1040_ _1161_ _1135_ sg13g2_a221oi_1
X_3439_ _1072_ _1070_ _1088_ _1092_ VPWR VGND sg13g2_a21o_2
X_5109_ net288 VGND VPWR _0437_ videogen.test_lut_thingy.pixel_feeder_inst.row\[34\]\[1\]
+ _0074_ sg13g2_dfrbpq_1
XFILLER_46_918 VPWR VGND sg13g2_decap_8
XFILLER_45_439 VPWR VGND sg13g2_decap_8
XFILLER_14_804 VPWR VGND sg13g2_fill_1
XFILLER_25_185 VPWR VGND sg13g2_decap_8
XFILLER_40_122 VPWR VGND sg13g2_decap_8
XFILLER_25_196 VPWR VGND sg13g2_fill_1
XFILLER_22_870 VPWR VGND sg13g2_decap_8
XFILLER_31_30 VPWR VGND sg13g2_decap_8
Xoutput6 net6 tmds_r VPWR VGND sg13g2_buf_1
X_5087__323 VPWR VGND net323 sg13g2_tiehi
XFILLER_49_745 VPWR VGND sg13g2_decap_8
XFILLER_45_962 VPWR VGND sg13g2_decap_8
XFILLER_16_152 VPWR VGND sg13g2_fill_1
XFILLER_17_675 VPWR VGND sg13g2_fill_2
XFILLER_32_623 VPWR VGND sg13g2_decap_4
X_5094__316 VPWR VGND net316 sg13g2_tiehi
XFILLER_32_634 VPWR VGND sg13g2_decap_8
X_2810_ videogen.test_lut_thingy.pixel_feeder_inst.row\[40\]\[2\] net781 _0771_ _0586_
+ VPWR VGND sg13g2_mux2_1
X_3790_ _1439_ _1440_ _1441_ _1442_ _1443_ VPWR VGND sg13g2_nor4_1
XFILLER_31_177 VPWR VGND sg13g2_fill_1
X_2741_ net794 videogen.test_lut_thingy.pixel_feeder_inst.row\[23\]\[1\] _0737_ _0631_
+ VPWR VGND sg13g2_mux2_1
X_2672_ VPWR _0680_ videogen.fancy_shader.n646\[6\] VGND sg13g2_inv_1
X_4411_ VGND VPWR _0697_ _1988_ _2049_ _2021_ sg13g2_a21oi_1
X_4342_ _1982_ VPWR _1983_ VGND _1978_ _1980_ sg13g2_o21ai_1
X_4273_ VGND VPWR _1896_ _1913_ _1919_ _1907_ sg13g2_a21oi_1
X_5168__166 VPWR VGND net166 sg13g2_tiehi
X_3224_ _0918_ VPWR _0919_ VGND videogen.test_lut_thingy.pixel_feeder_inst.v_pix\[3\]
+ _0916_ sg13g2_o21ai_1
.ends
